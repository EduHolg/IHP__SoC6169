// Design: CAMPROYECT/COMPLETE_PROYECT_TB
simulator lang=spectre
global 0
// lv MOS models (TT corner), shared by SG13G2 and SG13CMOS5L. ADJUST this path to the local PDK installation.
include "/PDK/SG13G2_618_rev1.3.2/tech/SG13_MOS/library/spectreG2/cornerMOSlv_psp.scs" section=tt
include "./inputs.scs"
include "./vec/ctrl_in6.spice"
include "./vec/ser_in6_ref19.spice"

// CAMPROYECT/INV/schematic
subckt INV GND IN VDD Y
    N0 (Y IN GND GND) sg13_lv_nmos w=200.00n l=130.00n ng=1 m=1
    P0 (Y IN VDD VDD) sg13_lv_pmos w=400n l=130.00n ng=1 m=1
ends INV

// CAMPROYECT/Xnor/schematic
subckt Xnor A B OUT VDD VSS
    I3 (VSS net3 VDD OUT) INV
    I2 (VSS net2 VDD net3) INV
    I0 (VSS B VDD net1) INV
    N0 (net2 A B VSS) sg13_lv_nmos w=200.00n l=130.00n ng=1 m=1
    P0 (net2 A net1 VDD) sg13_lv_pmos w=400n l=130.00n ng=1 m=1
ends Xnor

// CAMPROYECT/BUFFER/schematic
subckt BUFFER OUTP OUTPRE VDD VSS
    N0 (OUTP medio VSS VSS) sg13_lv_nmos w=3u l=130.00n ng=1 m=1
    P0 (OUTP medio VDD VDD) sg13_lv_pmos w=6u l=130.00n ng=1 m=1
    I306 (VSS OUTPRE VDD medio) INV
ends BUFFER

// CAMPROYECT/CELL/schematic
subckt CELL ML SL SL_N VDD VEVAL VSS WL
    I7 (VSS net1 VDD net2) INV
    I4 (VSS net2 VDD net1) INV
    N5 (net11 VEVAL VSS VSS) sg13_lv_nmos w=350n l=130n ng=1 m=1
    N4 (net11 net3 ML VSS) sg13_lv_nmos w=740.00n l=130.00n ng=1 m=1
    N3 (net3 net2 SL VSS) sg13_lv_nmos w=740.00n l=130.00n ng=1 m=1
    N2 (net3 net1 SL_N VSS) sg13_lv_nmos w=740.00n l=130.00n ng=1 m=1
    N1 (SL_N WL net1 VSS) sg13_lv_nmos w=740.00n l=130.00n ng=1 m=1
    N0 (SL WL net2 VSS) sg13_lv_nmos w=740.00n l=130.00n ng=1 m=1
ends CELL

// CAMPROYECT/WORD_32bits/schematic
subckt WORD_32bits ML SL_0 SL_0N SL_1 SL_10 SL_10N SL_11 SL_11N SL_12 SL_12N SL_13 SL_13N SL_14 SL_14N SL_15 SL_15N SL_16 SL_16N SL_17 SL_17N SL_18 SL_18N SL_19 SL_19N SL_1N SL_2 SL_20 SL_20N SL_21 SL_21N SL_22 SL_22N SL_23 SL_23N SL_24 SL_24N SL_25 SL_25N SL_26 SL_26N SL_27 SL_27N SL_28 SL_28N SL_29 SL_29N SL_2N SL_3 SL_30 SL_30N SL_31 SL_31N SL_3N SL_4 SL_4N SL_5 SL_5N SL_6 SL_6N SL_7 SL_7N SL_8 SL_8N SL_9 SL_9N VDD VEVAL VSS WL pc
    I31 (ML SL_27 SL_27N VDD VEVAL VSS WL) CELL
    I30 (ML SL_24 SL_24N VDD VEVAL VSS WL) CELL
    I29 (ML SL_25 SL_25N VDD VEVAL VSS WL) CELL
    I28 (ML SL_26 SL_26N VDD VEVAL VSS WL) CELL
    I27 (ML SL_28 SL_28N VDD VEVAL VSS WL) CELL
    I26 (ML SL_29 SL_29N VDD VEVAL VSS WL) CELL
    I25 (ML SL_30 SL_30N VDD VEVAL VSS WL) CELL
    I24 (ML SL_31 SL_31N VDD VEVAL VSS WL) CELL
    I23 (ML SL_19 SL_19N VDD VEVAL VSS WL) CELL
    I22 (ML SL_16 SL_16N VDD VEVAL VSS WL) CELL
    I21 (ML SL_17 SL_17N VDD VEVAL VSS WL) CELL
    I20 (ML SL_18 SL_18N VDD VEVAL VSS WL) CELL
    I19 (ML SL_20 SL_20N VDD VEVAL VSS WL) CELL
    I18 (ML SL_21 SL_21N VDD VEVAL VSS WL) CELL
    I17 (ML SL_22 SL_22N VDD VEVAL VSS WL) CELL
    I15 (ML SL_11 SL_11N VDD VEVAL VSS WL) CELL
    I14 (ML SL_8 SL_8N VDD VEVAL VSS WL) CELL
    I13 (ML SL_9 SL_9N VDD VEVAL VSS WL) CELL
    I12 (ML SL_10 SL_10N VDD VEVAL VSS WL) CELL
    I10 (ML SL_12 SL_12N VDD VEVAL VSS WL) CELL
    I6 (ML SL_13 SL_13N VDD VEVAL VSS WL) CELL
    I2 (ML SL_14 SL_14N VDD VEVAL VSS WL) CELL
    I1 (ML SL_15 SL_15N VDD VEVAL VSS WL) CELL
    I11 (ML SL_3 SL_3N VDD VEVAL VSS WL) CELL
    I9 (ML SL_0 SL_0N VDD VEVAL VSS WL) CELL
    I8 (ML SL_1 SL_1N VDD VEVAL VSS WL) CELL
    I7 (ML SL_2 SL_2N VDD VEVAL VSS WL) CELL
    I5 (ML SL_4 SL_4N VDD VEVAL VSS WL) CELL
    I4 (ML SL_5 SL_5N VDD VEVAL VSS WL) CELL
    I3 (ML SL_6 SL_6N VDD VEVAL VSS WL) CELL
    I0 (ML SL_7 SL_7N VDD VEVAL VSS WL) CELL
    I16 (ML SL_23 SL_23N VDD VEVAL VSS WL) CELL
    P0 (ML pc VDD VDD) sg13_lv_pmos w=2u l=130.00n ng=1 m=1
ends WORD_32bits

// CAMPROYECT/reference_complete/schematic
subckt reference_complete REFSENS SL_0 SL_0N SL_1 SL_10 SL_10N SL_11 SL_11N SL_12 SL_12N SL_13 SL_13N SL_14 SL_14N SL_15 SL_15N SL_16 SL_16N SL_17 SL_17N SL_18 SL_18N SL_19 SL_19N SL_1N SL_2 SL_20 SL_20N SL_21 SL_21N SL_22 SL_22N SL_23 SL_23N SL_24 SL_24N SL_25 SL_25N SL_26 SL_26N SL_27 SL_27N SL_28 SL_28N SL_29 SL_29N SL_2N SL_3 SL_30 SL_30N SL_31 SL_31N SL_3N SL_4 SL_4N SL_5 SL_5N SL_6 SL_6N SL_7 SL_7N SL_8 SL_8N SL_9 SL_9N VDD VEVAL VSS WL pc
    I311 (REFSENS net1 VDD VSS) BUFFER
    I323 (VSS ML_ref VDD net1) INV
    I0 (ML_ref SL_0 SL_0N SL_1 SL_10 SL_10N SL_11 SL_11N SL_12 SL_12N SL_13 SL_13N SL_14 SL_14N SL_15 SL_15N SL_16 SL_16N SL_17 SL_17N SL_18 SL_18N SL_19 SL_19N SL_1N SL_2 SL_20 SL_20N SL_21 SL_21N SL_22 SL_22N SL_23 SL_23N SL_24 SL_24N SL_25 SL_25N SL_26 SL_26N SL_27 SL_27N SL_28 SL_28N SL_29 SL_29N SL_2N SL_3 SL_30 SL_30N SL_31 SL_31N SL_3N SL_4 SL_4N SL_5 SL_5N SL_6 SL_6N SL_7 SL_7N SL_8 SL_8N SL_9 SL_9N VDD VEVAL VSS WL pc) WORD_32bits
ends reference_complete

// CAMPROYECT/ARRAY_32x32/schematic
subckt ARRAY_32x32 ML_0 ML_1 ML_10 ML_11 ML_12 ML_13 ML_14 ML_15 ML_16 ML_17 ML_18 ML_19 ML_2 ML_20 ML_21 ML_22 ML_23 ML_24 ML_25 ML_26 ML_27 ML_28 ML_29 ML_3 ML_30 ML_31 ML_4 ML_5 ML_6 ML_7 ML_8 ML_9 SL_0 SL_0N SL_1 SL_10 SL_10N SL_11 SL_11N SL_12 SL_12N SL_13 SL_13N SL_14 SL_14N SL_15 SL_15N SL_16 SL_16N SL_17 SL_17N SL_18 SL_18N SL_19 SL_19N SL_1N SL_2 SL_20 SL_20N SL_21 SL_21N SL_22 SL_22N SL_23 SL_23N SL_24 SL_24N SL_25 SL_25N SL_26 SL_26N SL_27 SL_27N SL_28 SL_28N SL_29 SL_29N SL_2N SL_3 SL_30 SL_30N SL_31 SL_31N SL_3N SL_4 SL_4N SL_5 SL_5N SL_6 SL_6N SL_7 SL_7N SL_8 SL_8N SL_9 SL_9N VDD VEVAL VSS WL_0 WL_1 WL_10 WL_11 WL_12 WL_13 WL_14 WL_15 WL_16 WL_17 WL_18 WL_19 WL_2 WL_20 WL_21 WL_22 WL_23 WL_24 WL_25 WL_26 WL_27 WL_28 WL_29 WL_3 WL_30 WL_31 WL_4 WL_5 WL_6 WL_7 WL_8 WL_9 pc
    I25 (ML_14 SL_0 SL_0N SL_1 SL_10 SL_10N SL_11 SL_11N SL_12 SL_12N SL_13 SL_13N SL_14 SL_14N SL_15 SL_15N SL_16 SL_16N SL_17 SL_17N SL_18 SL_18N SL_19 SL_19N SL_1N SL_2 SL_20 SL_20N SL_21 SL_21N SL_22 SL_22N SL_23 SL_23N SL_24 SL_24N SL_25 SL_25N SL_26 SL_26N SL_27 SL_27N SL_28 SL_28N SL_29 SL_29N SL_2N SL_3 SL_30 SL_30N SL_31 SL_31N SL_3N SL_4 SL_4N SL_5 SL_5N SL_6 SL_6N SL_7 SL_7N SL_8 SL_8N SL_9 SL_9N VDD VEVAL VSS WL_14 pc) WORD_32bits
    I24 (ML_13 SL_0 SL_0N SL_1 SL_10 SL_10N SL_11 SL_11N SL_12 SL_12N SL_13 SL_13N SL_14 SL_14N SL_15 SL_15N SL_16 SL_16N SL_17 SL_17N SL_18 SL_18N SL_19 SL_19N SL_1N SL_2 SL_20 SL_20N SL_21 SL_21N SL_22 SL_22N SL_23 SL_23N SL_24 SL_24N SL_25 SL_25N SL_26 SL_26N SL_27 SL_27N SL_28 SL_28N SL_29 SL_29N SL_2N SL_3 SL_30 SL_30N SL_31 SL_31N SL_3N SL_4 SL_4N SL_5 SL_5N SL_6 SL_6N SL_7 SL_7N SL_8 SL_8N SL_9 SL_9N VDD VEVAL VSS WL_13 pc) WORD_32bits
    I23 (ML_12 SL_0 SL_0N SL_1 SL_10 SL_10N SL_11 SL_11N SL_12 SL_12N SL_13 SL_13N SL_14 SL_14N SL_15 SL_15N SL_16 SL_16N SL_17 SL_17N SL_18 SL_18N SL_19 SL_19N SL_1N SL_2 SL_20 SL_20N SL_21 SL_21N SL_22 SL_22N SL_23 SL_23N SL_24 SL_24N SL_25 SL_25N SL_26 SL_26N SL_27 SL_27N SL_28 SL_28N SL_29 SL_29N SL_2N SL_3 SL_30 SL_30N SL_31 SL_31N SL_3N SL_4 SL_4N SL_5 SL_5N SL_6 SL_6N SL_7 SL_7N SL_8 SL_8N SL_9 SL_9N VDD VEVAL VSS WL_12 pc) WORD_32bits
    I47 (ML_17 SL_0 SL_0N SL_1 SL_10 SL_10N SL_11 SL_11N SL_12 SL_12N SL_13 SL_13N SL_14 SL_14N SL_15 SL_15N SL_16 SL_16N SL_17 SL_17N SL_18 SL_18N SL_19 SL_19N SL_1N SL_2 SL_20 SL_20N SL_21 SL_21N SL_22 SL_22N SL_23 SL_23N SL_24 SL_24N SL_25 SL_25N SL_26 SL_26N SL_27 SL_27N SL_28 SL_28N SL_29 SL_29N SL_2N SL_3 SL_30 SL_30N SL_31 SL_31N SL_3N SL_4 SL_4N SL_5 SL_5N SL_6 SL_6N SL_7 SL_7N SL_8 SL_8N SL_9 SL_9N VDD VEVAL VSS WL_17 pc) WORD_32bits
    I43 (ML_18 SL_0 SL_0N SL_1 SL_10 SL_10N SL_11 SL_11N SL_12 SL_12N SL_13 SL_13N SL_14 SL_14N SL_15 SL_15N SL_16 SL_16N SL_17 SL_17N SL_18 SL_18N SL_19 SL_19N SL_1N SL_2 SL_20 SL_20N SL_21 SL_21N SL_22 SL_22N SL_23 SL_23N SL_24 SL_24N SL_25 SL_25N SL_26 SL_26N SL_27 SL_27N SL_28 SL_28N SL_29 SL_29N SL_2N SL_3 SL_30 SL_30N SL_31 SL_31N SL_3N SL_4 SL_4N SL_5 SL_5N SL_6 SL_6N SL_7 SL_7N SL_8 SL_8N SL_9 SL_9N VDD VEVAL VSS WL_18 pc) WORD_32bits
    I49 (ML_16 SL_0 SL_0N SL_1 SL_10 SL_10N SL_11 SL_11N SL_12 SL_12N SL_13 SL_13N SL_14 SL_14N SL_15 SL_15N SL_16 SL_16N SL_17 SL_17N SL_18 SL_18N SL_19 SL_19N SL_1N SL_2 SL_20 SL_20N SL_21 SL_21N SL_22 SL_22N SL_23 SL_23N SL_24 SL_24N SL_25 SL_25N SL_26 SL_26N SL_27 SL_27N SL_28 SL_28N SL_29 SL_29N SL_2N SL_3 SL_30 SL_30N SL_31 SL_31N SL_3N SL_4 SL_4N SL_5 SL_5N SL_6 SL_6N SL_7 SL_7N SL_8 SL_8N SL_9 SL_9N VDD VEVAL VSS WL_16 pc) WORD_32bits
    I46 (ML_22 SL_0 SL_0N SL_1 SL_10 SL_10N SL_11 SL_11N SL_12 SL_12N SL_13 SL_13N SL_14 SL_14N SL_15 SL_15N SL_16 SL_16N SL_17 SL_17N SL_18 SL_18N SL_19 SL_19N SL_1N SL_2 SL_20 SL_20N SL_21 SL_21N SL_22 SL_22N SL_23 SL_23N SL_24 SL_24N SL_25 SL_25N SL_26 SL_26N SL_27 SL_27N SL_28 SL_28N SL_29 SL_29N SL_2N SL_3 SL_30 SL_30N SL_31 SL_31N SL_3N SL_4 SL_4N SL_5 SL_5N SL_6 SL_6N SL_7 SL_7N SL_8 SL_8N SL_9 SL_9N VDD VEVAL VSS WL_22 pc) WORD_32bits
    I48 (ML_21 SL_0 SL_0N SL_1 SL_10 SL_10N SL_11 SL_11N SL_12 SL_12N SL_13 SL_13N SL_14 SL_14N SL_15 SL_15N SL_16 SL_16N SL_17 SL_17N SL_18 SL_18N SL_19 SL_19N SL_1N SL_2 SL_20 SL_20N SL_21 SL_21N SL_22 SL_22N SL_23 SL_23N SL_24 SL_24N SL_25 SL_25N SL_26 SL_26N SL_27 SL_27N SL_28 SL_28N SL_29 SL_29N SL_2N SL_3 SL_30 SL_30N SL_31 SL_31N SL_3N SL_4 SL_4N SL_5 SL_5N SL_6 SL_6N SL_7 SL_7N SL_8 SL_8N SL_9 SL_9N VDD VEVAL VSS WL_21 pc) WORD_32bits
    I44 (ML_19 SL_0 SL_0N SL_1 SL_10 SL_10N SL_11 SL_11N SL_12 SL_12N SL_13 SL_13N SL_14 SL_14N SL_15 SL_15N SL_16 SL_16N SL_17 SL_17N SL_18 SL_18N SL_19 SL_19N SL_1N SL_2 SL_20 SL_20N SL_21 SL_21N SL_22 SL_22N SL_23 SL_23N SL_24 SL_24N SL_25 SL_25N SL_26 SL_26N SL_27 SL_27N SL_28 SL_28N SL_29 SL_29N SL_2N SL_3 SL_30 SL_30N SL_31 SL_31N SL_3N SL_4 SL_4N SL_5 SL_5N SL_6 SL_6N SL_7 SL_7N SL_8 SL_8N SL_9 SL_9N VDD VEVAL VSS WL_19 pc) WORD_32bits
    I45 (ML_23 SL_0 SL_0N SL_1 SL_10 SL_10N SL_11 SL_11N SL_12 SL_12N SL_13 SL_13N SL_14 SL_14N SL_15 SL_15N SL_16 SL_16N SL_17 SL_17N SL_18 SL_18N SL_19 SL_19N SL_1N SL_2 SL_20 SL_20N SL_21 SL_21N SL_22 SL_22N SL_23 SL_23N SL_24 SL_24N SL_25 SL_25N SL_26 SL_26N SL_27 SL_27N SL_28 SL_28N SL_29 SL_29N SL_2N SL_3 SL_30 SL_30N SL_31 SL_31N SL_3N SL_4 SL_4N SL_5 SL_5N SL_6 SL_6N SL_7 SL_7N SL_8 SL_8N SL_9 SL_9N VDD VEVAL VSS WL_23 pc) WORD_32bits
    I50 (ML_20 SL_0 SL_0N SL_1 SL_10 SL_10N SL_11 SL_11N SL_12 SL_12N SL_13 SL_13N SL_14 SL_14N SL_15 SL_15N SL_16 SL_16N SL_17 SL_17N SL_18 SL_18N SL_19 SL_19N SL_1N SL_2 SL_20 SL_20N SL_21 SL_21N SL_22 SL_22N SL_23 SL_23N SL_24 SL_24N SL_25 SL_25N SL_26 SL_26N SL_27 SL_27N SL_28 SL_28N SL_29 SL_29N SL_2N SL_3 SL_30 SL_30N SL_31 SL_31N SL_3N SL_4 SL_4N SL_5 SL_5N SL_6 SL_6N SL_7 SL_7N SL_8 SL_8N SL_9 SL_9N VDD VEVAL VSS WL_20 pc) WORD_32bits
    I22 (ML_9 SL_0 SL_0N SL_1 SL_10 SL_10N SL_11 SL_11N SL_12 SL_12N SL_13 SL_13N SL_14 SL_14N SL_15 SL_15N SL_16 SL_16N SL_17 SL_17N SL_18 SL_18N SL_19 SL_19N SL_1N SL_2 SL_20 SL_20N SL_21 SL_21N SL_22 SL_22N SL_23 SL_23N SL_24 SL_24N SL_25 SL_25N SL_26 SL_26N SL_27 SL_27N SL_28 SL_28N SL_29 SL_29N SL_2N SL_3 SL_30 SL_30N SL_31 SL_31N SL_3N SL_4 SL_4N SL_5 SL_5N SL_6 SL_6N SL_7 SL_7N SL_8 SL_8N SL_9 SL_9N VDD VEVAL VSS WL_9 pc) WORD_32bits
    I20 (ML_10 SL_0 SL_0N SL_1 SL_10 SL_10N SL_11 SL_11N SL_12 SL_12N SL_13 SL_13N SL_14 SL_14N SL_15 SL_15N SL_16 SL_16N SL_17 SL_17N SL_18 SL_18N SL_19 SL_19N SL_1N SL_2 SL_20 SL_20N SL_21 SL_21N SL_22 SL_22N SL_23 SL_23N SL_24 SL_24N SL_25 SL_25N SL_26 SL_26N SL_27 SL_27N SL_28 SL_28N SL_29 SL_29N SL_2N SL_3 SL_30 SL_30N SL_31 SL_31N SL_3N SL_4 SL_4N SL_5 SL_5N SL_6 SL_6N SL_7 SL_7N SL_8 SL_8N SL_9 SL_9N VDD VEVAL VSS WL_10 pc) WORD_32bits
    I10 (ML_0 SL_0 SL_0N SL_1 SL_10 SL_10N SL_11 SL_11N SL_12 SL_12N SL_13 SL_13N SL_14 SL_14N SL_15 SL_15N SL_16 SL_16N SL_17 SL_17N SL_18 SL_18N SL_19 SL_19N SL_1N SL_2 SL_20 SL_20N SL_21 SL_21N SL_22 SL_22N SL_23 SL_23N SL_24 SL_24N SL_25 SL_25N SL_26 SL_26N SL_27 SL_27N SL_28 SL_28N SL_29 SL_29N SL_2N SL_3 SL_30 SL_30N SL_31 SL_31N SL_3N SL_4 SL_4N SL_5 SL_5N SL_6 SL_6N SL_7 SL_7N SL_8 SL_8N SL_9 SL_9N VDD VEVAL VSS WL_0 pc) WORD_32bits
    I14 (ML_4 SL_0 SL_0N SL_1 SL_10 SL_10N SL_11 SL_11N SL_12 SL_12N SL_13 SL_13N SL_14 SL_14N SL_15 SL_15N SL_16 SL_16N SL_17 SL_17N SL_18 SL_18N SL_19 SL_19N SL_1N SL_2 SL_20 SL_20N SL_21 SL_21N SL_22 SL_22N SL_23 SL_23N SL_24 SL_24N SL_25 SL_25N SL_26 SL_26N SL_27 SL_27N SL_28 SL_28N SL_29 SL_29N SL_2N SL_3 SL_30 SL_30N SL_31 SL_31N SL_3N SL_4 SL_4N SL_5 SL_5N SL_6 SL_6N SL_7 SL_7N SL_8 SL_8N SL_9 SL_9N VDD VEVAL VSS WL_4 pc) WORD_32bits
    I15 (ML_5 SL_0 SL_0N SL_1 SL_10 SL_10N SL_11 SL_11N SL_12 SL_12N SL_13 SL_13N SL_14 SL_14N SL_15 SL_15N SL_16 SL_16N SL_17 SL_17N SL_18 SL_18N SL_19 SL_19N SL_1N SL_2 SL_20 SL_20N SL_21 SL_21N SL_22 SL_22N SL_23 SL_23N SL_24 SL_24N SL_25 SL_25N SL_26 SL_26N SL_27 SL_27N SL_28 SL_28N SL_29 SL_29N SL_2N SL_3 SL_30 SL_30N SL_31 SL_31N SL_3N SL_4 SL_4N SL_5 SL_5N SL_6 SL_6N SL_7 SL_7N SL_8 SL_8N SL_9 SL_9N VDD VEVAL VSS WL_5 pc) WORD_32bits
    I17 (ML_7 SL_0 SL_0N SL_1 SL_10 SL_10N SL_11 SL_11N SL_12 SL_12N SL_13 SL_13N SL_14 SL_14N SL_15 SL_15N SL_16 SL_16N SL_17 SL_17N SL_18 SL_18N SL_19 SL_19N SL_1N SL_2 SL_20 SL_20N SL_21 SL_21N SL_22 SL_22N SL_23 SL_23N SL_24 SL_24N SL_25 SL_25N SL_26 SL_26N SL_27 SL_27N SL_28 SL_28N SL_29 SL_29N SL_2N SL_3 SL_30 SL_30N SL_31 SL_31N SL_3N SL_4 SL_4N SL_5 SL_5N SL_6 SL_6N SL_7 SL_7N SL_8 SL_8N SL_9 SL_9N VDD VEVAL VSS WL_7 pc) WORD_32bits
    I16 (ML_6 SL_0 SL_0N SL_1 SL_10 SL_10N SL_11 SL_11N SL_12 SL_12N SL_13 SL_13N SL_14 SL_14N SL_15 SL_15N SL_16 SL_16N SL_17 SL_17N SL_18 SL_18N SL_19 SL_19N SL_1N SL_2 SL_20 SL_20N SL_21 SL_21N SL_22 SL_22N SL_23 SL_23N SL_24 SL_24N SL_25 SL_25N SL_26 SL_26N SL_27 SL_27N SL_28 SL_28N SL_29 SL_29N SL_2N SL_3 SL_30 SL_30N SL_31 SL_31N SL_3N SL_4 SL_4N SL_5 SL_5N SL_6 SL_6N SL_7 SL_7N SL_8 SL_8N SL_9 SL_9N VDD VEVAL VSS WL_6 pc) WORD_32bits
    I13 (ML_3 SL_0 SL_0N SL_1 SL_10 SL_10N SL_11 SL_11N SL_12 SL_12N SL_13 SL_13N SL_14 SL_14N SL_15 SL_15N SL_16 SL_16N SL_17 SL_17N SL_18 SL_18N SL_19 SL_19N SL_1N SL_2 SL_20 SL_20N SL_21 SL_21N SL_22 SL_22N SL_23 SL_23N SL_24 SL_24N SL_25 SL_25N SL_26 SL_26N SL_27 SL_27N SL_28 SL_28N SL_29 SL_29N SL_2N SL_3 SL_30 SL_30N SL_31 SL_31N SL_3N SL_4 SL_4N SL_5 SL_5N SL_6 SL_6N SL_7 SL_7N SL_8 SL_8N SL_9 SL_9N VDD VEVAL VSS WL_3 pc) WORD_32bits
    I18 (ML_15 SL_0 SL_0N SL_1 SL_10 SL_10N SL_11 SL_11N SL_12 SL_12N SL_13 SL_13N SL_14 SL_14N SL_15 SL_15N SL_16 SL_16N SL_17 SL_17N SL_18 SL_18N SL_19 SL_19N SL_1N SL_2 SL_20 SL_20N SL_21 SL_21N SL_22 SL_22N SL_23 SL_23N SL_24 SL_24N SL_25 SL_25N SL_26 SL_26N SL_27 SL_27N SL_28 SL_28N SL_29 SL_29N SL_2N SL_3 SL_30 SL_30N SL_31 SL_31N SL_3N SL_4 SL_4N SL_5 SL_5N SL_6 SL_6N SL_7 SL_7N SL_8 SL_8N SL_9 SL_9N VDD VEVAL VSS WL_15 pc) WORD_32bits
    I51 (ML_28 SL_0 SL_0N SL_1 SL_10 SL_10N SL_11 SL_11N SL_12 SL_12N SL_13 SL_13N SL_14 SL_14N SL_15 SL_15N SL_16 SL_16N SL_17 SL_17N SL_18 SL_18N SL_19 SL_19N SL_1N SL_2 SL_20 SL_20N SL_21 SL_21N SL_22 SL_22N SL_23 SL_23N SL_24 SL_24N SL_25 SL_25N SL_26 SL_26N SL_27 SL_27N SL_28 SL_28N SL_29 SL_29N SL_2N SL_3 SL_30 SL_30N SL_31 SL_31N SL_3N SL_4 SL_4N SL_5 SL_5N SL_6 SL_6N SL_7 SL_7N SL_8 SL_8N SL_9 SL_9N VDD VEVAL VSS WL_28 pc) WORD_32bits
    I57 (ML_27 SL_0 SL_0N SL_1 SL_10 SL_10N SL_11 SL_11N SL_12 SL_12N SL_13 SL_13N SL_14 SL_14N SL_15 SL_15N SL_16 SL_16N SL_17 SL_17N SL_18 SL_18N SL_19 SL_19N SL_1N SL_2 SL_20 SL_20N SL_21 SL_21N SL_22 SL_22N SL_23 SL_23N SL_24 SL_24N SL_25 SL_25N SL_26 SL_26N SL_27 SL_27N SL_28 SL_28N SL_29 SL_29N SL_2N SL_3 SL_30 SL_30N SL_31 SL_31N SL_3N SL_4 SL_4N SL_5 SL_5N SL_6 SL_6N SL_7 SL_7N SL_8 SL_8N SL_9 SL_9N VDD VEVAL VSS WL_27 pc) WORD_32bits
    I53 (ML_29 SL_0 SL_0N SL_1 SL_10 SL_10N SL_11 SL_11N SL_12 SL_12N SL_13 SL_13N SL_14 SL_14N SL_15 SL_15N SL_16 SL_16N SL_17 SL_17N SL_18 SL_18N SL_19 SL_19N SL_1N SL_2 SL_20 SL_20N SL_21 SL_21N SL_22 SL_22N SL_23 SL_23N SL_24 SL_24N SL_25 SL_25N SL_26 SL_26N SL_27 SL_27N SL_28 SL_28N SL_29 SL_29N SL_2N SL_3 SL_30 SL_30N SL_31 SL_31N SL_3N SL_4 SL_4N SL_5 SL_5N SL_6 SL_6N SL_7 SL_7N SL_8 SL_8N SL_9 SL_9N VDD VEVAL VSS WL_29 pc) WORD_32bits
    I54 (ML_25 SL_0 SL_0N SL_1 SL_10 SL_10N SL_11 SL_11N SL_12 SL_12N SL_13 SL_13N SL_14 SL_14N SL_15 SL_15N SL_16 SL_16N SL_17 SL_17N SL_18 SL_18N SL_19 SL_19N SL_1N SL_2 SL_20 SL_20N SL_21 SL_21N SL_22 SL_22N SL_23 SL_23N SL_24 SL_24N SL_25 SL_25N SL_26 SL_26N SL_27 SL_27N SL_28 SL_28N SL_29 SL_29N SL_2N SL_3 SL_30 SL_30N SL_31 SL_31N SL_3N SL_4 SL_4N SL_5 SL_5N SL_6 SL_6N SL_7 SL_7N SL_8 SL_8N SL_9 SL_9N VDD VEVAL VSS WL_25 pc) WORD_32bits
    I19 (ML_11 SL_0 SL_0N SL_1 SL_10 SL_10N SL_11 SL_11N SL_12 SL_12N SL_13 SL_13N SL_14 SL_14N SL_15 SL_15N SL_16 SL_16N SL_17 SL_17N SL_18 SL_18N SL_19 SL_19N SL_1N SL_2 SL_20 SL_20N SL_21 SL_21N SL_22 SL_22N SL_23 SL_23N SL_24 SL_24N SL_25 SL_25N SL_26 SL_26N SL_27 SL_27N SL_28 SL_28N SL_29 SL_29N SL_2N SL_3 SL_30 SL_30N SL_31 SL_31N SL_3N SL_4 SL_4N SL_5 SL_5N SL_6 SL_6N SL_7 SL_7N SL_8 SL_8N SL_9 SL_9N VDD VEVAL VSS WL_11 pc) WORD_32bits
    I52 (ML_24 SL_0 SL_0N SL_1 SL_10 SL_10N SL_11 SL_11N SL_12 SL_12N SL_13 SL_13N SL_14 SL_14N SL_15 SL_15N SL_16 SL_16N SL_17 SL_17N SL_18 SL_18N SL_19 SL_19N SL_1N SL_2 SL_20 SL_20N SL_21 SL_21N SL_22 SL_22N SL_23 SL_23N SL_24 SL_24N SL_25 SL_25N SL_26 SL_26N SL_27 SL_27N SL_28 SL_28N SL_29 SL_29N SL_2N SL_3 SL_30 SL_30N SL_31 SL_31N SL_3N SL_4 SL_4N SL_5 SL_5N SL_6 SL_6N SL_7 SL_7N SL_8 SL_8N SL_9 SL_9N VDD VEVAL VSS WL_24 pc) WORD_32bits
    I26 (ML_8 SL_0 SL_0N SL_1 SL_10 SL_10N SL_11 SL_11N SL_12 SL_12N SL_13 SL_13N SL_14 SL_14N SL_15 SL_15N SL_16 SL_16N SL_17 SL_17N SL_18 SL_18N SL_19 SL_19N SL_1N SL_2 SL_20 SL_20N SL_21 SL_21N SL_22 SL_22N SL_23 SL_23N SL_24 SL_24N SL_25 SL_25N SL_26 SL_26N SL_27 SL_27N SL_28 SL_28N SL_29 SL_29N SL_2N SL_3 SL_30 SL_30N SL_31 SL_31N SL_3N SL_4 SL_4N SL_5 SL_5N SL_6 SL_6N SL_7 SL_7N SL_8 SL_8N SL_9 SL_9N VDD VEVAL VSS WL_8 pc) WORD_32bits
    I58 (ML_26 SL_0 SL_0N SL_1 SL_10 SL_10N SL_11 SL_11N SL_12 SL_12N SL_13 SL_13N SL_14 SL_14N SL_15 SL_15N SL_16 SL_16N SL_17 SL_17N SL_18 SL_18N SL_19 SL_19N SL_1N SL_2 SL_20 SL_20N SL_21 SL_21N SL_22 SL_22N SL_23 SL_23N SL_24 SL_24N SL_25 SL_25N SL_26 SL_26N SL_27 SL_27N SL_28 SL_28N SL_29 SL_29N SL_2N SL_3 SL_30 SL_30N SL_31 SL_31N SL_3N SL_4 SL_4N SL_5 SL_5N SL_6 SL_6N SL_7 SL_7N SL_8 SL_8N SL_9 SL_9N VDD VEVAL VSS WL_26 pc) WORD_32bits
    I56 (ML_31 SL_0 SL_0N SL_1 SL_10 SL_10N SL_11 SL_11N SL_12 SL_12N SL_13 SL_13N SL_14 SL_14N SL_15 SL_15N SL_16 SL_16N SL_17 SL_17N SL_18 SL_18N SL_19 SL_19N SL_1N SL_2 SL_20 SL_20N SL_21 SL_21N SL_22 SL_22N SL_23 SL_23N SL_24 SL_24N SL_25 SL_25N SL_26 SL_26N SL_27 SL_27N SL_28 SL_28N SL_29 SL_29N SL_2N SL_3 SL_30 SL_30N SL_31 SL_31N SL_3N SL_4 SL_4N SL_5 SL_5N SL_6 SL_6N SL_7 SL_7N SL_8 SL_8N SL_9 SL_9N VDD VEVAL VSS WL_31 pc) WORD_32bits
    I55 (ML_30 SL_0 SL_0N SL_1 SL_10 SL_10N SL_11 SL_11N SL_12 SL_12N SL_13 SL_13N SL_14 SL_14N SL_15 SL_15N SL_16 SL_16N SL_17 SL_17N SL_18 SL_18N SL_19 SL_19N SL_1N SL_2 SL_20 SL_20N SL_21 SL_21N SL_22 SL_22N SL_23 SL_23N SL_24 SL_24N SL_25 SL_25N SL_26 SL_26N SL_27 SL_27N SL_28 SL_28N SL_29 SL_29N SL_2N SL_3 SL_30 SL_30N SL_31 SL_31N SL_3N SL_4 SL_4N SL_5 SL_5N SL_6 SL_6N SL_7 SL_7N SL_8 SL_8N SL_9 SL_9N VDD VEVAL VSS WL_30 pc) WORD_32bits
    I11 (ML_1 SL_0 SL_0N SL_1 SL_10 SL_10N SL_11 SL_11N SL_12 SL_12N SL_13 SL_13N SL_14 SL_14N SL_15 SL_15N SL_16 SL_16N SL_17 SL_17N SL_18 SL_18N SL_19 SL_19N SL_1N SL_2 SL_20 SL_20N SL_21 SL_21N SL_22 SL_22N SL_23 SL_23N SL_24 SL_24N SL_25 SL_25N SL_26 SL_26N SL_27 SL_27N SL_28 SL_28N SL_29 SL_29N SL_2N SL_3 SL_30 SL_30N SL_31 SL_31N SL_3N SL_4 SL_4N SL_5 SL_5N SL_6 SL_6N SL_7 SL_7N SL_8 SL_8N SL_9 SL_9N VDD VEVAL VSS WL_1 pc) WORD_32bits
    I12 (ML_2 SL_0 SL_0N SL_1 SL_10 SL_10N SL_11 SL_11N SL_12 SL_12N SL_13 SL_13N SL_14 SL_14N SL_15 SL_15N SL_16 SL_16N SL_17 SL_17N SL_18 SL_18N SL_19 SL_19N SL_1N SL_2 SL_20 SL_20N SL_21 SL_21N SL_22 SL_22N SL_23 SL_23N SL_24 SL_24N SL_25 SL_25N SL_26 SL_26N SL_27 SL_27N SL_28 SL_28N SL_29 SL_29N SL_2N SL_3 SL_30 SL_30N SL_31 SL_31N SL_3N SL_4 SL_4N SL_5 SL_5N SL_6 SL_6N SL_7 SL_7N SL_8 SL_8N SL_9 SL_9N VDD VEVAL VSS WL_2 pc) WORD_32bits
ends ARRAY_32x32

// CAMPROYECT/inverter_sens/schematic
subckt inverter_sens GND ML_0 ML_1 ML_2 ML_3 ML_4 ML_5 ML_6 ML_7 ML_8 ML_9 ML_10 ML_11 ML_12 ML_13 ML_14 ML_15 ML_16 ML_17 ML_18 ML_19 ML_20 ML_21 ML_22 ML_23 ML_24 ML_25 ML_26 ML_27 ML_28 ML_29 ML_30 ML_31 OUT0 OUT1 OUT2 OUT3 OUT4 OUT5 OUT6 OUT7 OUT8 OUT9 OUT10 OUT11 OUT12 OUT13 OUT14 OUT15 OUT16 OUT17 OUT18 OUT19 OUT20 OUT21 OUT22 OUT23 OUT24 OUT25 OUT26 OUT27 OUT28 OUT29 OUT30 OUT31 VDD
    I33 (GND ML_1 VDD OUT1) INV
    I32 (GND ML_0 VDD OUT0) INV
    I60 (GND ML_26 VDD OUT26) INV
    I58 (GND ML_25 VDD OUT25) INV
    I38 (GND ML_6 VDD OUT6) INV
    I59 (GND ML_27 VDD OUT27) INV
    I41 (GND ML_9 VDD OUT9) INV
    I35 (GND ML_3 VDD OUT3) INV
    I51 (GND ML_18 VDD OUT18) INV
    I50 (GND ML_19 VDD OUT19) INV
    I49 (GND ML_17 VDD OUT17) INV
    I44 (GND ML_14 VDD OUT14) INV
    I46 (GND ML_13 VDD OUT13) INV
    I48 (GND ML_16 VDD OUT16) INV
    I47 (GND ML_12 VDD OUT12) INV
    I34 (GND ML_2 VDD OUT2) INV
    I55 (GND ML_30 VDD OUT30) INV
    I57 (GND ML_29 VDD OUT29) INV
    I56 (GND ML_31 VDD OUT31) INV
    I37 (GND ML_5 VDD OUT5) INV
    I40 (GND ML_8 VDD OUT8) INV
    I43 (GND ML_10 VDD OUT10) INV
    I52 (GND ML_20 VDD OUT20) INV
    I54 (GND ML_28 VDD OUT28) INV
    I53 (GND ML_24 VDD OUT24) INV
    I61 (GND ML_22 VDD OUT22) INV
    I36 (GND ML_4 VDD OUT4) INV
    I63 (GND ML_21 VDD OUT21) INV
    I62 (GND ML_23 VDD OUT23) INV
    I39 (GND ML_7 VDD OUT7) INV
    I42 (GND ML_11 VDD OUT11) INV
    I45 (GND ML_15 VDD OUT15) INV
ends inverter_sens

// CAMPROYECT/flip_flop/schematic
subckt flip_flop CLK D Q Q_n VDD VSS
    I7 (VSS Q_n VDD Q) INV
    I5 (VSS Q_n VDD net14) INV
    I4 (VSS net17 VDD Q_n) INV
    I3 (VSS net9 VDD net15) INV
    I2 (VSS CLK VDD net12) INV
    I1 (VSS net8 VDD net9) INV
    I0 (VSS D VDD net5) INV
    N4 (net17 net12 net14 VSS) sg13_lv_nmos w=740.00n l=130.00n ng=1 m=1
    N3 (net9 CLK net17 VSS) sg13_lv_nmos w=740.00n l=130.00n ng=1 m=1
    N2 (net8 CLK net15 VSS) sg13_lv_nmos w=740.00n l=130.00n ng=1 m=1
    N0 (net5 net12 net8 VSS) sg13_lv_nmos w=740.00n l=130.00n ng=1 m=1
    P4 (net17 CLK net14 VDD) sg13_lv_pmos w=1.12u l=130.00n ng=1 m=1
    P3 (net9 net12 net17 VDD) sg13_lv_pmos w=1.12u l=130.00n ng=1 m=1
    P2 (net8 net12 net15 VDD) sg13_lv_pmos w=1.12u l=130.00n ng=1 m=1
    P0 (net5 CLK net8 VDD) sg13_lv_pmos w=1.12u l=130.00n ng=1 m=1
ends flip_flop

// CAMPROYECT/COMPARATOR_NEWBUFFER_64x32/schematic
subckt COMPARATOR_NEWBUFFER_64x32 COMP0 COMP1 COMP10 COMP11 COMP12 COMP13 COMP14 COMP15 COMP16 COMP17 COMP18 COMP19 COMP2 COMP20 COMP21 COMP22 COMP23 COMP24 COMP25 COMP26 COMP27 COMP28 COMP29 COMP3 COMP30 COMP31 COMP4 COMP5 COMP6 COMP7 COMP8 COMP9 REFSENS SENSML0 SENSML1 SENSML10 SENSML11 SENSML12 SENSML13 SENSML14 SENSML15 SENSML16 SENSML17 SENSML18 SENSML19 SENSML2 SENSML20 SENSML21 SENSML22 SENSML23 SENSML24 SENSML25 SENSML26 SENSML27 SENSML28 SENSML29 SENSML3 SENSML30 SENSML31 SENSML4 SENSML5 SENSML6 SENSML7 SENSML8 SENSML9 VDD VSS
    I36 (REFSENS SENSML0 COMP0 net12 VDD VSS) flip_flop
    I38 (REFSENS SENSML2 COMP2 net11 VDD VSS) flip_flop
    I37 (REFSENS SENSML1 COMP1 net10 VDD VSS) flip_flop
    I39 (REFSENS SENSML3 COMP3 net9 VDD VSS) flip_flop
    I40 (REFSENS SENSML4 COMP4 net8 VDD VSS) flip_flop
    I42 (REFSENS SENSML6 COMP6 net7 VDD VSS) flip_flop
    I41 (REFSENS SENSML5 COMP5 net6 VDD VSS) flip_flop
    I43 (REFSENS SENSML7 COMP7 net5 VDD VSS) flip_flop
    I44 (REFSENS SENSML8 COMP8 net4 VDD VSS) flip_flop
    I46 (REFSENS SENSML10 COMP10 net3 VDD VSS) flip_flop
    I45 (REFSENS SENSML9 COMP9 net2 VDD VSS) flip_flop
    I47 (REFSENS SENSML11 COMP11 net1 VDD VSS) flip_flop
    I48 (REFSENS SENSML12 COMP12 net32 VDD VSS) flip_flop
    I50 (REFSENS SENSML14 COMP14 net31 VDD VSS) flip_flop
    I49 (REFSENS SENSML13 COMP13 net30 VDD VSS) flip_flop
    I51 (REFSENS SENSML15 COMP15 net29 VDD VSS) flip_flop
    I52 (REFSENS SENSML16 COMP16 net28 VDD VSS) flip_flop
    I54 (REFSENS SENSML19 COMP19 net27 VDD VSS) flip_flop
    I53 (REFSENS SENSML17 COMP17 net26 VDD VSS) flip_flop
    I55 (REFSENS SENSML18 COMP18 net25 VDD VSS) flip_flop
    I56 (REFSENS SENSML20 COMP20 net24 VDD VSS) flip_flop
    I58 (REFSENS SENSML22 COMP22 net23 VDD VSS) flip_flop
    I57 (REFSENS SENSML21 COMP21 net22 VDD VSS) flip_flop
    I59 (REFSENS SENSML23 COMP23 net21 VDD VSS) flip_flop
    I60 (REFSENS SENSML24 COMP24 net20 VDD VSS) flip_flop
    I62 (REFSENS SENSML26 COMP26 net19 VDD VSS) flip_flop
    I61 (REFSENS SENSML25 COMP25 net18 VDD VSS) flip_flop
    I63 (REFSENS SENSML27 COMP27 net17 VDD VSS) flip_flop
    I64 (REFSENS SENSML28 COMP28 net16 VDD VSS) flip_flop
    I65 (REFSENS SENSML29 COMP29 net15 VDD VSS) flip_flop
    I66 (REFSENS SENSML30 COMP30 net14 VDD VSS) flip_flop
    I67 (REFSENS SENSML31 COMP31 net13 VDD VSS) flip_flop
ends COMPARATOR_NEWBUFFER_64x32

// CAMPROYECT/PART_SENS_COMPARATOR/schematic
subckt PART_SENS_COMPARATOR COMP0 COMP1 COMP10 COMP11 COMP12 COMP13 COMP14 COMP15 COMP16 COMP17 COMP18 COMP19 COMP2 COMP20 COMP21 COMP22 COMP23 COMP24 COMP25 COMP26 COMP27 COMP28 COMP29 COMP3 COMP30 COMP31 COMP4 COMP5 COMP6 COMP7 COMP8 COMP9 ML_0 ML_1 ML_10 ML_11 ML_12 ML_13 ML_14 ML_15 ML_16 ML_17 ML_18 ML_19 ML_2 ML_20 ML_21 ML_22 ML_23 ML_24 ML_25 ML_26 ML_27 ML_28 ML_29 ML_3 ML_30 ML_31 ML_4 ML_5 ML_6 ML_7 ML_8 ML_9 REFSENS VDD VSS
    I3 (VSS ML_0 ML_1 ML_2 ML_3 ML_4 ML_5 ML_6 ML_7 ML_8 ML_9 ML_10 ML_11 ML_12 ML_13 ML_14 ML_15 ML_16 ML_17 ML_18 ML_19 ML_20 ML_21 ML_22 ML_23 ML_24 ML_25 ML_26 ML_27 ML_28 ML_29 ML_30 ML_31 net32 net31 net30 net29 net28 net27 net26 net25 net24 net23 net22 net21 net20 net19 net18 net17 net16 net15 net14 net13 net12 net11 net10 net9 net8 net7 net6 net5 net4 net3 net2 net1 VDD) inverter_sens
    I4 (COMP0 COMP1 COMP10 COMP11 COMP12 COMP13 COMP14 COMP15 COMP16 COMP17 COMP18 COMP19 COMP2 COMP20 COMP21 COMP22 COMP23 COMP24 COMP25 COMP26 COMP27 COMP28 COMP29 COMP3 COMP30 COMP31 COMP4 COMP5 COMP6 COMP7 COMP8 COMP9 REFSENS net32 net31 net22 net21 net20 net19 net18 net17 net16 net15 net14 net13 net30 net12 net11 net10 net9 net8 net7 net6 net5 net4 net3 net29 net2 net1 net28 net27 net26 net25 net24 net23 VDD VSS) COMPARATOR_NEWBUFFER_64x32
ends PART_SENS_COMPARATOR

// CAMPROYECT/ANALOG_FIGURE/schematic
subckt ANALOG_FIGURE COMP0 COMP1 COMP10 COMP11 COMP12 COMP13 COMP14 COMP15 COMP16 COMP17 COMP18 COMP19 COMP2 COMP20 COMP21 COMP22 COMP23 COMP24 COMP25 COMP26 COMP27 COMP28 COMP29 COMP3 COMP30 COMP31 COMP4 COMP5 COMP6 COMP7 COMP8 COMP9 PC PSL_0 PSL_0N PSL_1 PSL_10 PSL_10N PSL_11 PSL_11N PSL_12 PSL_12N PSL_13 PSL_13N PSL_14 PSL_14N PSL_15 PSL_15N PSL_16 PSL_16N PSL_17 PSL_17N PSL_18 PSL_18N PSL_19 PSL_19N PSL_1N PSL_2 PSL_20 PSL_20N PSL_21 PSL_21N PSL_22 PSL_22N PSL_23 PSL_23N PSL_24 PSL_24N PSL_25 PSL_25N PSL_26 PSL_26N PSL_27 PSL_27N PSL_28 PSL_28N PSL_29 PSL_29N PSL_2N PSL_3 PSL_30 PSL_30N PSL_31 PSL_31N PSL_3N PSL_4 PSL_4N PSL_5 PSL_5N PSL_6 PSL_6N PSL_7 PSL_7N PSL_8 PSL_8N PSL_9 PSL_9N SL_0 SL_0N SL_1 SL_10 SL_10N SL_11 SL_11N SL_12 SL_12N SL_13 SL_13N SL_14 SL_14N SL_15 SL_15N SL_16 SL_16N SL_17 SL_17N SL_18 SL_18N SL_19 SL_19N SL_1N SL_2 SL_20 SL_20N SL_21 SL_21N SL_22 SL_22N SL_23 SL_23N SL_24 SL_24N SL_25 SL_25N SL_26 SL_26N SL_27 SL_27N SL_28 SL_28N SL_29 SL_29N SL_2N SL_3 SL_30 SL_30N SL_31 SL_31N SL_3N SL_4 SL_4N SL_5 SL_5N SL_6 SL_6N SL_7 SL_7N SL_8 SL_8N SL_9 SL_9N VDD VEVAL VSS WL WL_0 WL_1 WL_10 WL_11 WL_12 WL_13 WL_14 WL_15 WL_16 WL_17 WL_18 WL_19 WL_2 WL_20 WL_21 WL_22 WL_23 WL_24 WL_25 WL_26 WL_27 WL_28 WL_29 WL_3 WL_30 WL_31 WL_4 WL_5 WL_6 WL_7 WL_8 WL_9
    I1 (OUTP PSL_0 PSL_0N PSL_1 PSL_10 PSL_10N PSL_11 PSL_11N PSL_12 PSL_12N PSL_13 PSL_13N PSL_14 PSL_14N PSL_15 PSL_15N PSL_16 PSL_16N PSL_17 PSL_17N PSL_18 PSL_18N PSL_19 PSL_19N PSL_1N PSL_2 PSL_20 PSL_20N PSL_21 PSL_21N PSL_22 PSL_22N PSL_23 PSL_23N PSL_24 PSL_24N PSL_25 PSL_25N PSL_26 PSL_26N PSL_27 PSL_27N PSL_28 PSL_28N PSL_29 PSL_29N PSL_2N PSL_3 PSL_30 PSL_30N PSL_31 PSL_31N PSL_3N PSL_4 PSL_4N PSL_5 PSL_5N PSL_6 PSL_6N PSL_7 PSL_7N PSL_8 PSL_8N PSL_9 PSL_9N VDD VEVAL VSS WL PC) reference_complete
    I0 (ML_0 ML_1 ML_10 ML_11 ML_12 ML_13 ML_14 ML_15 ML_16 ML_17 ML_18 ML_19 ML_2 ML_20 ML_21 ML_22 ML_23 ML_24 ML_25 ML_26 ML_27 ML_28 ML_29 ML_3 ML_30 ML_31 ML_4 ML_5 ML_6 ML_7 ML_8 ML_9 SL_0 SL_0N SL_1 SL_10 SL_10N SL_11 SL_11N SL_12 SL_12N SL_13 SL_13N SL_14 SL_14N SL_15 SL_15N SL_16 SL_16N SL_17 SL_17N SL_18 SL_18N SL_19 SL_19N SL_1N SL_2 SL_20 SL_20N SL_21 SL_21N SL_22 SL_22N SL_23 SL_23N SL_24 SL_24N SL_25 SL_25N SL_26 SL_26N SL_27 SL_27N SL_28 SL_28N SL_29 SL_29N SL_2N SL_3 SL_30 SL_30N SL_31 SL_31N SL_3N SL_4 SL_4N SL_5 SL_5N SL_6 SL_6N SL_7 SL_7N SL_8 SL_8N SL_9 SL_9N VDD VEVAL VSS WL_0 WL_1 WL_10 WL_11 WL_12 WL_13 WL_14 WL_15 WL_16 WL_17 WL_18 WL_19 WL_2 WL_20 WL_21 WL_22 WL_23 WL_24 WL_25 WL_26 WL_27 WL_28 WL_29 WL_3 WL_30 WL_31 WL_4 WL_5 WL_6 WL_7 WL_8 WL_9 PC) ARRAY_32x32
    I326 (COMP0 COMP1 COMP10 COMP11 COMP12 COMP13 COMP14 COMP15 COMP16 COMP17 COMP18 COMP19 COMP2 COMP20 COMP21 COMP22 COMP23 COMP24 COMP25 COMP26 COMP27 COMP28 COMP29 COMP3 COMP30 COMP31 COMP4 COMP5 COMP6 COMP7 COMP8 COMP9 ML_0 ML_1 ML_10 ML_11 ML_12 ML_13 ML_14 ML_15 ML_16 ML_17 ML_18 ML_19 ML_2 ML_20 ML_21 ML_22 ML_23 ML_24 ML_25 ML_26 ML_27 ML_28 ML_29 ML_3 ML_30 ML_31 ML_4 ML_5 ML_6 ML_7 ML_8 ML_9 OUTP VDD VSS) PART_SENS_COMPARATOR
ends ANALOG_FIGURE

// CAMPROYECT/COMPLETE_PROYECT_FIG/schematic
subckt COMPLETE_PROYECT_FIG CLK EN_REFERENCE EN_SEARCH EN_WRITE OUTPUT VDD VEVAL_IN VSS reset serial_in_addr serial_in_data
    I18 (EN_REFERENCE EN_SEARCH EN_WRITE PC VEVAL1 CLK OUTPUT_en reset REF_sel wl_ref addr_shift deco_en shift_en VSS VDD) CAM_CONTROL
    I15 (REF_sel net48 net137 net135 net133 net131 net129 net127 net125 net123 net121 net119 net46 net117 net115 net113 net111 net109 net107 net105 net103 net101 net99 net44 net97 net96 net42 net40 net33 net30 net27 net23 net4 RS0 net3 net136 net134 net132 net130 RS15 RS16 net124 net122 net120 RS1 net118 net116 net114 net112 net110 net108 net106 net104 net102 net100 RS2 net98 RS31 net43 net41 net34 net31 net29 net25 net22 q0n q10n q11n q12n q13n q14n q15n q16n q17n q18n q19n q1n q20n q21n q22n q23n q24n q25n q26n q27n q28n q29n q2n q30n q31n q3n q4n q5n q6n q7n q8n q9n q0 q10 q11 q12 q13 q14 q15 q16 q17 q18 q19 q1 q20 q21 q22 q23 q24 q25 q26 q27 q28 q29 q2 q30 q31 q3 q4 q5 q6 q7 q8 q9 VSS VDD) REFERENCE_MUX
    I13 (VSS VDD deco_en add0 add1 add2 add3 add4 out0 out10 out11 out12 out13 out14 out15 out16 out17 out18 out19 out1 out20 out21 out22 out23 out24 out25 out26 out27 out28 out29 out2 out30 out31 out3 out4 out5 out6 out7 out8 out9) decoder_5to32
    I14 (VSS VDD CLK q0 q10 q11 q12 q13 q14 q15 q16 q17 q18 q19 q1 q20 q21 q22 q23 q24 q25 q26 q27 q28 q29 q2 q30 q31 q3 q4 q5 q6 q7 q8 q9 q0n q10n q11n q12n q13n q14n q15n q16n q17n q18n q19n q1n q20n q21n q22n q23n q24n q25n q26n q27n q28n q29n q2n q30n q31n q3n q4n q5n q6n q7n q8n q9n reset serial_in_data_int shift_en) shift_register_32
    I21 (serial_in_data REF_sel serial_in_data_int VDD VSS) Xnor
    I16 (VSS VDD CLK COMP0 net154 net153 net152 COMP13 net150 net149 net148 net147 net146 net145 net163 COMP20 net143 COMP22 net141 net140 net139 net138 net128 net126 net92 net162 net90 COMP31 net161 net160 COMP5 net158 net157 net156 net155 OUTPUT OUTPUT_en reset) OUTPUT
    I20 (COMP0 net163 net154 net153 net152 COMP13 net150 net149 net148 net147 net146 net145 net162 COMP20 net143 COMP22 net141 net140 net139 net138 net128 net126 net92 net161 net90 COMP31 net160 COMP5 net158 net157 net156 net155 PC RS0 net48 RS1 net3 net137 net136 net135 net134 net133 net132 net131 net130 net129 RS15 net127 RS16 net125 net124 net123 net122 net121 net120 net119 net46 RS2 net118 net117 net116 net115 net114 net113 net112 net111 net110 net109 net108 net107 net106 net105 net104 net103 net102 net101 net100 net99 net44 net43 net98 net97 RS31 net96 net42 net41 net40 net34 net33 net31 net30 net29 net27 net25 net23 net22 net4 q0 q0n q1 q10 q10n q11 q11n q12 q12n q13 q13n q14 q14n q15 q15n q16 q16n q17 q17n q18 q18n q19 q19n q1n q2 q20 q20n q21 q21n q22 q22n q23 q23n q24 q24n q25 q25n q26 q26n q27 q27n q28 q28n q29 q29n q2n q3 q30 q30n q31 q31n q3n q4 q4n q5 q5n q6 q6n q7 q7n q8 q8n q9 q9n VDD VEVAL VSS wl_ref out0 out1 out10 out11 out12 out13 out14 out15 out16 out17 out18 out19 out2 out20 out21 out22 out23 out24 out25 out26 out27 out28 out29 out3 out30 out31 out4 out5 out6 out7 out8 out9) ANALOG_FIGURE
    I12 (VSS VDD add0 add1 add2 add3 add4 addr_shift CLK reset serial_in_addr) SHIFT_5
// V_EVAL driver: inverter supplied by the external analog input VEVAL_IN
    N0 (VEVAL VEVAL1 VSS VSS) sg13_lv_nmos w=500n l=130n ng=1 m=1
    P0 (VEVAL VEVAL1 VEVAL_IN VEVAL_IN) sg13_lv_pmos w=15u l=130n ng=1 m=1
ends COMPLETE_PROYECT_FIG

// CAMPROYECT/COMPLETE_PROYECT_TB/schematic
I25 (CLK EN_REFERENCE EN_SEARCH EN_WRITE OUT VDD VEVAL_IN 0 reset serial_in_addr serial_in_data) COMPLETE_PROYECT_FIG
V0 (VDD 0) vsource dc=1.2 type=dc
V6 (VEVAL_IN 0) vsource dc=0.5 type=dc
V5 (CLK 0) vsource type=pulse val0=0 val1=1.2 period=10n delay=5n rise=10p fall=10p width=5n
simulatorOptions options temp=27.0
tran tran stop=3400n errpreset=moderate
saveOptions options pwr=all
// Netlists of the digital blocks (originally: CAMPROYECT/<block>/spiceText/spice.spc)
include "./digital_blocks.spice"
