simulator lang=spectre
myOpts options duplicate_subckt=warning
