simulator lang=spice
* =====================================================================
* Control for the 6-row test (0-3.3 V levels for IOVDD = 3.3 V): reset 0-20 ns, one EN pulse every 370 ns (20 ns wide)
* WRITE [30, 400, 770, 1140, 1510, 1880]  REFERENCE [2250]  SEARCH [2620]
* =====================================================================

VRST reset 0 PWL(
+ 0 3.3
+ 20n 3.3
+ 20.05n 0
+ )

VENW EN_WRITE 0 PWL(
+ 0 0
+ 30n 0
+ 30.05n 3.3
+ 50n 3.3
+ 50.05n 0
+ 400n 0
+ 400.05n 3.3
+ 420n 3.3
+ 420.05n 0
+ 770n 0
+ 770.05n 3.3
+ 790n 3.3
+ 790.05n 0
+ 1140n 0
+ 1140.05n 3.3
+ 1160n 3.3
+ 1160.05n 0
+ 1510n 0
+ 1510.05n 3.3
+ 1530n 3.3
+ 1530.05n 0
+ 1880n 0
+ 1880.05n 3.3
+ 1900n 3.3
+ 1900.05n 0
+ )

VENR EN_REFERENCE 0 PWL(
+ 0 0
+ 2250n 0
+ 2250.05n 3.3
+ 2270n 3.3
+ 2270.05n 0
+ )

VENS EN_SEARCH 0 PWL(
+ 0 0
+ 2620n 0
+ 2620.05n 3.3
+ 2640n 3.3
+ 2640.05n 0
+ )
