simulator lang=spice
* =====================================================================
* Control prueba 6 filas: reset 0-20 ns, un EN cada 370 ns (20 ns)
* WRITE [30, 400, 770, 1140, 1510, 1880]  REFERENCE [2250]  SEARCH [2620]
* =====================================================================

VRST reset 0 PWL(
+ 0 1.2
+ 20n 1.2
+ 20.05n 0
+ )

VENW EN_WRITE 0 PWL(
+ 0 0
+ 30n 0
+ 30.05n 1.2
+ 50n 1.2
+ 50.05n 0
+ 400n 0
+ 400.05n 1.2
+ 420n 1.2
+ 420.05n 0
+ 770n 0
+ 770.05n 1.2
+ 790n 1.2
+ 790.05n 0
+ 1140n 0
+ 1140.05n 1.2
+ 1160n 1.2
+ 1160.05n 0
+ 1510n 0
+ 1510.05n 1.2
+ 1530n 1.2
+ 1530.05n 0
+ 1880n 0
+ 1880.05n 1.2
+ 1900n 1.2
+ 1900.05n 0
+ )

VENR EN_REFERENCE 0 PWL(
+ 0 0
+ 2250n 0
+ 2250.05n 1.2
+ 2270n 1.2
+ 2270.05n 0
+ )

VENS EN_SEARCH 0 PWL(
+ 0 0
+ 2620n 0
+ 2620.05n 1.2
+ 2640n 1.2
+ 2640.05n 0
+ )
