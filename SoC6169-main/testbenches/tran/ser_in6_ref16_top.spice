simulator lang=spice
* =====================================================================
* (0-3.3 V levels for IOVDD = 3.3 V)
* 6-ROW TEST: 6 WRITE + REFERENCE (m_ref = 16) + SEARCH (query 0x0000FFFF)
* WRITE/REFERENCE data in NORMAL form (the input XNOR handles the polarity)
* Use with ctrl_in6_top.spice. Transient: 0 to 3400 ns
*
* W row  0  EN 30-50 ns  E0=35  data=0x0000FFFF  addr=00000  mm=0
* W row  5  EN 400-420 ns  E0=405  data=0x0000E000  addr=00101  mm=13
* W row 13  EN 770-790 ns  E0=775  data=0x00FF01FF  addr=01101  mm=15
* W row 20  EN 1140-1160 ns  E0=1145  data=0x00FF00FF  addr=10100  mm=16
* W row 22  EN 1510-1530 ns  E0=1515  data=0x00030000  addr=10110  mm=18
* W row 31  EN 1880-1900 ns  E0=1885  data=0xFFFF0000  addr=11111  mm=32
* REFERENCE  EN 2250-2270 ns  E0=2255  data=0xFFFFFFFF  mm=16
* SEARCH     EN 2620-2640 ns  E0=2625  data=0x0000FFFF
*
* mm = effective mismatches in the search (post-layout: match if HD <= 15)
* Expected: COMP0=0 COMP5=0 COMP13=0 | COMP20=1 COMP22=1 COMP31=1
* =====================================================================

VSADDR serial_in_addr 0 PWL(
+ 0 0
+ 430n 0
+ 430.05n 3.3
+ 440n 3.3
+ 440.05n 0
+ 450n 0
+ 450.05n 3.3
+ 460n 3.3
+ 460.05n 0
+ 790n 0
+ 790.05n 3.3
+ 810n 3.3
+ 810.05n 0
+ 820n 0
+ 820.05n 3.3
+ 830n 3.3
+ 830.05n 0
+ 1150n 0
+ 1150.05n 3.3
+ 1160n 3.3
+ 1160.05n 0
+ 1170n 0
+ 1170.05n 3.3
+ 1180n 3.3
+ 1180.05n 0
+ 1520n 0
+ 1520.05n 3.3
+ 1530n 3.3
+ 1530.05n 0
+ 1540n 0
+ 1540.05n 3.3
+ 1560n 3.3
+ 1560.05n 0
+ 1890n 0
+ 1890.05n 3.3
+ 1940n 3.3
+ 1940.05n 0
+ )

VSDATA serial_in_data 0 PWL(
+ 0 0
+ 200n 0
+ 200.05n 3.3
+ 360n 3.3
+ 360.05n 0
+ 570n 0
+ 570.05n 3.3
+ 600n 3.3
+ 600.05n 0
+ 860n 0
+ 860.05n 3.3
+ 940n 3.3
+ 940.05n 0
+ 1010n 0
+ 1010.05n 3.3
+ 1100n 3.3
+ 1100.05n 0
+ 1230n 0
+ 1230.05n 3.3
+ 1310n 3.3
+ 1310.05n 0
+ 1390n 0
+ 1390.05n 3.3
+ 1470n 3.3
+ 1470.05n 0
+ 1660n 0
+ 1660.05n 3.3
+ 1680n 3.3
+ 1680.05n 0
+ 1890n 0
+ 1890.05n 3.3
+ 2050n 3.3
+ 2050.05n 0
+ 2260n 0
+ 2260.05n 3.3
+ 2580n 3.3
+ 2580.05n 0
+ 2790n 0
+ 2790.05n 3.3
+ 2950n 3.3
+ 2950.05n 0
+ )
