* NGSPICE file created from SoC6169.ext - technology: ihp-sg13cmos5l

.subckt sg13cmos5l_decap_8 VSS VDD
X0 VSS VDD VSS VSS sg13_lv_nmos ad=0.1428p pd=1.52u as=3.1269p ps=15.58u w=0.42u l=1u
X1 VDD VSS VDD VDD sg13_lv_pmos ad=0.19p pd=1.38u as=4.13118p ps=17.18u w=1u l=1u
X2 VSS VDD VSS VSS sg13_lv_nmos ad=79.8f pd=0.8u as=0 ps=0 w=0.42u l=1u
X3 VDD VSS VDD VDD sg13_lv_pmos ad=0.34p pd=2.68u as=0 ps=0 w=1u l=1u
.ends

.subckt sg13cmos5l_decap_4 VSS VDD
X0 VDD VSS VDD VDD sg13_lv_pmos ad=0.34p pd=2.68u as=2.4331p ps=11.58u w=1u l=1u
X1 VSS VDD VSS VSS sg13_lv_nmos ad=0.1428p pd=1.52u as=1.84612p ps=9.32u w=0.42u l=1u
.ends

.subckt sg13cmos5l_SecondaryProtection iovdd pad core iovss
X0 core iovdd dpantenna l=0.64u w=4.98u
X1 core pad iovss rppd l=2u w=1u
X2 iovss core dantenna l=3.1u w=0.64u
.ends

.subckt sg13cmos5l_DCPDiode anode cathode guard anode_uq0
X0 anode_uq0 cathode dpantenna l=1.26u w=27.78u
X1 anode cathode dpantenna l=1.26u w=27.78u
.ends

.subckt sg13cmos5l_Clamp_P20N0D iovdd iovss pad pad_uq0 pad_uq1 pad_uq2 pad_uq3 pad_uq4
+ pad_uq5 pad_uq6 pad_uq7 pad_uq8
X0 iovdd a_5044_476# pad_uq3 iovdd sg13_hv_pmos ad=2.1312p pd=7.3u as=3.9294p ps=7.84u w=6.66u l=0.6u
X1 pad_uq5 a_5044_476# iovdd iovdd sg13_hv_pmos ad=3.9294p pd=7.84u as=2.1312p ps=7.3u w=6.66u l=0.6u
X2 iovdd a_5044_476# pad_uq1 iovdd sg13_hv_pmos ad=2.1312p pd=7.3u as=3.9294p ps=7.84u w=6.66u l=0.6u
X3 pad_uq7 a_5044_476# iovdd iovdd sg13_hv_pmos ad=3.9294p pd=7.84u as=2.1312p ps=7.3u w=6.66u l=0.6u
X4 pad_uq6 a_5044_476# iovdd iovdd sg13_hv_pmos ad=3.9294p pd=7.84u as=2.1312p ps=7.3u w=6.66u l=0.6u
X5 iovdd a_5044_476# pad_uq2 iovdd sg13_hv_pmos ad=2.1312p pd=7.3u as=3.9294p ps=7.84u w=6.66u l=0.6u
X6 a_5044_476# iovdd iovdd rppd l=12.9u w=0.5u
X7 pad_uq6 a_5044_476# iovdd iovdd sg13_hv_pmos ad=3.9294p pd=7.84u as=2.1312p ps=7.3u w=6.66u l=0.6u
X8 iovdd a_5044_476# pad_uq6 iovdd sg13_hv_pmos ad=2.1312p pd=7.3u as=3.9294p ps=7.84u w=6.66u l=0.6u
X9 pad_uq2 a_5044_476# iovdd iovdd sg13_hv_pmos ad=3.9294p pd=7.84u as=2.1312p ps=7.3u w=6.66u l=0.6u
X10 iovdd a_5044_476# pad iovdd sg13_hv_pmos ad=2.1312p pd=7.3u as=3.9294p ps=7.84u w=6.66u l=0.6u
X11 iovdd a_5044_476# pad_uq6 iovdd sg13_hv_pmos ad=2.1312p pd=7.3u as=3.9294p ps=7.84u w=6.66u l=0.6u
X12 pad_uq2 a_5044_476# iovdd iovdd sg13_hv_pmos ad=3.9294p pd=7.84u as=2.1312p ps=7.3u w=6.66u l=0.6u
X13 iovdd a_5044_476# pad_uq5 iovdd sg13_hv_pmos ad=2.1312p pd=7.3u as=3.9294p ps=7.84u w=6.66u l=0.6u
X14 iovdd a_5044_476# pad_uq1 iovdd sg13_hv_pmos ad=2.1312p pd=7.3u as=3.9294p ps=7.84u w=6.66u l=0.6u
X15 pad_uq3 a_5044_476# iovdd iovdd sg13_hv_pmos ad=3.9294p pd=7.84u as=2.1312p ps=7.3u w=6.66u l=0.6u
X16 pad_uq1 a_5044_476# iovdd iovdd sg13_hv_pmos ad=3.9294p pd=7.84u as=2.1312p ps=7.3u w=6.66u l=0.6u
X17 iovdd a_5044_476# pad_uq7 iovdd sg13_hv_pmos ad=2.1312p pd=7.3u as=3.9294p ps=7.84u w=6.66u l=0.6u
X18 pad_uq0 a_5044_476# iovdd iovdd sg13_hv_pmos ad=3.9294p pd=7.84u as=2.1312p ps=7.3u w=6.66u l=0.6u
X19 iovdd a_5044_476# pad_uq3 iovdd sg13_hv_pmos ad=2.1312p pd=7.3u as=3.9294p ps=7.84u w=6.66u l=0.6u
X20 pad_uq7 a_5044_476# iovdd iovdd sg13_hv_pmos ad=3.9294p pd=7.84u as=2.1312p ps=7.3u w=6.66u l=0.6u
X21 iovdd a_5044_476# pad_uq0 iovdd sg13_hv_pmos ad=3.1302p pd=14.26u as=3.9294p ps=7.84u w=6.66u l=0.6u
X22 pad_uq8 a_5044_476# iovdd iovdd sg13_hv_pmos ad=3.9294p pd=7.84u as=3.1302p ps=14.26u w=6.66u l=0.6u
X23 pad_uq8 a_5044_476# iovdd iovdd sg13_hv_pmos ad=3.9294p pd=7.84u as=3.1302p ps=14.26u w=6.66u l=0.6u
X24 iovdd a_5044_476# pad iovdd sg13_hv_pmos ad=2.1312p pd=7.3u as=3.9294p ps=7.84u w=6.66u l=0.6u
X25 pad_uq4 a_5044_476# iovdd iovdd sg13_hv_pmos ad=3.9294p pd=7.84u as=2.1312p ps=7.3u w=6.66u l=0.6u
X26 iovdd a_5044_476# pad_uq7 iovdd sg13_hv_pmos ad=2.1312p pd=7.3u as=3.9294p ps=7.84u w=6.66u l=0.6u
X27 pad_uq3 a_5044_476# iovdd iovdd sg13_hv_pmos ad=3.9294p pd=7.84u as=2.1312p ps=7.3u w=6.66u l=0.6u
X28 iovdd a_5044_476# pad_uq8 iovdd sg13_hv_pmos ad=2.1312p pd=7.3u as=3.9294p ps=7.84u w=6.66u l=0.6u
X29 pad_uq5 a_5044_476# iovdd iovdd sg13_hv_pmos ad=3.9294p pd=7.84u as=2.1312p ps=7.3u w=6.66u l=0.6u
X30 pad_uq0 a_5044_476# iovdd iovdd sg13_hv_pmos ad=3.9294p pd=7.84u as=2.1312p ps=7.3u w=6.66u l=0.6u
X31 iovdd a_5044_476# pad_uq0 iovdd sg13_hv_pmos ad=3.1302p pd=14.26u as=3.9294p ps=7.84u w=6.66u l=0.6u
X32 pad a_5044_476# iovdd iovdd sg13_hv_pmos ad=3.9294p pd=7.84u as=2.1312p ps=7.3u w=6.66u l=0.6u
X33 iovdd a_5044_476# pad_uq8 iovdd sg13_hv_pmos ad=2.1312p pd=7.3u as=3.9294p ps=7.84u w=6.66u l=0.6u
X34 iovdd a_5044_476# pad_uq4 iovdd sg13_hv_pmos ad=2.1312p pd=7.3u as=3.9294p ps=7.84u w=6.66u l=0.6u
X35 iovdd a_5044_476# pad_uq2 iovdd sg13_hv_pmos ad=2.1312p pd=7.3u as=3.9294p ps=7.84u w=6.66u l=0.6u
X36 iovdd a_5044_476# pad_uq4 iovdd sg13_hv_pmos ad=2.1312p pd=7.3u as=3.9294p ps=7.84u w=6.66u l=0.6u
X37 pad_uq4 a_5044_476# iovdd iovdd sg13_hv_pmos ad=3.9294p pd=7.84u as=2.1312p ps=7.3u w=6.66u l=0.6u
X38 pad a_5044_476# iovdd iovdd sg13_hv_pmos ad=3.9294p pd=7.84u as=2.1312p ps=7.3u w=6.66u l=0.6u
X39 iovdd a_5044_476# pad_uq5 iovdd sg13_hv_pmos ad=2.1312p pd=7.3u as=3.9294p ps=7.84u w=6.66u l=0.6u
X40 pad_uq1 a_5044_476# iovdd iovdd sg13_hv_pmos ad=3.9294p pd=7.84u as=2.1312p ps=7.3u w=6.66u l=0.6u
.ends

.subckt sg13cmos5l_DCNDiode cathode anode guard cathode_uq0
X0 anode cathode_uq0 dantenna l=1.26u w=27.78u
X1 anode cathode dantenna l=1.26u w=27.78u
.ends

.subckt sg13cmos5l_Clamp_N20N0D iovss pad pad_uq0 pad_uq1 pad_uq2 pad_uq3 pad_uq4
+ pad_uq5 pad_uq6 pad_uq7 pad_uq8 w_n124_n124#
X0 pad_uq5 a_5044_476# iovss iovss sg13_hv_nmos ad=2.596p pd=5.58u as=1.408p ps=5.04u w=4.4u l=0.6u
X1 iovss a_5044_476# pad_uq1 iovss sg13_hv_nmos ad=1.408p pd=5.04u as=2.596p ps=5.58u w=4.4u l=0.6u
X2 pad_uq6 a_5044_476# iovss iovss sg13_hv_nmos ad=2.596p pd=5.58u as=1.408p ps=5.04u w=4.4u l=0.6u
X3 iovss a_5044_476# pad_uq2 iovss sg13_hv_nmos ad=1.408p pd=5.04u as=2.596p ps=5.58u w=4.4u l=0.6u
X4 a_5044_476# iovss iovss rppd l=3.54u w=0.5u
X5 iovss a_5044_476# pad_uq6 iovss sg13_hv_nmos ad=1.408p pd=5.04u as=2.596p ps=5.58u w=4.4u l=0.6u
X6 pad_uq2 a_5044_476# iovss iovss sg13_hv_nmos ad=2.596p pd=5.58u as=1.408p ps=5.04u w=4.4u l=0.6u
X7 pad_uq3 a_5044_476# iovss iovss sg13_hv_nmos ad=2.596p pd=5.58u as=1.408p ps=5.04u w=4.4u l=0.6u
X8 iovss a_5044_476# pad_uq7 iovss sg13_hv_nmos ad=1.408p pd=5.04u as=2.596p ps=5.58u w=4.4u l=0.6u
X9 pad_uq0 a_5044_476# iovss iovss sg13_hv_nmos ad=2.596p pd=5.58u as=1.408p ps=5.04u w=4.4u l=0.6u
X10 iovss a_5044_476# pad_uq3 iovss sg13_hv_nmos ad=1.408p pd=5.04u as=2.596p ps=5.58u w=4.4u l=0.6u
X11 pad_uq7 a_5044_476# iovss iovss sg13_hv_nmos ad=2.596p pd=5.58u as=1.408p ps=5.04u w=4.4u l=0.6u
X12 iovss a_5044_476# pad_uq0 iovss sg13_hv_nmos ad=2.068p pd=9.74u as=2.596p ps=5.58u w=4.4u l=0.6u
X13 pad_uq8 a_5044_476# iovss iovss sg13_hv_nmos ad=2.596p pd=5.58u as=2.068p ps=9.74u w=4.4u l=0.6u
X14 iovss a_5044_476# pad iovss sg13_hv_nmos ad=1.408p pd=5.04u as=2.596p ps=5.58u w=4.4u l=0.6u
X15 pad_uq4 a_5044_476# iovss iovss sg13_hv_nmos ad=2.596p pd=5.58u as=1.408p ps=5.04u w=4.4u l=0.6u
X16 iovss a_5044_476# pad_uq8 iovss sg13_hv_nmos ad=1.408p pd=5.04u as=2.596p ps=5.58u w=4.4u l=0.6u
X17 pad a_5044_476# iovss iovss sg13_hv_nmos ad=2.596p pd=5.58u as=1.408p ps=5.04u w=4.4u l=0.6u
X18 iovss a_5044_476# pad_uq4 iovss sg13_hv_nmos ad=1.408p pd=5.04u as=2.596p ps=5.58u w=4.4u l=0.6u
X19 iovss a_5044_476# pad_uq5 iovss sg13_hv_nmos ad=1.408p pd=5.04u as=2.596p ps=5.58u w=4.4u l=0.6u
X20 pad_uq1 a_5044_476# iovss iovss sg13_hv_nmos ad=2.596p pd=5.58u as=1.408p ps=5.04u w=4.4u l=0.6u
.ends

.subckt sg13cmos5l_IOPadAnalog padres vdd iovss iovdd iovdd_uq0 sg13cmos5l_DCNDiode_0/guard
+ vss pad
Xsg13cmos5l_SecondaryProtection_0 iovdd pad padres vss sg13cmos5l_SecondaryProtection
Xsg13cmos5l_DCPDiode_0 pad iovdd_uq0 vss pad sg13cmos5l_DCPDiode
Xsg13cmos5l_Clamp_P20N0D_0 iovdd_uq0 vss pad pad pad pad pad pad pad pad pad pad sg13cmos5l_Clamp_P20N0D
Xsg13cmos5l_DCNDiode_0 pad vss sg13cmos5l_DCNDiode_0/guard pad sg13cmos5l_DCNDiode
Xsg13cmos5l_Clamp_N20N0D_0 vss pad pad pad pad pad pad pad pad pad pad sg13cmos5l_DCNDiode_0/guard
+ sg13cmos5l_Clamp_N20N0D
.ends

.subckt sg13g2_SecondaryProtection plus minus core pad
X0 core plus dpantenna l=0.64u w=4.98u
X1 core pad minus rppd l=2u w=1u
X2 minus core dantenna l=3.1u w=0.64u
.ends

.subckt sg13cmos5l_LevelDown vdd core pad a_1826_n1666# vss iovdd
Xsg13g2_SecondaryProtection_0 iovdd vss sg13g2_SecondaryProtection_0/core pad sg13g2_SecondaryProtection
X0 vss sg13g2_SecondaryProtection_0/core a_525_1768# vss sg13_hv_nmos ad=0.247p pd=1.68u as=0.442p ps=3.28u w=1.3u l=0.45u
X1 a_359_1768# a_525_1768# iovdd iovdd sg13_hv_pmos ad=0.437p pd=2.68u as=0.437p ps=2.68u w=2.3u l=0.45u
X2 a_525_1768# sg13g2_SecondaryProtection_0/core iovdd iovdd sg13_hv_pmos ad=0.437p pd=2.68u as=0.782p ps=5.28u w=2.3u l=0.45u
X3 vdd a_89_1790# core vdd sg13_lv_pmos ad=1.615p pd=10.18u as=1.615p ps=10.18u w=4.75u l=0.13u
X4 a_89_1790# a_359_1768# vss vss sg13_hv_nmos ad=0.5035p pd=3.03u as=0.901p ps=5.98u w=2.65u l=0.45u
X5 vss a_89_1790# core vss sg13_lv_nmos ad=0.935p pd=6.18u as=0.935p ps=6.18u w=2.75u l=0.13u
X6 iovdd sg13g2_SecondaryProtection_0/core a_525_1768# iovdd sg13_hv_pmos ad=0.437p pd=2.68u as=0.437p ps=2.68u w=2.3u l=0.45u
X7 iovdd a_525_1768# a_359_1768# iovdd sg13_hv_pmos ad=0.782p pd=5.28u as=0.437p ps=2.68u w=2.3u l=0.45u
X8 a_359_1768# a_525_1768# vss vss sg13_hv_nmos ad=0.442p pd=3.28u as=0.247p ps=1.68u w=1.3u l=0.45u
X9 vdd a_525_1768# a_89_1790# vss sg13_hv_nmos ad=0.901p pd=5.98u as=0.5035p ps=3.03u w=2.65u l=0.45u
X10 vdd vdd vdd vdd sg13_hv_pmos ad=1.581p pd=9.98u as=9.6081p ps=53.91u w=4.65u l=0.45u
.ends

.subckt sg13cmos5l_IOPadIn pad p2c vdd vss iovdd sg13cmos5l_DCNDiode_0/guard
Xsg13cmos5l_DCPDiode_0 pad iovdd vss pad sg13cmos5l_DCPDiode
Xsg13cmos5l_LevelDown_0 vdd p2c pad vss vss iovdd sg13cmos5l_LevelDown
Xsg13cmos5l_DCNDiode_0 pad vss sg13cmos5l_DCNDiode_0/guard pad sg13cmos5l_DCNDiode
.ends

.subckt sg13cmos5l_Clamp_N15N15D iovss pad gate pad_uq0 pad_uq1 pad_uq2 pad_uq3 pad_uq4
+ pad_uq5 pad_uq6 w_n124_n124#
X0 iovss gate pad_uq6 iovss sg13_hv_nmos ad=1.408p pd=5.04u as=2.596p ps=5.58u w=4.4u l=0.6u
X1 pad_uq5 gate iovss iovss sg13_hv_nmos ad=2.596p pd=5.58u as=1.408p ps=5.04u w=4.4u l=0.6u
X2 iovss gate pad_uq2 iovss sg13_hv_nmos ad=1.408p pd=5.04u as=2.596p ps=5.58u w=4.4u l=0.6u
X3 iovss gate dantenna l=0.78u w=0.78u
X4 pad_uq6 gate iovss iovss sg13_hv_nmos ad=2.596p pd=5.58u as=2.068p ps=9.74u w=4.4u l=0.6u
X5 pad_uq1 gate iovss iovss sg13_hv_nmos ad=2.596p pd=5.58u as=1.408p ps=5.04u w=4.4u l=0.6u
X6 pad_uq2 gate iovss iovss sg13_hv_nmos ad=2.596p pd=5.58u as=1.408p ps=5.04u w=4.4u l=0.6u
X7 pad_uq0 gate iovss iovss sg13_hv_nmos ad=3.256p pd=10.28u as=1.408p ps=5.04u w=4.4u l=0.6u
X8 iovss gate pad_uq3 iovss sg13_hv_nmos ad=1.408p pd=5.04u as=2.596p ps=5.58u w=4.4u l=0.6u
X9 iovss gate pad_uq4 iovss sg13_hv_nmos ad=1.408p pd=5.04u as=2.596p ps=5.58u w=4.4u l=0.6u
X10 pad_uq3 gate iovss iovss sg13_hv_nmos ad=2.596p pd=5.58u as=1.408p ps=5.04u w=4.4u l=0.6u
X11 pad_uq4 gate iovss iovss sg13_hv_nmos ad=2.596p pd=5.58u as=1.408p ps=5.04u w=4.4u l=0.6u
X12 iovss gate pad iovss sg13_hv_nmos ad=1.408p pd=5.04u as=2.596p ps=5.58u w=4.4u l=0.6u
X13 iovss gate pad_uq1 iovss sg13_hv_nmos ad=1.408p pd=5.04u as=2.596p ps=5.58u w=4.4u l=0.6u
X14 pad gate iovss iovss sg13_hv_nmos ad=2.596p pd=5.58u as=1.408p ps=5.04u w=4.4u l=0.6u
X15 iovss gate pad_uq5 iovss sg13_hv_nmos ad=1.408p pd=5.04u as=2.596p ps=5.58u w=4.4u l=0.6u
.ends

.subckt sg13cmos5l_Clamp_P15N15D iovdd iovss pad gate pad_uq0 pad_uq1 pad_uq2 pad_uq3
+ pad_uq4 pad_uq5 pad_uq6
X0 iovdd gate pad_uq2 iovdd sg13_hv_pmos ad=2.1312p pd=7.3u as=3.9294p ps=7.84u w=6.66u l=0.6u
X1 iovdd gate pad_uq6 iovdd sg13_hv_pmos ad=2.1312p pd=7.3u as=3.9294p ps=7.84u w=6.66u l=0.6u
X2 pad_uq5 gate iovdd iovdd sg13_hv_pmos ad=3.9294p pd=7.84u as=2.1312p ps=7.3u w=6.66u l=0.6u
X3 pad_uq1 gate iovdd iovdd sg13_hv_pmos ad=3.9294p pd=7.84u as=2.1312p ps=7.3u w=6.66u l=0.6u
X4 pad_uq5 gate iovdd iovdd sg13_hv_pmos ad=3.9294p pd=7.84u as=2.1312p ps=7.3u w=6.66u l=0.6u
X5 iovdd gate pad_uq2 iovdd sg13_hv_pmos ad=2.1312p pd=7.3u as=3.9294p ps=7.84u w=6.66u l=0.6u
X6 pad_uq6 gate iovdd iovdd sg13_hv_pmos ad=3.9294p pd=7.84u as=3.1302p ps=14.26u w=6.66u l=0.6u
X7 pad_uq6 gate iovdd iovdd sg13_hv_pmos ad=3.9294p pd=7.84u as=3.1302p ps=14.26u w=6.66u l=0.6u
X8 pad gate iovdd iovdd sg13_hv_pmos ad=3.9294p pd=7.84u as=2.1312p ps=7.3u w=6.66u l=0.6u
X9 pad_uq1 gate iovdd iovdd sg13_hv_pmos ad=3.9294p pd=7.84u as=2.1312p ps=7.3u w=6.66u l=0.6u
X10 iovdd gate pad_uq5 iovdd sg13_hv_pmos ad=2.1312p pd=7.3u as=3.9294p ps=7.84u w=6.66u l=0.6u
X11 pad_uq2 gate iovdd iovdd sg13_hv_pmos ad=3.9294p pd=7.84u as=2.1312p ps=7.3u w=6.66u l=0.6u
X12 gate iovdd dpantenna l=0.78u w=0.78u
X13 iovdd gate pad_uq4 iovdd sg13_hv_pmos ad=2.1312p pd=7.3u as=3.9294p ps=7.84u w=6.66u l=0.6u
X14 iovdd gate pad iovdd sg13_hv_pmos ad=2.1312p pd=7.3u as=3.9294p ps=7.84u w=6.66u l=0.6u
X15 pad_uq0 gate iovdd iovdd sg13_hv_pmos ad=4.9284p pd=14.8u as=2.1312p ps=7.3u w=6.66u l=0.6u
X16 iovdd gate pad_uq3 iovdd sg13_hv_pmos ad=2.1312p pd=7.3u as=3.9294p ps=7.84u w=6.66u l=0.6u
X17 pad_uq2 gate iovdd iovdd sg13_hv_pmos ad=3.9294p pd=7.84u as=2.1312p ps=7.3u w=6.66u l=0.6u
X18 iovdd gate pad_uq4 iovdd sg13_hv_pmos ad=2.1312p pd=7.3u as=3.9294p ps=7.84u w=6.66u l=0.6u
X19 pad_uq3 gate iovdd iovdd sg13_hv_pmos ad=3.9294p pd=7.84u as=2.1312p ps=7.3u w=6.66u l=0.6u
X20 pad_uq3 gate iovdd iovdd sg13_hv_pmos ad=3.9294p pd=7.84u as=2.1312p ps=7.3u w=6.66u l=0.6u
X21 pad_uq4 gate iovdd iovdd sg13_hv_pmos ad=3.9294p pd=7.84u as=2.1312p ps=7.3u w=6.66u l=0.6u
X22 iovdd gate pad iovdd sg13_hv_pmos ad=2.1312p pd=7.3u as=3.9294p ps=7.84u w=6.66u l=0.6u
X23 iovdd gate pad_uq6 iovdd sg13_hv_pmos ad=2.1312p pd=7.3u as=3.9294p ps=7.84u w=6.66u l=0.6u
X24 iovdd gate pad_uq1 iovdd sg13_hv_pmos ad=2.1312p pd=7.3u as=3.9294p ps=7.84u w=6.66u l=0.6u
X25 pad gate iovdd iovdd sg13_hv_pmos ad=3.9294p pd=7.84u as=2.1312p ps=7.3u w=6.66u l=0.6u
X26 pad_uq0 gate iovdd iovdd sg13_hv_pmos ad=4.9284p pd=14.8u as=2.1312p ps=7.3u w=6.66u l=0.6u
X27 pad_uq4 gate iovdd iovdd sg13_hv_pmos ad=3.9294p pd=7.84u as=2.1312p ps=7.3u w=6.66u l=0.6u
X28 iovdd gate pad_uq1 iovdd sg13_hv_pmos ad=2.1312p pd=7.3u as=3.9294p ps=7.84u w=6.66u l=0.6u
X29 iovdd gate pad_uq3 iovdd sg13_hv_pmos ad=2.1312p pd=7.3u as=3.9294p ps=7.84u w=6.66u l=0.6u
X30 iovdd gate pad_uq5 iovdd sg13_hv_pmos ad=2.1312p pd=7.3u as=3.9294p ps=7.84u w=6.66u l=0.6u
.ends

.subckt sg13cmos5l_LevelUpInv vdd vss iovdd i o
X0 a_89_470# a_21_1826# vss vss sg13_hv_nmos ad=0.646p pd=4.48u as=0.361p ps=2.28u w=1.9u l=0.45u
X1 iovdd a_89_470# a_21_506# iovdd sg13_hv_pmos ad=57f pd=0.68u as=0.102p ps=1.28u w=0.3u l=0.45u
X2 vdd i a_21_1826# vdd sg13_lv_pmos ad=1.615p pd=10.18u as=1.615p ps=10.18u w=4.75u l=0.13u
X3 a_89_470# a_21_506# iovdd iovdd sg13_hv_pmos ad=0.102p pd=1.28u as=57f ps=0.68u w=0.3u l=0.45u
X4 vss i a_21_1826# vss sg13_lv_nmos ad=0.935p pd=6.18u as=0.935p ps=6.18u w=2.75u l=0.13u
X5 vss i a_21_506# vss sg13_hv_nmos ad=0.361p pd=2.28u as=0.646p ps=4.48u w=1.9u l=0.45u
X6 o a_89_470# vss vss sg13_hv_nmos ad=0.646p pd=4.48u as=0.646p ps=4.48u w=1.9u l=0.45u
X7 o a_89_470# iovdd iovdd sg13_hv_pmos ad=1.326p pd=8.48u as=1.326p ps=8.48u w=3.9u l=0.45u
.ends

.subckt sg13cmos5l_GateLevelUpInv iovdd ngate pgate core vss vdd
Xsg13cmos5l_LevelUpInv_0 vdd vss iovdd core pgate sg13cmos5l_LevelUpInv
Xsg13cmos5l_LevelUpInv_1 vdd vss iovdd core ngate sg13cmos5l_LevelUpInv
.ends

.subckt sg13cmos5l_IOPadOut30mA pad c2p iovss iovdd vdd iovdd_uq0 vss sg13cmos5l_DCNDiode_0/guard
Xsg13cmos5l_Clamp_N15N15D_0 vss pad sg13cmos5l_Clamp_N15N15D_0/gate pad pad pad pad
+ pad pad pad sg13cmos5l_DCNDiode_0/guard sg13cmos5l_Clamp_N15N15D
Xsg13cmos5l_DCPDiode_0 pad iovdd_uq0 vss pad sg13cmos5l_DCPDiode
Xsg13cmos5l_Clamp_P15N15D_0 iovdd_uq0 vss pad sg13cmos5l_Clamp_P15N15D_0/gate pad
+ pad pad pad pad pad pad sg13cmos5l_Clamp_P15N15D
Xsg13cmos5l_GateLevelUpInv_0 iovdd sg13cmos5l_Clamp_N15N15D_0/gate sg13cmos5l_Clamp_P15N15D_0/gate
+ c2p vss vdd sg13cmos5l_GateLevelUpInv
Xsg13cmos5l_DCNDiode_0 pad vss sg13cmos5l_DCNDiode_0/guard pad sg13cmos5l_DCNDiode
.ends

.subckt sg13cmos5l_IOPadVss vss iovdd vdd sg13cmos5l_DCNDiode_0/guard
Xsg13cmos5l_DCPDiode_0 vss iovdd vss vss sg13cmos5l_DCPDiode
Xsg13cmos5l_DCNDiode_0 vss vss sg13cmos5l_DCNDiode_0/guard vss sg13cmos5l_DCNDiode
.ends

.subckt sg13cmos5l_Clamp_N43N43D4R iovss pad gate pad_uq0 pad_uq1 pad_uq2 pad_uq3
+ pad_uq4 pad_uq5 pad_uq6 pad_uq7 pad_uq8 pad_uq9 pad_uq10 pad_uq11 pad_uq12 pad_uq13
+ pad_uq14 pad_uq15 pad_uq16 pad_uq17 pad_uq18 pad_uq19 pad_uq20 w_n124_n124#
X0 iovss gate pad_uq1 iovss sg13_hv_nmos ad=1.408p pd=5.04u as=2.596p ps=5.58u w=4.4u l=0.6u
X1 iovss gate pad_uq19 iovss sg13_hv_nmos ad=1.408p pd=5.04u as=2.596p ps=5.58u w=4.4u l=0.6u
X2 iovss gate pad_uq15 iovss sg13_hv_nmos ad=1.408p pd=5.04u as=2.596p ps=5.58u w=4.4u l=0.6u
X3 iovss gate pad_uq13 iovss sg13_hv_nmos ad=1.408p pd=5.04u as=2.596p ps=5.58u w=4.4u l=0.6u
X4 pad_uq17 gate iovss iovss sg13_hv_nmos ad=2.596p pd=5.58u as=1.408p ps=5.04u w=4.4u l=0.6u
X5 pad_uq15 gate iovss iovss sg13_hv_nmos ad=2.596p pd=5.58u as=1.408p ps=5.04u w=4.4u l=0.6u
X6 pad_uq0 gate iovss iovss sg13_hv_nmos ad=3.256p pd=10.28u as=1.408p ps=5.04u w=4.4u l=0.6u
X7 pad_uq12 gate iovss iovss sg13_hv_nmos ad=2.596p pd=5.58u as=1.408p ps=5.04u w=4.4u l=0.6u
X8 pad_uq5 gate iovss iovss sg13_hv_nmos ad=2.596p pd=5.58u as=1.408p ps=5.04u w=4.4u l=0.6u
X9 iovss gate pad_uq16 iovss sg13_hv_nmos ad=1.408p pd=5.04u as=2.596p ps=5.58u w=4.4u l=0.6u
X10 iovss gate pad_uq12 iovss sg13_hv_nmos ad=1.408p pd=5.04u as=2.596p ps=5.58u w=4.4u l=0.6u
X11 iovss gate pad_uq3 iovss sg13_hv_nmos ad=1.408p pd=5.04u as=2.596p ps=5.58u w=4.4u l=0.6u
X12 iovss gate pad_uq18 iovss sg13_hv_nmos ad=1.408p pd=5.04u as=2.596p ps=5.58u w=4.4u l=0.6u
X13 pad_uq6 gate iovss iovss sg13_hv_nmos ad=2.596p pd=5.58u as=1.408p ps=5.04u w=4.4u l=0.6u
X14 pad gate iovss iovss sg13_hv_nmos ad=2.596p pd=5.58u as=1.408p ps=5.04u w=4.4u l=0.6u
X15 iovss gate pad_uq5 iovss sg13_hv_nmos ad=1.408p pd=5.04u as=2.596p ps=5.58u w=4.4u l=0.6u
X16 iovss gate pad_uq20 iovss sg13_hv_nmos ad=1.408p pd=5.04u as=2.596p ps=5.58u w=4.4u l=0.6u
X17 pad_uq14 gate iovss iovss sg13_hv_nmos ad=2.596p pd=5.58u as=1.408p ps=5.04u w=4.4u l=0.6u
X18 pad_uq20 gate iovss iovss sg13_hv_nmos ad=2.596p pd=5.58u as=2.068p ps=9.74u w=4.4u l=0.6u
X19 pad_uq10 gate iovss iovss sg13_hv_nmos ad=2.596p pd=5.58u as=1.408p ps=5.04u w=4.4u l=0.6u
X20 iovss gate pad_uq9 iovss sg13_hv_nmos ad=1.408p pd=5.04u as=2.596p ps=5.58u w=4.4u l=0.6u
X21 pad_uq16 gate iovss iovss sg13_hv_nmos ad=2.596p pd=5.58u as=1.408p ps=5.04u w=4.4u l=0.6u
X22 iovss gate pad_uq8 iovss sg13_hv_nmos ad=1.408p pd=5.04u as=2.596p ps=5.58u w=4.4u l=0.6u
X23 iovss gate pad_uq6 iovss sg13_hv_nmos ad=1.408p pd=5.04u as=2.596p ps=5.58u w=4.4u l=0.6u
X24 iovss gate pad_uq14 iovss sg13_hv_nmos ad=1.408p pd=5.04u as=2.596p ps=5.58u w=4.4u l=0.6u
X25 pad_uq11 gate iovss iovss sg13_hv_nmos ad=2.596p pd=5.58u as=1.408p ps=5.04u w=4.4u l=0.6u
X26 iovss gate pad_uq2 iovss sg13_hv_nmos ad=1.408p pd=5.04u as=2.596p ps=5.58u w=4.4u l=0.6u
X27 iovss gate pad_uq10 iovss sg13_hv_nmos ad=1.408p pd=5.04u as=2.596p ps=5.58u w=4.4u l=0.6u
X28 pad_uq13 gate iovss iovss sg13_hv_nmos ad=2.596p pd=5.58u as=1.408p ps=5.04u w=4.4u l=0.6u
X29 pad_uq8 gate iovss iovss sg13_hv_nmos ad=2.596p pd=5.58u as=1.408p ps=5.04u w=4.4u l=0.6u
X30 pad gate iovss iovss sg13_hv_nmos ad=2.596p pd=5.58u as=1.408p ps=5.04u w=4.4u l=0.6u
X31 iovss gate pad_uq17 iovss sg13_hv_nmos ad=1.408p pd=5.04u as=2.596p ps=5.58u w=4.4u l=0.6u
X32 iovss gate pad_uq11 iovss sg13_hv_nmos ad=1.408p pd=5.04u as=2.596p ps=5.58u w=4.4u l=0.6u
X33 iovss gate pad_uq13 iovss sg13_hv_nmos ad=1.408p pd=5.04u as=2.596p ps=5.58u w=4.4u l=0.6u
X34 iovss gate pad_uq7 iovss sg13_hv_nmos ad=1.408p pd=5.04u as=2.596p ps=5.58u w=4.4u l=0.6u
X35 pad_uq1 gate iovss iovss sg13_hv_nmos ad=2.596p pd=5.58u as=1.408p ps=5.04u w=4.4u l=0.6u
X36 pad_uq1 gate iovss iovss sg13_hv_nmos ad=2.596p pd=5.58u as=1.408p ps=5.04u w=4.4u l=0.6u
X37 iovss gate pad_uq4 iovss sg13_hv_nmos ad=1.408p pd=5.04u as=2.596p ps=5.58u w=4.4u l=0.6u
X38 iovss gate pad_uq19 iovss sg13_hv_nmos ad=1.408p pd=5.04u as=2.596p ps=5.58u w=4.4u l=0.6u
X39 iovss gate pad_uq5 iovss sg13_hv_nmos ad=1.408p pd=5.04u as=2.596p ps=5.58u w=4.4u l=0.6u
X40 iovss gate pad_uq15 iovss sg13_hv_nmos ad=1.408p pd=5.04u as=2.596p ps=5.58u w=4.4u l=0.6u
X41 pad_uq3 gate iovss iovss sg13_hv_nmos ad=2.596p pd=5.58u as=1.408p ps=5.04u w=4.4u l=0.6u
X42 pad_uq15 gate iovss iovss sg13_hv_nmos ad=2.596p pd=5.58u as=1.408p ps=5.04u w=4.4u l=0.6u
X43 pad_uq14 gate iovss iovss sg13_hv_nmos ad=2.596p pd=5.58u as=1.408p ps=5.04u w=4.4u l=0.6u
X44 pad_uq9 gate iovss iovss sg13_hv_nmos ad=2.596p pd=5.58u as=1.408p ps=5.04u w=4.4u l=0.6u
X45 iovss gate pad_uq18 iovss sg13_hv_nmos ad=1.408p pd=5.04u as=2.596p ps=5.58u w=4.4u l=0.6u
X46 pad_uq4 gate iovss iovss sg13_hv_nmos ad=2.596p pd=5.58u as=1.408p ps=5.04u w=4.4u l=0.6u
X47 iovss gate pad_uq3 iovss sg13_hv_nmos ad=1.408p pd=5.04u as=2.596p ps=5.58u w=4.4u l=0.6u
X48 iovss gate pad_uq9 iovss sg13_hv_nmos ad=1.408p pd=5.04u as=2.596p ps=5.58u w=4.4u l=0.6u
X49 pad_uq6 gate iovss iovss sg13_hv_nmos ad=2.596p pd=5.58u as=1.408p ps=5.04u w=4.4u l=0.6u
X50 pad_uq18 gate iovss iovss sg13_hv_nmos ad=2.596p pd=5.58u as=1.408p ps=5.04u w=4.4u l=0.6u
X51 pad_uq12 gate iovss iovss sg13_hv_nmos ad=2.596p pd=5.58u as=1.408p ps=5.04u w=4.4u l=0.6u
X52 pad_uq8 gate iovss iovss sg13_hv_nmos ad=2.596p pd=5.58u as=1.408p ps=5.04u w=4.4u l=0.6u
X53 iovss gate pad_uq5 iovss sg13_hv_nmos ad=1.408p pd=5.04u as=2.596p ps=5.58u w=4.4u l=0.6u
X54 iovss gate pad_uq6 iovss sg13_hv_nmos ad=1.408p pd=5.04u as=2.596p ps=5.58u w=4.4u l=0.6u
X55 iovss gate pad iovss sg13_hv_nmos ad=1.408p pd=5.04u as=2.596p ps=5.58u w=4.4u l=0.6u
X56 iovss gate pad_uq1 iovss sg13_hv_nmos ad=1.408p pd=5.04u as=2.596p ps=5.58u w=4.4u l=0.6u
X57 pad_uq19 gate iovss iovss sg13_hv_nmos ad=2.596p pd=5.58u as=1.408p ps=5.04u w=4.4u l=0.6u
X58 pad_uq5 gate iovss iovss sg13_hv_nmos ad=2.596p pd=5.58u as=1.408p ps=5.04u w=4.4u l=0.6u
X59 pad_uq9 gate iovss iovss sg13_hv_nmos ad=2.596p pd=5.58u as=1.408p ps=5.04u w=4.4u l=0.6u
X60 iovss gate pad_uq8 iovss sg13_hv_nmos ad=1.408p pd=5.04u as=2.596p ps=5.58u w=4.4u l=0.6u
X61 pad_uq11 gate iovss iovss sg13_hv_nmos ad=2.596p pd=5.58u as=1.408p ps=5.04u w=4.4u l=0.6u
X62 iovss gate pad_uq14 iovss sg13_hv_nmos ad=1.408p pd=5.04u as=2.596p ps=5.58u w=4.4u l=0.6u
X63 pad_uq2 gate iovss iovss sg13_hv_nmos ad=2.596p pd=5.58u as=1.408p ps=5.04u w=4.4u l=0.6u
X64 iovss gate pad_uq10 iovss sg13_hv_nmos ad=1.408p pd=5.04u as=2.596p ps=5.58u w=4.4u l=0.6u
X65 iovss gate pad_uq14 iovss sg13_hv_nmos ad=1.408p pd=5.04u as=2.596p ps=5.58u w=4.4u l=0.6u
X66 iovss gate pad_uq17 iovss sg13_hv_nmos ad=1.408p pd=5.04u as=2.596p ps=5.58u w=4.4u l=0.6u
X67 pad_uq17 gate iovss iovss sg13_hv_nmos ad=2.596p pd=5.58u as=1.408p ps=5.04u w=4.4u l=0.6u
X68 pad_uq0 gate iovss iovss sg13_hv_nmos ad=3.256p pd=10.28u as=1.408p ps=5.04u w=4.4u l=0.6u
X69 pad_uq7 gate iovss iovss sg13_hv_nmos ad=2.596p pd=5.58u as=1.408p ps=5.04u w=4.4u l=0.6u
X70 pad_uq18 gate iovss iovss sg13_hv_nmos ad=2.596p pd=5.58u as=1.408p ps=5.04u w=4.4u l=0.6u
X71 pad_uq5 gate iovss iovss sg13_hv_nmos ad=2.596p pd=5.58u as=1.408p ps=5.04u w=4.4u l=0.6u
X72 iovss gate pad_uq4 iovss sg13_hv_nmos ad=1.408p pd=5.04u as=2.596p ps=5.58u w=4.4u l=0.6u
X73 pad_uq1 gate iovss iovss sg13_hv_nmos ad=2.596p pd=5.58u as=1.408p ps=5.04u w=4.4u l=0.6u
X74 pad_uq13 gate iovss iovss sg13_hv_nmos ad=2.596p pd=5.58u as=1.408p ps=5.04u w=4.4u l=0.6u
X75 iovss gate pad_uq18 iovss sg13_hv_nmos ad=1.408p pd=5.04u as=2.596p ps=5.58u w=4.4u l=0.6u
X76 pad_uq3 gate iovss iovss sg13_hv_nmos ad=2.596p pd=5.58u as=1.408p ps=5.04u w=4.4u l=0.6u
X77 iovss gate pad_uq2 iovss sg13_hv_nmos ad=1.408p pd=5.04u as=2.596p ps=5.58u w=4.4u l=0.6u
X78 pad_uq14 gate iovss iovss sg13_hv_nmos ad=2.596p pd=5.58u as=1.408p ps=5.04u w=4.4u l=0.6u
X79 pad_uq6 gate iovss iovss sg13_hv_nmos ad=2.596p pd=5.58u as=1.408p ps=5.04u w=4.4u l=0.6u
X80 iovss gate pad_uq20 iovss sg13_hv_nmos ad=1.408p pd=5.04u as=2.596p ps=5.58u w=4.4u l=0.6u
X81 iovss gate pad_uq1 iovss sg13_hv_nmos ad=1.408p pd=5.04u as=2.596p ps=5.58u w=4.4u l=0.6u
X82 pad_uq20 gate iovss iovss sg13_hv_nmos ad=2.596p pd=5.58u as=2.068p ps=9.74u w=4.4u l=0.6u
X83 pad_uq10 gate iovss iovss sg13_hv_nmos ad=2.596p pd=5.58u as=1.408p ps=5.04u w=4.4u l=0.6u
X84 iovss gate pad_uq9 iovss sg13_hv_nmos ad=1.408p pd=5.04u as=2.596p ps=5.58u w=4.4u l=0.6u
X85 pad_uq16 gate iovss iovss sg13_hv_nmos ad=2.596p pd=5.58u as=1.408p ps=5.04u w=4.4u l=0.6u
X86 pad_uq12 gate iovss iovss sg13_hv_nmos ad=2.596p pd=5.58u as=1.408p ps=5.04u w=4.4u l=0.6u
X87 pad_uq19 gate iovss iovss sg13_hv_nmos ad=2.596p pd=5.58u as=1.408p ps=5.04u w=4.4u l=0.6u
X88 pad_uq18 gate iovss iovss sg13_hv_nmos ad=2.596p pd=5.58u as=1.408p ps=5.04u w=4.4u l=0.6u
X89 iovss gate pad_uq10 iovss sg13_hv_nmos ad=1.408p pd=5.04u as=2.596p ps=5.58u w=4.4u l=0.6u
X90 pad_uq8 gate iovss iovss sg13_hv_nmos ad=2.596p pd=5.58u as=1.408p ps=5.04u w=4.4u l=0.6u
X91 iovss gate pad_uq16 iovss sg13_hv_nmos ad=1.408p pd=5.04u as=2.596p ps=5.58u w=4.4u l=0.6u
X92 iovss gate pad iovss sg13_hv_nmos ad=1.408p pd=5.04u as=2.596p ps=5.58u w=4.4u l=0.6u
X93 iovss gate pad_uq12 iovss sg13_hv_nmos ad=1.408p pd=5.04u as=2.596p ps=5.58u w=4.4u l=0.6u
X94 iovss gate pad_uq3 iovss sg13_hv_nmos ad=1.408p pd=5.04u as=2.596p ps=5.58u w=4.4u l=0.6u
X95 pad_uq2 gate iovss iovss sg13_hv_nmos ad=2.596p pd=5.58u as=1.408p ps=5.04u w=4.4u l=0.6u
X96 pad gate iovss iovss sg13_hv_nmos ad=2.596p pd=5.58u as=1.408p ps=5.04u w=4.4u l=0.6u
X97 pad_uq2 gate iovss iovss sg13_hv_nmos ad=2.596p pd=5.58u as=1.408p ps=5.04u w=4.4u l=0.6u
X98 iovss gate pad_uq13 iovss sg13_hv_nmos ad=1.408p pd=5.04u as=2.596p ps=5.58u w=4.4u l=0.6u
X99 iovss gate pad_uq11 iovss sg13_hv_nmos ad=1.408p pd=5.04u as=2.596p ps=5.58u w=4.4u l=0.6u
X100 iovss gate pad_uq19 iovss sg13_hv_nmos ad=1.408p pd=5.04u as=2.596p ps=5.58u w=4.4u l=0.6u
X101 iovss gate pad_uq6 iovss sg13_hv_nmos ad=1.408p pd=5.04u as=2.596p ps=5.58u w=4.4u l=0.6u
X102 pad_uq15 gate iovss iovss sg13_hv_nmos ad=2.596p pd=5.58u as=1.408p ps=5.04u w=4.4u l=0.6u
X103 iovss gate pad_uq15 iovss sg13_hv_nmos ad=1.408p pd=5.04u as=2.596p ps=5.58u w=4.4u l=0.6u
X104 iovss gate pad_uq2 iovss sg13_hv_nmos ad=1.408p pd=5.04u as=2.596p ps=5.58u w=4.4u l=0.6u
X105 iovss gate pad_uq17 iovss sg13_hv_nmos ad=1.408p pd=5.04u as=2.596p ps=5.58u w=4.4u l=0.6u
X106 pad_uq10 gate iovss iovss sg13_hv_nmos ad=2.596p pd=5.58u as=1.408p ps=5.04u w=4.4u l=0.6u
X107 pad_uq15 gate iovss iovss sg13_hv_nmos ad=2.596p pd=5.58u as=1.408p ps=5.04u w=4.4u l=0.6u
X108 iovss gate pad_uq19 iovss sg13_hv_nmos ad=1.408p pd=5.04u as=2.596p ps=5.58u w=4.4u l=0.6u
X109 pad_uq17 gate iovss iovss sg13_hv_nmos ad=2.596p pd=5.58u as=1.408p ps=5.04u w=4.4u l=0.6u
X110 pad_uq13 gate iovss iovss sg13_hv_nmos ad=2.596p pd=5.58u as=1.408p ps=5.04u w=4.4u l=0.6u
X111 pad_uq7 gate iovss iovss sg13_hv_nmos ad=2.596p pd=5.58u as=1.408p ps=5.04u w=4.4u l=0.6u
X112 iovss gate pad_uq3 iovss sg13_hv_nmos ad=1.408p pd=5.04u as=2.596p ps=5.58u w=4.4u l=0.6u
X113 iovss gate pad_uq11 iovss sg13_hv_nmos ad=1.408p pd=5.04u as=2.596p ps=5.58u w=4.4u l=0.6u
X114 pad_uq6 gate iovss iovss sg13_hv_nmos ad=2.596p pd=5.58u as=1.408p ps=5.04u w=4.4u l=0.6u
X115 iovss gate dantenna l=0.48u w=0.48u
X116 iovss gate pad_uq7 iovss sg13_hv_nmos ad=1.408p pd=5.04u as=2.596p ps=5.58u w=4.4u l=0.6u
X117 iovss gate pad_uq5 iovss sg13_hv_nmos ad=1.408p pd=5.04u as=2.596p ps=5.58u w=4.4u l=0.6u
X118 iovss gate pad_uq1 iovss sg13_hv_nmos ad=1.408p pd=5.04u as=2.596p ps=5.58u w=4.4u l=0.6u
X119 iovss gate pad_uq8 iovss sg13_hv_nmos ad=1.408p pd=5.04u as=2.596p ps=5.58u w=4.4u l=0.6u
X120 pad_uq11 gate iovss iovss sg13_hv_nmos ad=2.596p pd=5.58u as=1.408p ps=5.04u w=4.4u l=0.6u
X121 iovss gate pad_uq14 iovss sg13_hv_nmos ad=1.408p pd=5.04u as=2.596p ps=5.58u w=4.4u l=0.6u
X122 iovss gate pad_uq7 iovss sg13_hv_nmos ad=1.408p pd=5.04u as=2.596p ps=5.58u w=4.4u l=0.6u
X123 iovss gate pad_uq16 iovss sg13_hv_nmos ad=1.408p pd=5.04u as=2.596p ps=5.58u w=4.4u l=0.6u
X124 pad_uq4 gate iovss iovss sg13_hv_nmos ad=2.596p pd=5.58u as=1.408p ps=5.04u w=4.4u l=0.6u
X125 iovss gate pad_uq10 iovss sg13_hv_nmos ad=1.408p pd=5.04u as=2.596p ps=5.58u w=4.4u l=0.6u
X126 pad_uq11 gate iovss iovss sg13_hv_nmos ad=2.596p pd=5.58u as=1.408p ps=5.04u w=4.4u l=0.6u
X127 iovss gate pad_uq12 iovss sg13_hv_nmos ad=1.408p pd=5.04u as=2.596p ps=5.58u w=4.4u l=0.6u
X128 iovss gate pad_uq15 iovss sg13_hv_nmos ad=1.408p pd=5.04u as=2.596p ps=5.58u w=4.4u l=0.6u
X129 pad_uq0 gate iovss iovss sg13_hv_nmos ad=3.256p pd=10.28u as=1.408p ps=5.04u w=4.4u l=0.6u
X130 pad_uq1 gate iovss iovss sg13_hv_nmos ad=2.596p pd=5.58u as=1.408p ps=5.04u w=4.4u l=0.6u
X131 pad_uq19 gate iovss iovss sg13_hv_nmos ad=2.596p pd=5.58u as=1.408p ps=5.04u w=4.4u l=0.6u
X132 iovss gate pad_uq4 iovss sg13_hv_nmos ad=1.408p pd=5.04u as=2.596p ps=5.58u w=4.4u l=0.6u
X133 pad_uq9 gate iovss iovss sg13_hv_nmos ad=2.596p pd=5.58u as=1.408p ps=5.04u w=4.4u l=0.6u
X134 iovss gate pad_uq6 iovss sg13_hv_nmos ad=1.408p pd=5.04u as=2.596p ps=5.58u w=4.4u l=0.6u
X135 iovss gate pad_uq8 iovss sg13_hv_nmos ad=1.408p pd=5.04u as=2.596p ps=5.58u w=4.4u l=0.6u
X136 pad_uq3 gate iovss iovss sg13_hv_nmos ad=2.596p pd=5.58u as=1.408p ps=5.04u w=4.4u l=0.6u
X137 iovss gate pad_uq2 iovss sg13_hv_nmos ad=1.408p pd=5.04u as=2.596p ps=5.58u w=4.4u l=0.6u
X138 pad_uq7 gate iovss iovss sg13_hv_nmos ad=2.596p pd=5.58u as=1.408p ps=5.04u w=4.4u l=0.6u
X139 iovss gate pad_uq16 iovss sg13_hv_nmos ad=1.408p pd=5.04u as=2.596p ps=5.58u w=4.4u l=0.6u
X140 pad_uq20 gate iovss iovss sg13_hv_nmos ad=2.596p pd=5.58u as=2.068p ps=9.74u w=4.4u l=0.6u
X141 iovss gate pad_uq9 iovss sg13_hv_nmos ad=1.408p pd=5.04u as=2.596p ps=5.58u w=4.4u l=0.6u
X142 pad_uq12 gate iovss iovss sg13_hv_nmos ad=2.596p pd=5.58u as=1.408p ps=5.04u w=4.4u l=0.6u
X143 pad_uq18 gate iovss iovss sg13_hv_nmos ad=2.596p pd=5.58u as=1.408p ps=5.04u w=4.4u l=0.6u
X144 iovss gate pad_uq11 iovss sg13_hv_nmos ad=1.408p pd=5.04u as=2.596p ps=5.58u w=4.4u l=0.6u
X145 pad_uq8 gate iovss iovss sg13_hv_nmos ad=2.596p pd=5.58u as=1.408p ps=5.04u w=4.4u l=0.6u
X146 pad_uq0 gate iovss iovss sg13_hv_nmos ad=3.256p pd=10.28u as=1.408p ps=5.04u w=4.4u l=0.6u
X147 iovss gate pad_uq7 iovss sg13_hv_nmos ad=1.408p pd=5.04u as=2.596p ps=5.58u w=4.4u l=0.6u
X148 pad_uq5 gate iovss iovss sg13_hv_nmos ad=2.596p pd=5.58u as=1.408p ps=5.04u w=4.4u l=0.6u
X149 iovss gate pad_uq4 iovss sg13_hv_nmos ad=1.408p pd=5.04u as=2.596p ps=5.58u w=4.4u l=0.6u
X150 iovss gate pad iovss sg13_hv_nmos ad=1.408p pd=5.04u as=2.596p ps=5.58u w=4.4u l=0.6u
X151 iovss gate pad_uq18 iovss sg13_hv_nmos ad=1.408p pd=5.04u as=2.596p ps=5.58u w=4.4u l=0.6u
X152 iovss gate pad_uq20 iovss sg13_hv_nmos ad=1.408p pd=5.04u as=2.596p ps=5.58u w=4.4u l=0.6u
X153 pad_uq14 gate iovss iovss sg13_hv_nmos ad=2.596p pd=5.58u as=1.408p ps=5.04u w=4.4u l=0.6u
X154 pad_uq2 gate iovss iovss sg13_hv_nmos ad=2.596p pd=5.58u as=1.408p ps=5.04u w=4.4u l=0.6u
X155 pad_uq20 gate iovss iovss sg13_hv_nmos ad=2.596p pd=5.58u as=2.068p ps=9.74u w=4.4u l=0.6u
X156 pad_uq10 gate iovss iovss sg13_hv_nmos ad=2.596p pd=5.58u as=1.408p ps=5.04u w=4.4u l=0.6u
X157 pad_uq3 gate iovss iovss sg13_hv_nmos ad=2.596p pd=5.58u as=1.408p ps=5.04u w=4.4u l=0.6u
X158 pad_uq4 gate iovss iovss sg13_hv_nmos ad=2.596p pd=5.58u as=1.408p ps=5.04u w=4.4u l=0.6u
X159 pad_uq16 gate iovss iovss sg13_hv_nmos ad=2.596p pd=5.58u as=1.408p ps=5.04u w=4.4u l=0.6u
X160 iovss gate pad_uq12 iovss sg13_hv_nmos ad=1.408p pd=5.04u as=2.596p ps=5.58u w=4.4u l=0.6u
X161 iovss gate pad_uq17 iovss sg13_hv_nmos ad=1.408p pd=5.04u as=2.596p ps=5.58u w=4.4u l=0.6u
X162 pad_uq16 gate iovss iovss sg13_hv_nmos ad=2.596p pd=5.58u as=1.408p ps=5.04u w=4.4u l=0.6u
X163 pad_uq17 gate iovss iovss sg13_hv_nmos ad=2.596p pd=5.58u as=1.408p ps=5.04u w=4.4u l=0.6u
X164 pad_uq7 gate iovss iovss sg13_hv_nmos ad=2.596p pd=5.58u as=1.408p ps=5.04u w=4.4u l=0.6u
X165 pad_uq19 gate iovss iovss sg13_hv_nmos ad=2.596p pd=5.58u as=1.408p ps=5.04u w=4.4u l=0.6u
X166 iovss gate pad_uq20 iovss sg13_hv_nmos ad=1.408p pd=5.04u as=2.596p ps=5.58u w=4.4u l=0.6u
X167 pad_uq13 gate iovss iovss sg13_hv_nmos ad=2.596p pd=5.58u as=1.408p ps=5.04u w=4.4u l=0.6u
X168 pad_uq9 gate iovss iovss sg13_hv_nmos ad=2.596p pd=5.58u as=1.408p ps=5.04u w=4.4u l=0.6u
X169 pad gate iovss iovss sg13_hv_nmos ad=2.596p pd=5.58u as=1.408p ps=5.04u w=4.4u l=0.6u
X170 iovss gate pad iovss sg13_hv_nmos ad=1.408p pd=5.04u as=2.596p ps=5.58u w=4.4u l=0.6u
X171 pad_uq4 gate iovss iovss sg13_hv_nmos ad=2.596p pd=5.58u as=1.408p ps=5.04u w=4.4u l=0.6u
X172 iovss gate pad_uq13 iovss sg13_hv_nmos ad=1.408p pd=5.04u as=2.596p ps=5.58u w=4.4u l=0.6u
.ends

.subckt sg13cmos5l_RCClampInverter supply iovss in out
X0 iovss in iovss iovss sg13_hv_nmos ad=1.71p pd=9.38u as=0.10408n ps=0.84352m w=9u l=9.5u
X1 out in supply supply sg13_hv_pmos ad=1.33p pd=7.38u as=1.33p ps=7.38u w=7u l=0.5u
X2 iovss in out iovss sg13_hv_nmos ad=1.71p pd=9.38u as=1.71p ps=9.38u w=9u l=0.5u
X3 out in supply supply sg13_hv_pmos ad=1.33p pd=7.38u as=2.38p ps=14.68u w=7u l=0.5u
X4 out in supply supply sg13_hv_pmos ad=1.33p pd=7.38u as=1.33p ps=7.38u w=7u l=0.5u
X5 supply in out supply sg13_hv_pmos ad=1.33p pd=7.38u as=1.33p ps=7.38u w=7u l=0.5u
X6 supply in out supply sg13_hv_pmos ad=1.33p pd=7.38u as=1.33p ps=7.38u w=7u l=0.5u
X7 out in iovss iovss sg13_hv_nmos ad=1.71p pd=9.38u as=1.71p ps=9.38u w=9u l=0.5u
X8 supply in out supply sg13_hv_pmos ad=1.33p pd=7.38u as=1.33p ps=7.38u w=7u l=0.5u
X9 supply in out supply sg13_hv_pmos ad=1.33p pd=7.38u as=1.33p ps=7.38u w=7u l=0.5u
X10 supply in out supply sg13_hv_pmos ad=1.33p pd=7.38u as=1.33p ps=7.38u w=7u l=0.5u
X11 out in supply supply sg13_hv_pmos ad=1.33p pd=7.38u as=1.33p ps=7.38u w=7u l=0.5u
X12 out in supply supply sg13_hv_pmos ad=1.33p pd=7.38u as=1.33p ps=7.38u w=7u l=0.5u
X13 supply in out supply sg13_hv_pmos ad=1.33p pd=7.38u as=1.33p ps=7.38u w=7u l=0.5u
X14 supply in out supply sg13_hv_pmos ad=1.33p pd=7.38u as=1.33p ps=7.38u w=7u l=0.5u
X15 iovss in iovss iovss sg13_hv_nmos ad=3.06p pd=18.68u as=0 ps=0 w=9u l=9.5u
X16 out in iovss iovss sg13_hv_nmos ad=1.71p pd=9.38u as=1.71p ps=9.38u w=9u l=0.5u
X17 iovss in out iovss sg13_hv_nmos ad=3.06p pd=18.68u as=1.71p ps=9.38u w=9u l=0.5u
X18 iovss in iovss iovss sg13_hv_nmos ad=1.71p pd=9.38u as=0 ps=0 w=9u l=9.5u
X19 iovss in iovss iovss sg13_hv_nmos ad=3.06p pd=18.68u as=0 ps=0 w=9u l=9.5u
X20 iovss in iovss iovss sg13_hv_nmos ad=1.71p pd=9.38u as=0 ps=0 w=9u l=9.5u
X21 iovss in iovss iovss sg13_hv_nmos ad=1.71p pd=9.38u as=0 ps=0 w=9u l=9.5u
X22 supply in out supply sg13_hv_pmos ad=1.33p pd=7.38u as=1.33p ps=7.38u w=7u l=0.5u
X23 out in supply supply sg13_hv_pmos ad=1.33p pd=7.38u as=1.33p ps=7.38u w=7u l=0.5u
X24 out in supply supply sg13_hv_pmos ad=1.33p pd=7.38u as=1.33p ps=7.38u w=7u l=0.5u
X25 iovss in iovss iovss sg13_hv_nmos ad=1.71p pd=9.38u as=0 ps=0 w=9u l=9.5u
X26 out in supply supply sg13_hv_pmos ad=1.33p pd=7.38u as=1.33p ps=7.38u w=7u l=0.5u
X27 iovss in out iovss sg13_hv_nmos ad=1.71p pd=9.38u as=1.71p ps=9.38u w=9u l=0.5u
X28 out in supply supply sg13_hv_pmos ad=1.33p pd=7.38u as=1.33p ps=7.38u w=7u l=0.5u
X29 supply in out supply sg13_hv_pmos ad=1.33p pd=7.38u as=1.33p ps=7.38u w=7u l=0.5u
X30 out in supply supply sg13_hv_pmos ad=1.33p pd=7.38u as=1.33p ps=7.38u w=7u l=0.5u
X31 iovss in iovss iovss sg13_hv_nmos ad=1.71p pd=9.38u as=0 ps=0 w=9u l=9.5u
X32 out in supply supply sg13_hv_pmos ad=1.33p pd=7.38u as=1.33p ps=7.38u w=7u l=0.5u
X33 supply in out supply sg13_hv_pmos ad=1.33p pd=7.38u as=1.33p ps=7.38u w=7u l=0.5u
X34 out in iovss iovss sg13_hv_nmos ad=1.71p pd=9.38u as=1.71p ps=9.38u w=9u l=0.5u
X35 supply in out supply sg13_hv_pmos ad=1.33p pd=7.38u as=1.33p ps=7.38u w=7u l=0.5u
X36 out in supply supply sg13_hv_pmos ad=1.33p pd=7.38u as=1.33p ps=7.38u w=7u l=0.5u
X37 out in supply supply sg13_hv_pmos ad=1.33p pd=7.38u as=1.33p ps=7.38u w=7u l=0.5u
X38 out in supply supply sg13_hv_pmos ad=1.33p pd=7.38u as=1.33p ps=7.38u w=7u l=0.5u
X39 supply in out supply sg13_hv_pmos ad=1.33p pd=7.38u as=1.33p ps=7.38u w=7u l=0.5u
X40 out in supply supply sg13_hv_pmos ad=1.33p pd=7.38u as=1.33p ps=7.38u w=7u l=0.5u
X41 supply in out supply sg13_hv_pmos ad=1.33p pd=7.38u as=1.33p ps=7.38u w=7u l=0.5u
X42 iovss in iovss iovss sg13_hv_nmos ad=1.71p pd=9.38u as=0 ps=0 w=9u l=9.5u
X43 supply in out supply sg13_hv_pmos ad=1.33p pd=7.38u as=1.33p ps=7.38u w=7u l=0.5u
X44 out in supply supply sg13_hv_pmos ad=1.33p pd=7.38u as=1.33p ps=7.38u w=7u l=0.5u
X45 iovss in out iovss sg13_hv_nmos ad=1.71p pd=9.38u as=1.71p ps=9.38u w=9u l=0.5u
X46 iovss in iovss iovss sg13_hv_nmos ad=1.71p pd=9.38u as=0 ps=0 w=9u l=9.5u
X47 out in supply supply sg13_hv_pmos ad=1.33p pd=7.38u as=1.33p ps=7.38u w=7u l=0.5u
X48 supply in out supply sg13_hv_pmos ad=2.38p pd=14.68u as=1.33p ps=7.38u w=7u l=0.5u
X49 out in iovss iovss sg13_hv_nmos ad=1.71p pd=9.38u as=1.71p ps=9.38u w=9u l=0.5u
X50 supply in out supply sg13_hv_pmos ad=1.33p pd=7.38u as=1.33p ps=7.38u w=7u l=0.5u
X51 out in supply supply sg13_hv_pmos ad=1.33p pd=7.38u as=1.33p ps=7.38u w=7u l=0.5u
X52 out in supply supply sg13_hv_pmos ad=1.33p pd=7.38u as=1.33p ps=7.38u w=7u l=0.5u
X53 supply in out supply sg13_hv_pmos ad=1.33p pd=7.38u as=1.33p ps=7.38u w=7u l=0.5u
X54 iovss in iovss iovss sg13_hv_nmos ad=1.71p pd=9.38u as=0 ps=0 w=9u l=9.5u
X55 out in supply supply sg13_hv_pmos ad=1.33p pd=7.38u as=1.33p ps=7.38u w=7u l=0.5u
X56 supply in out supply sg13_hv_pmos ad=1.33p pd=7.38u as=1.33p ps=7.38u w=7u l=0.5u
X57 supply in out supply sg13_hv_pmos ad=1.33p pd=7.38u as=1.33p ps=7.38u w=7u l=0.5u
X58 supply in out supply sg13_hv_pmos ad=1.33p pd=7.38u as=1.33p ps=7.38u w=7u l=0.5u
X59 out in supply supply sg13_hv_pmos ad=1.33p pd=7.38u as=1.33p ps=7.38u w=7u l=0.5u
X60 supply in out supply sg13_hv_pmos ad=1.33p pd=7.38u as=1.33p ps=7.38u w=7u l=0.5u
X61 out in iovss iovss sg13_hv_nmos ad=1.71p pd=9.38u as=1.71p ps=9.38u w=9u l=0.5u
X62 out in supply supply sg13_hv_pmos ad=1.33p pd=7.38u as=1.33p ps=7.38u w=7u l=0.5u
X63 iovss in out iovss sg13_hv_nmos ad=1.71p pd=9.38u as=1.71p ps=9.38u w=9u l=0.5u
X64 supply in out supply sg13_hv_pmos ad=1.33p pd=7.38u as=1.33p ps=7.38u w=7u l=0.5u
X65 supply in out supply sg13_hv_pmos ad=1.33p pd=7.38u as=1.33p ps=7.38u w=7u l=0.5u
X66 out in supply supply sg13_hv_pmos ad=1.33p pd=7.38u as=1.33p ps=7.38u w=7u l=0.5u
X67 out in supply supply sg13_hv_pmos ad=1.33p pd=7.38u as=1.33p ps=7.38u w=7u l=0.5u
X68 iovss in iovss iovss sg13_hv_nmos ad=1.71p pd=9.38u as=0 ps=0 w=9u l=9.5u
X69 out in supply supply sg13_hv_pmos ad=1.33p pd=7.38u as=1.33p ps=7.38u w=7u l=0.5u
X70 supply in out supply sg13_hv_pmos ad=1.33p pd=7.38u as=1.33p ps=7.38u w=7u l=0.5u
X71 supply in out supply sg13_hv_pmos ad=1.33p pd=7.38u as=1.33p ps=7.38u w=7u l=0.5u
X72 iovss in out iovss sg13_hv_nmos ad=3.06p pd=18.68u as=1.71p ps=9.38u w=9u l=0.5u
X73 iovss in iovss iovss sg13_hv_nmos ad=1.71p pd=9.38u as=0 ps=0 w=9u l=9.5u
X74 iovss in iovss iovss sg13_hv_nmos ad=1.71p pd=9.38u as=0 ps=0 w=9u l=9.5u
X75 out in iovss iovss sg13_hv_nmos ad=1.71p pd=9.38u as=1.71p ps=9.38u w=9u l=0.5u
.ends

.subckt sg13cmos5l_RCClampResistor pin1 pin2 sub
X0 a_2640_4086# a_2970_0# sub rppd l=20u w=1u
X1 a_3300_4086# a_2970_0# sub rppd l=20u w=1u
X2 a_4620_4086# a_4950_0# sub rppd l=20u w=1u
X3 a_5280_4086# a_4950_0# sub rppd l=20u w=1u
X4 a_6600_4086# a_6930_0# sub rppd l=20u w=1u
X5 a_7260_4086# a_6930_0# sub rppd l=20u w=1u
X6 a_2640_4086# a_2310_0# sub rppd l=20u w=1u
X7 a_4620_4086# a_4290_0# sub rppd l=20u w=1u
X8 a_660_4086# a_990_0# sub rppd l=20u w=1u
X9 a_6600_4086# a_6270_0# sub rppd l=20u w=1u
X10 a_1980_4086# a_1650_0# sub rppd l=20u w=1u
X11 a_1980_4086# a_2310_0# sub rppd l=20u w=1u
X12 a_660_4086# a_330_0# sub rppd l=20u w=1u
X13 a_3960_4086# a_3630_0# sub rppd l=20u w=1u
X14 a_3960_4086# a_4290_0# sub rppd l=20u w=1u
X15 a_5940_4086# a_5610_0# sub rppd l=20u w=1u
X16 a_5940_4086# a_6270_0# sub rppd l=20u w=1u
X17 a_7920_4086# a_7590_0# sub rppd l=20u w=1u
X18 a_7920_4086# pin2 sub rppd l=20u w=1u
X19 a_0_4086# pin1 sub rppd l=20u w=1u
X20 a_1320_4086# a_1650_0# sub rppd l=20u w=1u
X21 a_3300_4086# a_3630_0# sub rppd l=20u w=1u
X22 a_0_4086# a_330_0# sub rppd l=20u w=1u
X23 a_5280_4086# a_5610_0# sub rppd l=20u w=1u
X24 a_7260_4086# a_7590_0# sub rppd l=20u w=1u
X25 a_1320_4086# a_990_0# sub rppd l=20u w=1u
.ends

.subckt sg13cmos5l_IOPadVdd iovss iovdd iovdd_uq0 vss w_n124_1076# vdd
Xsg13cmos5l_Clamp_N43N43D4R_0 vss vdd sg13cmos5l_RCClampInverter_0/out vdd vdd vdd
+ vdd vdd vdd vdd vdd vdd vdd vdd vdd vdd vdd vdd vdd vdd vdd vdd vdd vdd w_n124_1076#
+ sg13cmos5l_Clamp_N43N43D4R
Xsg13cmos5l_RCClampInverter_0 vdd vss sg13cmos5l_RCClampInverter_0/in sg13cmos5l_RCClampInverter_0/out
+ sg13cmos5l_RCClampInverter
Xsg13cmos5l_RCClampResistor_0 vdd sg13cmos5l_RCClampInverter_0/in vss sg13cmos5l_RCClampResistor
.ends

.subckt sg13cmos5l_IOPadIOVss iovdd vss vdd sg13cmos5l_DCNDiode_0/guard
Xsg13cmos5l_DCPDiode_0 vss iovdd vss vss sg13cmos5l_DCPDiode
Xsg13cmos5l_DCNDiode_0 vss vss sg13cmos5l_DCNDiode_0/guard vss sg13cmos5l_DCNDiode
.ends

.subckt sg13cmos5l_IOPadIOVdd iovss vdd vss iovdd
Xsg13cmos5l_Clamp_N43N43D4R_0 vss iovdd sg13cmos5l_RCClampInverter_0/out iovdd iovdd
+ iovdd iovdd iovdd iovdd iovdd iovdd iovdd iovdd iovdd iovdd iovdd iovdd iovdd iovdd
+ iovdd iovdd iovdd iovdd iovdd iovdd sg13cmos5l_Clamp_N43N43D4R
Xsg13cmos5l_RCClampInverter_0 iovdd vss sg13cmos5l_RCClampInverter_0/in sg13cmos5l_RCClampInverter_0/out
+ sg13cmos5l_RCClampInverter
Xsg13cmos5l_RCClampResistor_0 iovdd sg13cmos5l_RCClampInverter_0/in vss sg13cmos5l_RCClampResistor
.ends

.subckt pmos$4 a_68_n36# w_n62_n62# a_94_0# a_0_0#
X0 a_94_0# a_68_n36# a_0_0# w_n62_n62# sg13_lv_pmos ad=0.136p pd=1.48u as=0.136p ps=1.48u w=0.4u l=0.13u
.ends

.subckt nmos$7 a_68_n36# sub a_94_0# a_0_0#
X0 a_94_0# a_68_n36# a_0_0# sub sg13_lv_nmos ad=0.17p pd=1.68u as=0.17p ps=1.68u w=0.5u l=0.13u
.ends

.subckt nmos$5 a_68_n36# sub a_94_0# a_0_0#
X0 a_94_0# a_68_n36# a_0_0# sub sg13_lv_nmos ad=0.119p pd=1.38u as=0.119p ps=1.38u w=0.35u l=0.13u
.ends

.subckt nmos$2 a_68_n36# sub a_94_0# a_0_0#
X0 a_94_0# a_68_n36# a_0_0# sub sg13_lv_nmos ad=0.2516p pd=2.16u as=0.2516p ps=2.16u w=0.74u l=0.13u
.ends

.subckt pmos$1 a_68_n36# w_n62_n62# a_94_0# a_0_0#
X0 a_94_0# a_68_n36# a_0_0# w_n62_n62# sg13_lv_pmos ad=0.3808p pd=2.92u as=0.3808p ps=2.92u w=1.12u l=0.13u
.ends

.subckt nmos a_74_n26# sub a_0_0# a_100_10#
X0 a_100_10# a_74_n26# a_0_0# sub sg13_lv_nmos ad=0.104p pd=1.34u as=0.104p ps=1.34u w=0.2u l=0.13u
.ends

.subckt nmos$3 a_74_n26# sub a_0_0# a_100_10#
X0 a_100_10# a_74_n26# a_0_0# sub sg13_lv_nmos ad=0.104p pd=1.34u as=0.104p ps=1.34u w=0.2u l=0.13u
.ends

.subckt pmos a_68_n36# w_n62_n62# a_94_0# a_0_0#
X0 a_94_0# a_68_n36# a_0_0# w_n62_n62# sg13_lv_pmos ad=0.136p pd=1.48u as=0.136p ps=1.48u w=0.4u l=0.13u
.ends

.subckt pmos$3 a_68_n36# w_n62_n62# a_94_0# a_0_0#
X0 a_94_0# a_68_n36# a_0_0# w_n62_n62# sg13_lv_pmos ad=0.68p pd=4.68u as=0.68p ps=4.68u w=2u l=0.13u
.ends

.subckt pmos$2 a_68_n36# w_n62_n62# a_94_0# a_0_0#
X0 a_94_0# a_68_n36# a_0_0# w_n62_n62# sg13_lv_pmos ad=2.04p pd=12.68u as=2.04p ps=12.68u w=6u l=0.13u
.ends

.subckt nmos$1 a_68_n36# sub a_94_0# a_0_0#
X0 a_94_0# a_68_n36# a_0_0# sub sg13_lv_nmos ad=0.2516p pd=2.16u as=0.2516p ps=2.16u w=0.74u l=0.13u
.ends

.subckt nmos$4 a_68_n36# sub a_94_0# a_0_0#
X0 a_94_0# a_68_n36# a_0_0# sub sg13_lv_nmos ad=1.02p pd=6.68u as=1.02p ps=6.68u w=3u l=0.13u
.ends

.subckt ANALOG_FIGURE WL_4 PSL_23 PSL_12 PSL_0 PSL_28N WL_3 PSL_22 PSL_11 WL_2 PSL_10N
+ PSL_21 PSL_10 COMP19 WL_1 PSL_31 PSL_20 COMP18 COMP29 WL_0 PSL_22N PSL_30 PSL_27N
+ COMP17 COMP28 SL_19 PSL_4N SL_22N SL_24N COMP16 COMP27 SL_29 SL_18 PSL_5N PSL_30N
+ COMP15 COMP26 SL_17 SL_28 PSL_31N PSL_0N SL_26N COMP25 COMP14 SL_16 SL_27 PSL_26N
+ SL_9 PSL_13N PSL_16N a_n72108_n13206# COMP24 COMP13 SL_15 SL_26 SL_25N SL_8 PSL_17N
+ COMP9 COMP23 COMP12 SL_14 SL_25 SL_7 SL_29N COMP8 WL COMP22 COMP11 SL_13 SL_24 SL_6
+ a_n71647_n13137# COMP7 COMP21 COMP10 SL_23 SL_12 SL_5 COMP6 COMP20 COMP31 SL_22
+ SL_11 WL_19 SL_4 COMP5 COMP30 SL_10 SL_21 WL_29 WL_18 SL_3 PSL_8N SL_27N COMP4 SL_31
+ SL_20 WL_28 WL_17 PSL_9N SL_2 COMP3 SL_30 WL_27 WL_16 SL_1 VEVAL PSL_7N COMP2 PSL_21N
+ WL_26 WL_15 SL_0 PSL_12N PSL_2N COMP1 WL_25 WL_14 SL_21N PSL_3N SL_10N COMP0 SL_0N
+ WL_24 WL_13 SL_1N WL_23 WL_12 SL_12N PSL_20N PSL_25N WL_22 WL_11 SL_20N SL_3N WL_21
+ WL_10 SL_14N SL_31N SL_4N WL_31 WL_20 PSL_19N SL_2N WL_30 SL_16N SL_17N SL_30N SL_7N
+ SL_8N SL_6N SL_13N SL_19N PSL_14N PSL_9 SL_9N SL_15N PSL_15N PSL_29N VSS VDD PSL_8
+ SL_5N PSL_6N PSL_19 PSL_24N PC PSL_11N PSL_7 PSL_1N PSL_29 PSL_18 PSL_6 m2_n44135_352#
+ SL_11N WL_9 PSL_23N PSL_28 PSL_17 PSL_5 WL_8 PSL_27 PSL_16 PSL_18N SL_23N PSL_4
+ WL_7 PSL_26 PSL_15 PSL_3 SL_18N SL_28N WL_6 PSL_25 PSL_14 PSL_2 WL_5 PSL_24 PSL_13
+ PSL_1
Xnmos$5_919 VEVAL VSS m1_n44459_21079# VSS nmos$5
Xnmos$5_908 VEVAL VSS m1_n41445_18463# VSS nmos$5
Xnmos$2_1115 a_n78135_n9282# VSS a_n77674_n9213# SL_2N nmos$2
Xnmos$2_1104 WL_27 VSS a_n77988_n7894# SL_2 nmos$2
Xnmos$2_1126 a_n76169_n7905# VSS ML_27 m1_n76072_n7697# nmos$2
Xnmos$2_1159 WL_25 VSS SL_1N a_n79644_n5358# nmos$2
Xnmos$2_1137 a_n77674_n5289# VSS ML_25 m1_n77577_n5081# nmos$2
Xnmos$2_1148 WL_24 VSS SL_2N a_n78135_n4050# nmos$2
Xpmos$1_90 a_n28089_16424# VDD a_n26151_16918# a_n27618_16918# pmos$1
Xnmos_460 a_n58411_n3970# VSS a_n58558_n4050# VSS nmos
Xnmos_482 a_n58411_5186# VSS a_n58558_5405# VSS nmos
Xnmos_493 a_n61425_2570# VSS a_n61572_2789# VSS nmos
Xnmos_471 a_n59916_n2662# VSS a_n60063_n2742# VSS nmos
Xnmos$2_3040 a_n73156_23487# VSS ML_3 m1_n73059_23695# nmos$2
Xnmos$2_3062 WL_5 VSS SL_8N a_n69104_21101# nmos$2
Xnmos$2_3051 a_n68643_20871# VSS ML_5 m1_n68546_21079# nmos$2
Xnmos$2_3073 a_n70142_23487# VSS ML_3 m1_n70045_23695# nmos$2
Xnmos$2_3084 WL_4 VSS a_n68957_22190# SL_8 nmos$2
Xnmos$2_3095 WL_7 VSS SL_3N a_n76630_18485# nmos$2
Xnmos$3_451 a_n63077_15869# VSS VSS a_n62930_15650# nmos$3
Xnmos$2_2350 WL_12 VSS SL_15N a_n58558_11945# nmos$2
Xnmos$3_440 a_n64585_11945# VSS VSS a_n64438_11726# nmos$3
Xnmos$3_473 a_n57062_15869# VSS VSS a_n56915_15650# nmos$3
Xnmos$2_2383 a_n58097_15639# VSS ML_9 m1_n58000_15847# nmos$2
Xnmos$2_2372 a_n59916_14342# VSS SL_14 a_n59602_14331# nmos$2
Xnmos$2_2361 a_n58558_13253# VSS a_n58097_13023# SL_15N nmos$2
Xnmos$3_462 a_n60063_9329# VSS VSS a_n59916_9110# nmos$3
Xnmos$3_484 a_n70603_2789# VSS VSS a_n70456_2570# nmos$3
Xnmos$2_2394 WL_10 VSS a_n53901_14342# SL_18 nmos$2
Xnmos$3_495 a_n73617_5405# VSS VSS a_n73470_5186# nmos$3
Xnmos$2_1671 WL_25 VSS SL_10N a_n66090_n5358# nmos$2
Xnmos$2_1682 a_n67599_n4050# VSS a_n67138_n3981# SL_9N nmos$2
Xnmos$2_1660 WL_24 VSS a_n62930_n3970# SL_12 nmos$2
Xnmos$2_1693 a_n66090_n1434# VSS a_n65629_n1365# SL_10N nmos$2
Xpmos_2212 a_n26495_22670# VDD COMP6 VDD pmos
Xpmos_2201 a_n26151_18356# VDD VDD a_n26495_18356# pmos
Xpmos_2256 a_n38843_22190# VDD VDD a_n38990_22409# pmos
Xpmos_1511 a_n56915_22190# VDD VDD a_n57062_22409# pmos
Xpmos_1500 a_n58411_22190# VDD VDD a_n58558_22409# pmos
Xpmos_2223 a_n27274_21232# VDD VDD a_n27618_21232# pmos
Xpmos_2245 a_n35976_18485# VDD a_n35829_18266# VDD pmos
Xpmos_2234 a_n37338_16958# VDD VDD a_n37485_17177# pmos
Xpmos_2278 a_n35829_27422# VDD VDD a_n35976_27641# pmos
Xpmos_2289 a_n38843_27422# VDD VDD a_n38990_27641# pmos
Xpmos_2267 a_n35829_22190# VDD VDD a_n35976_22409# pmos
Xpmos_1544 a_n64585_21101# VDD a_n64438_20882# VDD pmos
Xpmos_1522 a_n64438_18266# VDD VDD a_n64585_18485# pmos
Xpmos_1533 a_n66090_17177# VDD a_n65943_16958# VDD pmos
Xpmos_1577 a_n62930_26114# VDD VDD a_n63077_26333# pmos
Xpmos_1566 a_n62930_22190# VDD VDD a_n63077_22409# pmos
Xpmos_1555 a_n61572_21101# VDD a_n61425_20882# VDD pmos
Xpmos_704 a_n62930_n13126# VDD VDD a_n63077_n13206# pmos
Xpmos_726 a_n61572_n10590# VDD a_n61425_n10510# VDD pmos
Xpmos_715 a_n64585_n9282# VDD a_n64438_n9202# VDD pmos
Xpmos_1588 a_n64585_27641# VDD a_n64438_27422# VDD pmos
Xpmos_1599 a_n54048_26333# VDD a_n53901_26114# VDD pmos
Xpmos_737 a_n61572_n5358# VDD a_n61425_n5278# VDD pmos
Xpmos_759 a_n65943_n3970# VDD VDD a_n66090_n4050# pmos
Xpmos_748 a_n62930_n3970# VDD VDD a_n63077_n4050# pmos
Xnmos$2_3 WL VSS PSL_29N a_n37485_n29051# nmos$2
Xnmos$5_727 VEVAL VSS m1_n62519_26311# VSS nmos$5
Xnmos$5_716 VEVAL VSS m1_n61014_23695# VSS nmos$5
Xnmos$5_705 VEVAL VSS m1_n65532_22387# VSS nmos$5
Xnmos$5_749 VEVAL VSS m1_n58000_26311# VSS nmos$5
Xnmos$5_738 VEVAL VSS m1_n54999_25003# VSS nmos$5
Xnmos_290 a_n71961_n9202# VSS a_n72108_n9282# VSS nmos
Xnmos$2_2180 WL_12 VSS SL_13N a_n61572_11945# nmos$2
Xnmos$2_2191 a_n64438_10418# VSS SL_11 a_n64124_10407# nmos$2
Xnmos$3_270 a_n72108_n1434# VSS VSS a_n71961_n1354# nmos$3
Xnmos$3_281 a_n67599_n2742# VSS VSS a_n67452_n2662# nmos$3
Xnmos$3_292 a_n60063_n13206# VSS VSS a_n59916_n13126# nmos$3
Xnmos$2_1490 a_n59602_n9213# VSS ML_28 m1_n59505_n9005# nmos$2
Xpmos_2020 a_n43365_14342# VDD VDD a_n43512_14561# pmos
Xpmos_2064 a_n42003_23717# VDD a_n41856_23498# VDD pmos
Xpmos_2053 a_n44870_23498# VDD VDD a_n45017_23717# pmos
Xpmos_2031 a_n40498_18485# VDD a_n40351_18266# VDD pmos
Xpmos_2042 a_n44870_18266# VDD VDD a_n45017_18485# pmos
Xpmos_1352 a_n69104_23717# VDD a_n68957_23498# VDD pmos
Xpmos_1330 a_n73617_22409# VDD a_n73470_22190# VDD pmos
Xpmos_2097 a_n51035_21101# VDD a_n50888_20882# VDD pmos
Xpmos_1341 a_n70456_20882# VDD VDD a_n70603_21101# pmos
Xpmos_2075 a_n49383_18266# VDD VDD a_n49530_18485# pmos
Xpmos_2086 a_n53901_16958# VDD VDD a_n54048_17177# pmos
Xpmos_501 a_n78135_n13206# VDD a_n77988_n13126# VDD pmos
Xpmos_1385 a_n81002_23498# VDD VDD a_n81149_23717# pmos
Xpmos_1396 a_n76483_20882# VDD VDD a_n76630_21101# pmos
Xpmos_1363 a_n76483_19574# VDD VDD a_n76630_19793# pmos
Xpmos_1374 a_n78135_18485# VDD a_n77988_18266# VDD pmos
Xpmos_523 a_n79644_n10590# VDD a_n79497_n10510# VDD pmos
Xpmos_512 a_n79497_n9202# VDD VDD a_n79644_n9282# pmos
Xpmos_534 a_n77988_n7894# VDD VDD a_n78135_n7974# pmos
Xpmos_578 a_n79644_173# VDD a_n79497_n46# VDD pmos
Xpmos_567 a_n78135_n1434# VDD a_n77988_n1354# VDD pmos
Xpmos_556 a_n81149_n5358# VDD a_n81002_n5278# VDD pmos
Xpmos_545 a_n76630_n5358# VDD a_n76483_n5278# VDD pmos
Xpmos_589 a_n77988_n46# VDD VDD a_n78135_173# pmos
Xnmos_1250 a_n26495_31298# VSS m1_n26796_31310# VSS nmos
Xnmos_1261 a_n28485_28520# VSS VSS m1_n28364_28345# nmos
Xnmos_1272 a_n40351_27422# VSS a_n40498_27641# VSS nmos
Xnmos$2_3809 a_n38990_4097# VSS a_n38529_3867# SL_28N nmos$2
Xnmos_1294 a_n67452_1262# VSS a_n67599_1481# VSS nmos
Xnmos_1283 a_n68957_1262# VSS a_n69104_1481# VSS nmos
Xnmos$2_708 a_n38843_n5278# VSS SL_28 a_n38529_n5289# nmos$2
Xnmos$2_719 WL_24 VSS a_n37338_n3970# SL_29 nmos$2
Xnmos$5_40 VEVAL VSS m1_n42954_n9005# VSS nmos$5
Xnmos$5_51 VEVAL VSS m1_n51985_n11621# VSS nmos$5
Xnmos$5_62 VEVAL VSS m1_n48972_n9005# VSS nmos$5
Xnmos$5_73 VEVAL VSS m1_n51985_n3773# VSS nmos$5
Xnmos$5_95 VEVAL VSS m1_n44459_n1157# VSS nmos$5
Xnmos$5_84 VEVAL VSS m1_n51985_n2465# VSS nmos$5
Xpmos$1_109 OUTP VDD m1_n26796_29872# a_n26151_29860# pmos$1
Xnmos$5_502 VEVAL VSS m1_n70045_7999# VSS nmos$5
Xnmos$5_535 VEVAL VSS m1_n76072_9307# VSS nmos$5
Xnmos$5_524 VEVAL VSS m1_n79086_7999# VSS nmos$5
Xnmos$5_513 VEVAL VSS m1_n79086_1459# VSS nmos$5
Xnmos$5_557 VEVAL VSS m1_n76072_13231# VSS nmos$5
Xnmos$5_568 VEVAL VSS m1_n70045_11923# VSS nmos$5
Xnmos$5_546 VEVAL VSS m1_n80591_10615# VSS nmos$5
Xnmos$5_579 VEVAL VSS m1_n73059_14539# VSS nmos$5
Xpmos$3_25 PC VDD ML_6 VDD pmos$3
Xpmos$3_14 PC VDD ML_19 VDD pmos$3
Xpmos_1160 a_n81149_6713# VDD a_n81002_6494# VDD pmos
Xpmos_1182 a_n76630_9329# VDD a_n76483_9110# VDD pmos
Xpmos_1193 a_n78135_9329# VDD a_n77988_9110# VDD pmos
Xpmos_1171 a_n76483_5186# VDD VDD a_n76630_5405# pmos
Xpmos_331 a_n37338_n2662# VDD VDD a_n37485_n2742# pmos
Xpmos_342 a_n37485_n2742# VDD a_n37338_n2662# VDD pmos
Xpmos_320 a_n38990_n6666# VDD a_n38843_n6586# VDD pmos
Xnmos$2_5019 WL_3 VSS SL_29N a_n37485_23717# nmos$2
Xnmos$2_5008 a_n38990_21101# VSS a_n38529_20871# SL_28N nmos$2
Xpmos_386 m2_n30953_n488# VDD m1_n28364_n1853# VDD pmos
Xpmos_375 ML_25 VDD a_n28485_n4554# VDD pmos
Xpmos_353 OUTP VDD VDD a_n28089_n6584# pmos
Xpmos_364 a_n26495_n3214# VDD COMP24 VDD pmos
Xnmos$2_4329 WL_10 VSS SL_19N a_n52543_14561# nmos$2
Xnmos$2_4318 a_n52082_14331# VSS ML_10 m1_n51985_14539# nmos$2
Xnmos$2_4307 a_n50888_13034# VSS SL_20 a_n50574_13023# nmos$2
Xpmos_397 a_n40351_n28971# VDD VDD a_n40498_n29051# pmos
Xnmos$2_3628 WL_3 VSS SL_11N a_n64585_23717# nmos$2
Xnmos_1080 a_n43365_20882# VSS a_n43512_21101# VSS nmos
Xnmos$2_3606 a_n61572_21101# VSS a_n61111_20871# SL_13N nmos$2
Xnmos$2_3617 a_n64585_21101# VSS a_n64124_20871# SL_11N nmos$2
Xnmos$2_3639 WL_5 VSS SL_12N a_n63077_21101# nmos$2
Xnmos_1091 a_n53901_16958# VSS a_n54048_17177# VSS nmos
Xnmos$2_2916 a_n69104_14561# VSS a_n68643_14331# SL_8N nmos$2
Xnmos$2_2905 WL_10 VSS SL_5N a_n73617_14561# nmos$2
Xnmos$2_2949 WL_8 VSS SL_8N a_n69104_17177# nmos$2
Xnmos$2_2938 WL_9 VSS SL_8N a_n69104_15869# nmos$2
Xnmos$2_2927 a_n70456_14342# VSS SL_7 a_n70142_14331# nmos$2
Xnmos$2_516 WL_23 VSS a_n40351_n2662# SL_27 nmos$2
Xnmos$2_505 WL_23 VSS a_n43365_n2662# SL_25 nmos$2
Xnmos$2_527 a_n46369_n7894# VSS SL_23 a_n46055_n7905# nmos$2
Xnmos$3_1040 a_n58558_1481# VSS VSS a_n58411_1262# nmos$3
Xnmos$3_1051 a_n72108_1481# VSS VSS a_n71961_1262# nmos$3
Xnmos$2_549 WL_26 VSS SL_20N a_n51035_n6666# nmos$2
Xnmos$2_538 a_n43512_n6666# VSS a_n43051_n6597# SL_25N nmos$2
Xnmos$2_4841 WL_0 VSS SL_20N a_n51035_27641# nmos$2
Xnmos$2_4852 a_n52082_26103# VSS ML_1 m1_n51985_26311# nmos$2
Xnmos$2_4830 WL_2 VSS SL_20N a_n51035_25025# nmos$2
Xnmos$5_310 VEVAL VSS m1_n67041_n9005# VSS nmos$5
Xnmos$2_4874 a_n41856_27422# VSS SL_26 a_n41542_27411# nmos$2
Xnmos$2_4885 a_n43512_26333# VSS a_n43051_26103# SL_25N nmos$2
Xnmos$2_4863 WL_2 VSS a_n40351_24806# SL_27 nmos$2
Xnmos$5_343 VEVAL VSS m1_n67041_n2465# VSS nmos$5
Xnmos$5_321 VEVAL VSS m1_n64027_n11621# VSS nmos$5
Xnmos$5_332 VEVAL VSS m1_n67041_n5081# VSS nmos$5
Xnmos$2_4896 a_n40037_26103# VSS ML_1 m1_n39940_26311# nmos$2
Xnmos$5_376 VEVAL VSS m1_n56504_4075# VSS nmos$5
Xnmos$5_365 VEVAL VSS m1_n56504_n1157# VSS nmos$5
Xnmos$5_354 VEVAL VSS m1_n56504_n3773# VSS nmos$5
Xnmos$5_387 VEVAL VSS m1_n59505_6691# VSS nmos$5
Xnmos$5_398 VEVAL VSS m1_n62519_2767# VSS nmos$5
Xpmos$1_7 a_n28089_n13774# VDD a_n26151_n13280# a_n27618_n13280# pmos$1
Xnmos$2_41 WL VSS PSL_26N a_n42003_n29051# nmos$2
Xnmos$2_30 a_n43051_n28982# VSS a_n32313_n28669# m1_n42954_n28774# nmos$2
Xnmos$2_52 WL VSS a_n46369_n28971# PSL_23 nmos$2
Xnmos$2_74 a_n43512_n13206# VSS a_n43051_n13137# SL_25N nmos$2
Xnmos$2_63 a_n52082_n28982# VSS a_n32313_n28669# m1_n51985_n28774# nmos$2
Xnmos$2_96 a_n40498_n11898# VSS a_n40037_n11829# SL_27N nmos$2
Xnmos$2_85 WL_29 VSS a_n41856_n10510# SL_26 nmos$2
Xnmos_801 a_n64438_22190# VSS a_n64585_22409# VSS nmos
Xpmos_150 a_n53901_n1354# VDD VDD a_n54048_n1434# pmos
Xpmos_161 a_n49383_n2662# VDD VDD a_n49530_n2742# pmos
Xnmos_812 a_n64438_27422# VSS a_n64585_27641# VSS nmos
Xnmos_823 a_n56915_24806# VSS a_n57062_25025# VSS nmos
Xnmos$2_4104 WL_15 VSS SL_25N a_n43512_8021# nmos$2
Xnmos_834 a_n26495_2538# VSS m1_n26796_2550# VSS nmos
Xpmos_194 a_n45017_n6666# VDD a_n44870_n6586# VDD pmos
Xpmos_183 a_n42003_n6666# VDD a_n41856_n6586# VDD pmos
Xpmos_172 a_n50888_n5278# VDD VDD a_n51035_n5358# pmos
Xnmos_867 a_n27274_8290# VSS a_n27618_8290# VSS nmos
Xnmos_856 a_n26151_6852# VSS a_n26495_6852# VSS nmos
Xnmos$2_4126 a_n49383_3878# VSS SL_21 a_n49069_3867# nmos$2
Xnmos_878 a_n37338_2570# VSS a_n37485_2789# VSS nmos
Xnmos$2_4115 WL_19 VSS SL_22N a_n48021_2789# nmos$2
Xnmos$2_4137 a_n50888_2570# VSS SL_20 a_n50574_2559# nmos$2
Xnmos_845 a_n26151_2538# VSS a_n26495_2538# VSS nmos
Xnmos$2_3436 a_n58558_22409# VSS a_n58097_22179# SL_15N nmos$2
Xnmos$2_3425 WL_6 VSS a_n59916_19574# SL_14 nmos$2
Xnmos$2_3403 a_n58558_17177# VSS a_n58097_16947# SL_15N nmos$2
Xnmos$2_3414 a_n59602_16947# VSS ML_8 m1_n59505_17155# nmos$2
Xnmos_889 a_n34324_6494# VSS a_n34471_6713# VSS nmos
Xnmos$2_4148 a_n54048_4097# VSS a_n53587_3867# SL_18N nmos$2
Xnmos$2_4159 WL_19 VSS SL_19N a_n52543_2789# nmos$2
Xnmos$2_3458 WL_3 VSS a_n59916_23498# SL_14 nmos$2
Xnmos$2_3447 WL_5 VSS SL_14N a_n60063_21101# nmos$2
Xnmos$2_3469 a_n53901_20882# VSS SL_18 a_n53587_20871# nmos$2
Xnmos$3_803 a_n35976_15869# VSS VSS a_n35829_15650# nmos$3
Xnmos$2_2724 WL_12 VSS SL_1N a_n79644_11945# nmos$2
Xnmos$2_2702 WL_13 VSS a_n77988_10418# SL_2 nmos$2
Xnmos$2_2713 a_n80688_10407# VSS ML_13 m1_n80591_10615# nmos$2
Xnmos$3_825 a_n42003_5405# VSS VSS a_n41856_5186# nmos$3
Xnmos$3_814 a_n45017_4097# VSS VSS a_n44870_3878# nmos$3
Xnmos$2_302 WL_25 VSS a_n46369_n5278# SL_23 nmos$2
Xnmos$2_2757 a_n79497_15650# VSS SL_1 a_n79183_15639# nmos$2
Xnmos$2_2746 a_n80688_14331# VSS ML_10 m1_n80591_14539# nmos$2
Xnmos$2_2735 a_n79183_13023# VSS ML_11 m1_n79086_13231# nmos$2
Xnmos$3_858 a_n46516_11945# VSS VSS a_n46369_11726# nmos$3
Xnmos$3_847 a_n49530_6713# VSS VSS a_n49383_6494# nmos$3
Xnmos$3_836 a_n52543_4097# VSS VSS a_n52396_3878# nmos$3
Xnmos$2_324 a_n52082_n5289# VSS ML_25 m1_n51985_n5081# nmos$2
Xnmos$2_335 a_n50574_n3981# VSS ML_24 m1_n50477_n3773# nmos$2
Xnmos$2_313 WL_24 VSS SL_22N a_n48021_n4050# nmos$2
Xnmos$3_869 a_n51035_14561# VSS VSS a_n50888_14342# nmos$3
Xnmos$2_2768 WL_10 VSS a_n74975_14342# SL_4 nmos$2
Xnmos$2_2779 a_n76169_13023# VSS ML_11 m1_n76072_13231# nmos$2
Xnmos$2_357 a_n52082_n57# VSS ML_21 m1_n51985_151# nmos$2
Xnmos$2_368 WL_22 VSS SL_22N a_n48021_n1434# nmos$2
Xnmos$2_346 WL_22 VSS SL_20N a_n51035_n1434# nmos$2
Xnmos$2_379 a_n49069_n57# VSS ML_21 m1_n48972_151# nmos$2
Xpmos_1918 a_n49383_11726# VDD VDD a_n49530_11945# pmos
Xpmos_1907 a_n50888_2570# VDD VDD a_n51035_2789# pmos
Xpmos_1929 a_n51035_9329# VDD a_n50888_9110# VDD pmos
Xnmos$2_4660 a_n48021_18485# VSS a_n47560_18255# SL_22N nmos$2
Xnmos$2_4682 WL_6 VSS SL_22N a_n48021_19793# nmos$2
Xnmos$2_4671 WL_7 VSS a_n49383_18266# SL_21 nmos$2
Xnmos$2_4693 WL_7 VSS a_n50888_18266# SL_20 nmos$2
Xnmos$5_151 VEVAL VSS m1_n33913_151# VSS nmos$5
Xnmos$5_140 VEVAL VSS m1_n36927_n5081# VSS nmos$5
Xnmos$2_3981 WL_9 VSS a_n34324_15650# SL_31 nmos$2
Xnmos$2_3970 WL_11 VSS a_n34324_13034# SL_31 nmos$2
Xnmos$2_3992 WL_12 VSS a_n35829_11726# SL_30 nmos$2
Xnmos$5_173 VEVAL VSS m1_n80591_n28774# VSS nmos$5
Xnmos$5_162 VEVAL VSS m1_n61014_n28774# VSS nmos$5
Xnmos$5_184 VEVAL VSS m1_n71550_n10313# VSS nmos$5
Xnmos$5_195 VEVAL VSS m1_n70045_n6389# VSS nmos$5
Xnmos$2_880 a_n76169_n28982# VSS a_n32313_n28669# m1_n76072_n28774# nmos$2
Xnmos$2_891 WL VSS PSL_1N a_n79644_n29051# nmos$2
Xnmos_108 a_n43365_n46# VSS a_n43512_173# VSS nmos
Xnmos_119 a_n26495_n11842# VSS VSS COMP30 nmos
Xnmos$2_2009 a_n56601_6483# VSS ML_16 m1_n56504_6691# nmos$2
Xnmos$2_1308 a_n75122_173# VSS a_n74661_n57# SL_4N nmos$2
Xnmos$2_1319 WL_22 VSS SL_8N a_n69104_n1434# nmos$2
Xnmos_631 a_n81002_13034# VSS a_n81149_13253# VSS nmos
Xnmos_642 a_n68957_10418# VSS a_n69104_10637# VSS nmos
Xnmos_620 a_n77988_9110# VSS a_n78135_9329# VSS nmos
Xnmos_686 a_n71961_22190# VSS a_n72108_22409# VSS nmos
Xnmos$2_3211 a_n78135_22409# VSS a_n77674_22179# SL_2N nmos$2
Xnmos_675 a_n70456_19574# VSS a_n70603_19793# VSS nmos
Xnmos$2_3200 WL_5 VSS a_n74975_20882# SL_4 nmos$2
Xnmos_664 a_n73470_15650# VSS a_n73617_15869# VSS nmos
Xnmos_653 a_n73470_9110# VSS a_n73617_9329# VSS nmos
Xnmos$2_3244 a_n76630_27641# VSS a_n76169_27411# SL_3N nmos$2
Xnmos$2_3233 WL_2 VSS a_n76483_24806# SL_3 nmos$2
Xnmos$2_3222 a_n74975_23498# VSS SL_4 a_n74661_23487# nmos$2
Xnmos_697 a_n70456_22190# VSS a_n70603_22409# VSS nmos
Xnmos$3_600 a_n69104_17177# VSS VSS a_n68957_16958# nmos$3
Xnmos$2_3277 a_n79183_27411# VSS ML_0 m1_n79086_27619# nmos$2
Xnmos$2_3255 a_n74661_26103# VSS ML_1 m1_n74564_26311# nmos$2
Xnmos$2_3266 a_n81002_24806# VSS SL_0 a_n80688_24795# nmos$2
Xnmos$3_622 a_n69104_21101# VSS VSS a_n68957_20882# nmos$3
Xnmos$3_611 a_n73617_21101# VSS VSS a_n73470_20882# nmos$3
Xnmos$3_633 a_n79644_18485# VSS VSS a_n79497_18266# nmos$3
Xnmos$2_2532 a_n70456_7802# VSS SL_7 a_n70142_7791# nmos$2
Xnmos$2_2521 a_n69104_5405# VSS a_n68643_5175# SL_8N nmos$2
Xnmos$2_2510 a_n68643_5175# VSS ML_17 m1_n68546_5383# nmos$2
Xnmos$2_110 WL_31 VSS a_n44870_n13126# SL_24 nmos$2
Xnmos$3_666 a_n81149_27641# VSS VSS a_n81002_27422# nmos$3
Xnmos$3_655 a_n76630_26333# VSS VSS a_n76483_26114# nmos$3
Xnmos$2_3288 a_n79644_26333# VSS a_n79183_26103# SL_1N nmos$2
Xnmos$2_3299 WL_2 VSS SL_8N a_n69104_25025# nmos$2
Xnmos$3_677 a_n72108_25025# VSS VSS a_n71961_24806# nmos$3
Xnmos$3_644 a_n79644_23717# VSS VSS a_n79497_23498# nmos$3
Xnmos$2_2543 WL_16 VSS a_n68957_6494# SL_8 nmos$2
Xnmos$2_2565 a_n76630_4097# VSS a_n76169_3867# SL_3N nmos$2
Xnmos$2_2554 WL_19 VSS SL_2N a_n78135_2789# nmos$2
Xnmos$2_2576 WL_19 VSS a_n81002_2570# SL_0 nmos$2
Xnmos$2_1820 a_n58411_n46# VSS SL_15 a_n58097_n57# nmos$2
Xnmos$2_1831 WL_22 VSS SL_16N a_n57062_n1434# nmos$2
Xnmos$2_132 a_n43051_n11829# VSS ML_30 m1_n42954_n11621# nmos$2
Xnmos$2_121 a_n46516_n10590# VSS a_n46055_n10521# SL_23N nmos$2
Xnmos$2_143 a_n44870_n9202# VSS SL_24 a_n44556_n9213# nmos$2
Xnmos$3_699 a_n57062_22409# VSS VSS a_n56915_22190# nmos$3
Xnmos$3_688 a_n54048_19793# VSS VSS a_n53901_19574# nmos$3
Xnmos$2_2598 a_n79644_6713# VSS a_n79183_6483# SL_1N nmos$2
Xnmos$2_2587 a_n77988_3878# VSS SL_2 a_n77674_3867# nmos$2
Xnmos$2_1842 a_n53901_n46# VSS SL_18 a_n53587_n57# nmos$2
Xnmos$2_1864 a_n53587_n2673# VSS ML_23 m1_n53490_n2465# nmos$2
Xnmos$2_1853 WL_23 VSS SL_15N a_n58558_n2742# nmos$2
Xnmos$2_187 WL_31 VSS a_n46369_n13126# SL_23 nmos$2
Xnmos$2_165 WL_28 VSS SL_25N a_n43512_n9282# nmos$2
Xnmos$2_154 a_n43051_n7905# VSS ML_27 m1_n42954_n7697# nmos$2
Xnmos$2_176 a_n40351_n7894# VSS SL_27 a_n40037_n7905# nmos$2
Xpmos_8 a_n35976_n29051# VDD a_n35829_n28971# VDD pmos
Xnmos$2_198 a_n49069_n10521# VSS ML_29 m1_n48972_n10313# nmos$2
Xnmos$2_1875 a_n65629_n6597# VSS ML_26 m1_n65532_n6389# nmos$2
Xnmos$2_1897 WL_26 VSS SL_12N a_n63077_n6666# nmos$2
Xnmos$2_1886 WL_26 VSS a_n56915_n6586# SL_16 nmos$2
Xpmos_1726 a_n35976_9329# VDD a_n35829_9110# VDD pmos
Xpmos_1715 a_n34324_7802# VDD VDD a_n34471_8021# pmos
Xpmos_1704 a_n37485_5405# VDD a_n37338_5186# VDD pmos
Xpmos_1759 a_n35829_15650# VDD VDD a_n35976_15869# pmos
Xpmos_1748 a_n37485_14561# VDD a_n37338_14342# VDD pmos
Xpmos_1737 a_n38990_10637# VDD a_n38843_10418# VDD pmos
Xpmos_908 a_n63077_1481# VDD a_n62930_1262# VDD pmos
Xpmos_919 a_n64585_1481# VDD a_n64438_1262# VDD pmos
Xnmos$2_5180 a_n40037_1251# VSS ML_20 m1_n39940_1459# nmos$2
Xnmos$2_5191 WL_20 VSS SL_25N a_n43512_1481# nmos$2
Xnmos$2_4490 a_n41542_14331# VSS ML_10 m1_n41445_14539# nmos$2
Xnmos$5_909 VEVAL VSS m1_n41445_17155# VSS nmos$5
Xnmos$2_1116 a_n76169_n9213# VSS ML_28 m1_n76072_n9005# nmos$2
Xnmos$2_1105 a_n79644_n7974# VSS a_n79183_n7905# SL_1N nmos$2
Xnmos$2_1127 WL_27 VSS a_n74975_n7894# SL_4 nmos$2
Xnmos$2_1138 WL_25 VSS a_n76483_n5278# SL_3 nmos$2
Xnmos$2_1149 a_n76630_n4050# VSS a_n76169_n3981# SL_3N nmos$2
Xpmos$1_91 OUTP VDD a_n27274_18356# m1_n28364_18279# pmos$1
Xpmos$1_80 OUTP VDD m1_n26796_16930# a_n26151_16918# pmos$1
Xnmos_461 a_n58411_n1354# VSS a_n58558_n1434# VSS nmos
Xnmos_450 a_n61425_n2662# VSS a_n61572_n2742# VSS nmos
Xnmos_483 a_n59916_5186# VSS a_n60063_5405# VSS nmos
Xnmos_494 a_n62930_2570# VSS a_n63077_2789# VSS nmos
Xnmos_472 a_n58411_n2662# VSS a_n58558_n2742# VSS nmos
Xnmos$2_3041 WL_3 VSS SL_4N a_n75122_23717# nmos$2
Xnmos$2_3030 a_n75122_22409# VSS a_n74661_22179# SL_4N nmos$2
Xnmos$2_3052 a_n68957_20882# VSS SL_8 a_n68643_20871# nmos$2
Xnmos$2_3074 a_n70456_23498# VSS SL_7 a_n70142_23487# nmos$2
Xnmos$2_3085 WL_5 VSS a_n68957_20882# SL_8 nmos$2
Xnmos$2_3063 WL_5 VSS a_n70456_20882# SL_7 nmos$2
Xnmos$3_452 a_n61572_15869# VSS VSS a_n61425_15650# nmos$3
Xnmos$3_441 a_n64585_13253# VSS VSS a_n64438_13034# nmos$3
Xnmos$2_2351 a_n58558_11945# VSS a_n58097_11715# SL_15N nmos$2
Xnmos$2_2340 WL_14 VSS a_n59916_9110# SL_14 nmos$2
Xnmos$3_430 a_n61572_9329# VSS VSS a_n61425_9110# nmos$3
Xnmos$2_3096 a_n76630_18485# VSS a_n76169_18255# SL_3N nmos$2
Xnmos$2_2384 a_n58411_15650# VSS SL_15 a_n58097_15639# nmos$2
Xnmos$3_474 a_n58558_15869# VSS VSS a_n58411_15650# nmos$3
Xnmos$2_2362 a_n58097_13023# VSS ML_11 m1_n58000_13231# nmos$2
Xnmos$2_2373 WL_11 VSS SL_14N a_n60063_13253# nmos$2
Xnmos$3_463 a_n60063_11945# VSS VSS a_n59916_11726# nmos$3
Xnmos$3_485 a_n70603_4097# VSS VSS a_n70456_3878# nmos$3
Xnmos$2_2395 a_n53901_14342# VSS SL_18 a_n53587_14331# nmos$2
Xnmos$3_496 a_n73617_6713# VSS VSS a_n73470_6494# nmos$3
Xnmos$2_1672 a_n64124_n5289# VSS ML_25 m1_n64027_n5081# nmos$2
Xnmos$2_1650 WL_25 VSS a_n62930_n5278# SL_12 nmos$2
Xnmos$2_1661 a_n61572_n4050# VSS a_n61111_n3981# SL_13N nmos$2
Xnmos$2_1694 WL_22 VSS a_n64438_n1354# SL_11 nmos$2
Xnmos$2_1683 WL_24 VSS a_n64438_n3970# SL_11 nmos$2
Xpmos_2213 OUTP VDD VDD a_n28089_22176# pmos
Xpmos_2202 a_n28485_18454# VDD m1_n28364_18279# VDD pmos
Xpmos_1501 a_n57062_22409# VDD a_n56915_22190# VDD pmos
Xpmos_2224 ML_6 VDD a_n28485_22768# VDD pmos
Xpmos_2246 a_n37485_18485# VDD a_n37338_18266# VDD pmos
Xpmos_2235 a_n35976_17177# VDD a_n35829_16958# VDD pmos
Xpmos_2279 a_n35829_26114# VDD VDD a_n35976_26333# pmos
Xpmos_2257 a_n35976_23717# VDD a_n35829_23498# VDD pmos
Xpmos_2268 a_n34471_22409# VDD a_n34324_22190# VDD pmos
Xpmos_1512 a_n55557_22409# VDD a_n55410_22190# VDD pmos
Xpmos_1545 a_n66090_21101# VDD a_n65943_20882# VDD pmos
Xpmos_1523 a_n64438_19574# VDD VDD a_n64585_19793# pmos
Xpmos_1534 a_n67452_16958# VDD VDD a_n67599_17177# pmos
Xpmos_1578 a_n62930_27422# VDD VDD a_n63077_27641# pmos
Xpmos_1567 a_n61572_25025# VDD a_n61425_24806# VDD pmos
Xpmos_1556 a_n64438_20882# VDD VDD a_n64585_21101# pmos
Xpmos_705 a_n65943_n13126# VDD VDD a_n66090_n13206# pmos
Xpmos_727 a_n64438_n10510# VDD VDD a_n64585_n10590# pmos
Xpmos_716 a_n65943_n9202# VDD VDD a_n66090_n9282# pmos
Xpmos_1589 a_n64585_26333# VDD a_n64438_26114# VDD pmos
Xpmos_738 a_n61572_n6666# VDD a_n61425_n6586# VDD pmos
Xpmos_749 a_n65943_n5278# VDD VDD a_n66090_n5358# pmos
Xnmos$2_4 WL VSS a_n37338_n28971# PSL_29 nmos$2
Xnmos$5_706 VEVAL VSS m1_n65532_21079# VSS nmos$5
Xnmos$5_717 VEVAL VSS m1_n64027_18463# VSS nmos$5
Xnmos$5_728 VEVAL VSS m1_n61014_26311# VSS nmos$5
Xnmos$5_739 VEVAL VSS m1_n56504_25003# VSS nmos$5
Xnmos_280 a_n68957_n11818# VSS a_n69104_n11898# VSS nmos
Xnmos_291 a_n74975_n9202# VSS a_n75122_n9282# VSS nmos
Xnmos$3_260 a_n67599_n5358# VSS VSS a_n67452_n5278# nmos$3
Xnmos$2_2181 a_n61572_11945# VSS a_n61111_11715# SL_13N nmos$2
Xnmos$2_2170 a_n62930_10418# VSS SL_12 a_n62616_10407# nmos$2
Xnmos$2_2192 WL_13 VSS a_n64438_10418# SL_11 nmos$2
Xnmos$3_271 a_n73617_n1434# VSS VSS a_n73470_n1354# nmos$3
Xnmos$3_282 a_n73617_n2742# VSS VSS a_n73470_n2662# nmos$3
Xnmos$3_293 a_n60063_n10590# VSS VSS a_n59916_n10510# nmos$3
Xnmos$2_1480 a_n58097_n9213# VSS ML_28 m1_n58000_n9005# nmos$2
Xnmos$2_1491 WL_27 VSS SL_14N a_n60063_n7974# nmos$2
Xpmos_2021 a_n40498_17177# VDD a_n40351_16958# VDD pmos
Xpmos_2010 a_n41856_13034# VDD VDD a_n42003_13253# pmos
Xpmos_2054 a_n43512_22409# VDD a_n43365_22190# VDD pmos
Xpmos_2032 a_n41856_18266# VDD VDD a_n42003_18485# pmos
Xpmos_2043 a_n43512_18485# VDD a_n43365_18266# VDD pmos
Xpmos_2065 a_n40498_22409# VDD a_n40351_22190# VDD pmos
Xpmos_1331 a_n74975_22190# VDD VDD a_n75122_22409# pmos
Xpmos_2098 a_n53901_20882# VDD VDD a_n54048_21101# pmos
Xpmos_1353 a_n69104_21101# VDD a_n68957_20882# VDD pmos
Xpmos_1342 a_n70603_21101# VDD a_n70456_20882# VDD pmos
Xpmos_1320 a_n71961_19574# VDD VDD a_n72108_19793# pmos
Xpmos_2076 a_n49530_18485# VDD a_n49383_18266# VDD pmos
Xpmos_2087 a_n52543_17177# VDD a_n52396_16958# VDD pmos
Xpmos_1386 a_n81149_22409# VDD a_n81002_22190# VDD pmos
Xpmos_1375 a_n78135_19793# VDD a_n77988_19574# VDD pmos
Xpmos_1364 a_n76483_18266# VDD VDD a_n76630_18485# pmos
Xpmos_502 a_n79497_n13126# VDD VDD a_n79644_n13206# pmos
Xpmos_513 a_n79497_n10510# VDD VDD a_n79644_n10590# pmos
Xpmos_524 a_n79644_n9282# VDD a_n79497_n9202# VDD pmos
Xpmos_535 a_n76630_n7974# VDD a_n76483_n7894# VDD pmos
Xpmos_1397 a_n75122_21101# VDD a_n74975_20882# VDD pmos
Xpmos_568 a_n78135_n2742# VDD a_n77988_n2662# VDD pmos
Xpmos_557 a_n81002_n6586# VDD VDD a_n81149_n6666# pmos
Xpmos_546 a_n76630_n4050# VDD a_n76483_n3970# VDD pmos
Xpmos_579 a_n79644_n2742# VDD a_n79497_n2662# VDD pmos
Xnmos_1251 a_n26151_31298# VSS a_n26495_31298# VSS nmos
Xnmos_1240 ML_1 VSS VSS a_n28485_29958# nmos
Xnmos_1262 a_n40351_19574# VSS a_n40498_19793# VSS nmos
Xnmos_1273 a_n40351_7802# VSS a_n40498_8021# VSS nmos
Xnmos_1295 a_n47874_1262# VSS a_n48021_1481# VSS nmos
Xnmos_1284 a_n74975_1262# VSS a_n75122_1481# VSS nmos
Xnmos$2_709 WL_25 VSS a_n38843_n5278# SL_28 nmos$2
Xnmos$5_30 VEVAL VSS m1_n44459_n6389# VSS nmos$5
Xnmos$5_41 VEVAL VSS m1_n42954_n12929# VSS nmos$5
Xnmos$5_52 VEVAL VSS m1_n51985_n10313# VSS nmos$5
Xnmos$5_63 VEVAL VSS m1_n48972_n6389# VSS nmos$5
Xnmos$5_74 VEVAL VSS m1_n50477_n3773# VSS nmos$5
Xnmos$5_96 VEVAL VSS m1_n45958_n1157# VSS nmos$5
Xnmos$5_85 VEVAL VSS m1_n50477_n2465# VSS nmos$5
Xnmos$5_503 VEVAL VSS m1_n68546_7999# VSS nmos$5
Xnmos$5_525 VEVAL VSS m1_n74564_6691# VSS nmos$5
Xnmos$5_514 VEVAL VSS m1_n79086_2767# VSS nmos$5
Xnmos$5_558 VEVAL VSS m1_n76072_14539# VSS nmos$5
Xnmos$5_569 VEVAL VSS m1_n68546_11923# VSS nmos$5
Xnmos$5_547 VEVAL VSS m1_n80591_11923# VSS nmos$5
Xnmos$5_536 VEVAL VSS m1_n76072_10615# VSS nmos$5
Xpmos$3_26 PC VDD ML_7 VDD pmos$3
Xpmos$3_15 PC VDD ML_17 VDD pmos$3
Xpmos_1161 a_n81002_7802# VDD VDD a_n81149_8021# pmos
Xpmos_1150 a_n79644_4097# VDD a_n79497_3878# VDD pmos
Xpmos_310 a_n34471_n6666# VDD a_n34324_n6586# VDD pmos
Xpmos_1183 a_n77988_9110# VDD VDD a_n78135_9329# pmos
Xpmos_1194 a_n81002_9110# VDD VDD a_n81149_9329# pmos
Xpmos_1172 a_n77988_6494# VDD VDD a_n78135_6713# pmos
Xpmos_343 a_n37485_173# VDD a_n37338_n46# VDD pmos
Xpmos_332 a_n35976_n2742# VDD a_n35829_n2662# VDD pmos
Xpmos_321 a_n38843_n6586# VDD VDD a_n38990_n6666# pmos
Xnmos$2_5009 WL_5 VSS SL_28N a_n38990_21101# nmos$2
Xpmos_354 a_n26495_n6090# VDD COMP26 VDD pmos
Xpmos_376 ML_27 VDD a_n28485_n7430# VDD pmos
Xpmos_365 a_n26151_n3214# VDD VDD a_n26495_n3214# pmos
Xnmos$2_4319 WL_9 VSS SL_18N a_n54048_15869# nmos$2
Xnmos$2_4308 a_n50574_14331# VSS ML_10 m1_n50477_14539# nmos$2
Xpmos_387 a_n27274_n338# VDD VDD a_n27618_n338# pmos
Xpmos_398 a_n40351_n6586# VDD VDD a_n40498_n6666# pmos
Xnmos$2_3607 WL_5 VSS SL_13N a_n61572_21101# nmos$2
Xnmos_1070 a_n44870_19574# VSS a_n45017_19793# VSS nmos
Xnmos$2_3618 a_n62930_20882# VSS SL_12 a_n62616_20871# nmos$2
Xnmos_1081 a_n43365_23498# VSS a_n43512_23717# VSS nmos
Xnmos$2_3629 a_n64585_23717# VSS a_n64124_23487# SL_11N nmos$2
Xnmos_1092 a_n53901_18266# VSS a_n54048_18485# VSS nmos
Xnmos$2_2906 WL_11 VSS SL_5N a_n73617_13253# nmos$2
Xnmos$2_2939 a_n68957_15650# VSS SL_8 a_n68643_15639# nmos$2
Xnmos$2_2917 WL_10 VSS a_n67452_14342# SL_9 nmos$2
Xnmos$2_2928 a_n70142_14331# VSS ML_10 m1_n70045_14539# nmos$2
Xnmos$2_506 a_n43365_n2662# VSS SL_25 a_n43051_n2673# nmos$2
Xnmos$2_517 WL_23 VSS a_n44870_n2662# SL_24 nmos$2
Xnmos$3_1030 a_n52543_1481# VSS VSS a_n52396_1262# nmos$3
Xnmos$3_1041 a_n60063_1481# VSS VSS a_n59916_1262# nmos$3
Xnmos$2_528 a_n46369_n9202# VSS SL_23 a_n46055_n9213# nmos$2
Xnmos$2_539 WL_26 VSS a_n41856_n6586# SL_26 nmos$2
Xnmos$3_1052 a_n81149_1481# VSS VSS a_n81002_1262# nmos$3
Xnmos$2_4842 WL_0 VSS a_n50888_27422# SL_20 nmos$2
Xnmos$2_4820 a_n47560_26103# VSS ML_1 m1_n47463_26311# nmos$2
Xnmos$2_4831 WL_2 VSS a_n52396_24806# SL_19 nmos$2
Xnmos$5_300 VEVAL VSS m1_n62519_n11621# VSS nmos$5
Xnmos$2_4875 WL_0 VSS SL_25N a_n43512_27641# nmos$2
Xnmos$2_4853 WL_1 VSS a_n52396_26114# SL_19 nmos$2
Xnmos$2_4864 a_n40037_24795# VSS ML_2 m1_n39940_25003# nmos$2
Xnmos$5_344 VEVAL VSS m1_n61014_n2465# VSS nmos$5
Xnmos$5_322 VEVAL VSS m1_n64027_n12929# VSS nmos$5
Xnmos$5_311 VEVAL VSS m1_n67041_n7697# VSS nmos$5
Xnmos$5_333 VEVAL VSS m1_n67041_n3773# VSS nmos$5
Xnmos$2_4897 a_n41856_26114# VSS SL_26 a_n41542_26103# nmos$2
Xnmos$2_4886 WL_1 VSS SL_25N a_n43512_26333# nmos$2
Xnmos$5_377 VEVAL VSS m1_n54999_4075# VSS nmos$5
Xnmos$5_366 VEVAL VSS m1_n56504_151# VSS nmos$5
Xnmos$5_355 VEVAL VSS m1_n54999_n3773# VSS nmos$5
Xnmos$5_388 VEVAL VSS m1_n59505_7999# VSS nmos$5
Xnmos$5_399 VEVAL VSS m1_n62519_1459# VSS nmos$5
Xpmos$1_8 OUTP VDD m1_n26796_n8954# a_n26151_n8966# pmos$1
Xnmos$2_20 a_n40351_n28971# VSS PSL_27 a_n40037_n28982# nmos$2
Xnmos$2_31 a_n43512_n29051# VSS a_n43051_n28982# PSL_25N nmos$2
Xnmos$2_42 WL VSS PSL_24N a_n45017_n29051# nmos$2
Xnmos$2_53 WL VSS PSL_20N a_n51035_n29051# nmos$2
Xnmos$2_75 WL_31 VSS a_n41856_n13126# SL_26 nmos$2
Xnmos$2_64 a_n49383_n28971# VSS PSL_21 a_n49069_n28982# nmos$2
Xnmos$2_86 a_n43512_n11898# VSS a_n43051_n11829# SL_25N nmos$2
Xnmos$2_97 a_n40037_n11829# VSS ML_30 m1_n39940_n11621# nmos$2
Xpmos_151 a_n52543_n1434# VDD a_n52396_n1354# VDD pmos
Xpmos_140 a_n53901_n6586# VDD VDD a_n54048_n6666# pmos
Xnmos_813 a_n62930_27422# VSS a_n63077_27641# VSS nmos
Xnmos_824 a_n56915_26114# VSS a_n57062_26333# VSS nmos
Xnmos_802 a_n64438_20882# VSS a_n64585_21101# VSS nmos
Xnmos_835 OUTP VSS a_n28089_3482# VSS nmos
Xpmos_162 a_n49383_n1354# VDD VDD a_n49530_n1434# pmos
Xpmos_173 a_n50888_n1354# VDD VDD a_n51035_n1434# pmos
Xpmos_184 a_n43365_n6586# VDD VDD a_n43512_n6666# pmos
Xnmos_868 a_n28485_8388# VSS VSS m1_n28364_8213# nmos
Xnmos$2_4105 a_n43512_8021# VSS a_n43051_7791# SL_25N nmos$2
Xnmos_857 a_n26495_6852# VSS VSS COMP17 nmos
Xnmos_846 a_n27274_3976# VSS a_n27618_3976# VSS nmos
Xnmos$2_4127 WL_18 VSS SL_21N a_n49530_4097# nmos$2
Xnmos$2_4116 a_n48021_2789# VSS a_n47560_2559# SL_22N nmos$2
Xnmos$2_4138 a_n50574_2559# VSS ML_19 m1_n50477_2767# nmos$2
Xpmos_195 a_n45017_n5358# VDD a_n44870_n5278# VDD pmos
Xnmos$2_3426 WL_6 VSS a_n56915_19574# SL_16 nmos$2
Xnmos$2_3404 a_n58411_16958# VSS SL_15 a_n58097_16947# nmos$2
Xnmos$2_3415 a_n60063_17177# VSS a_n59602_16947# SL_14N nmos$2
Xnmos$2_4149 a_n52396_3878# VSS SL_19 a_n52082_3867# nmos$2
Xnmos_879 a_n38843_2570# VSS a_n38990_2789# VSS nmos
Xnmos$2_3459 a_n58558_23717# VSS a_n58097_23487# SL_15N nmos$2
Xnmos$2_3437 WL_4 VSS a_n58411_22190# SL_15 nmos$2
Xnmos$2_3448 a_n60063_22409# VSS a_n59602_22179# SL_14N nmos$2
Xnmos$3_804 a_n37485_15869# VSS VSS a_n37338_15650# nmos$3
Xnmos$2_2725 a_n79644_11945# VSS a_n79183_11715# SL_1N nmos$2
Xnmos$2_2714 WL_13 VSS SL_0N a_n81149_10637# nmos$2
Xnmos$2_2703 a_n79183_9099# VSS ML_14 m1_n79086_9307# nmos$2
Xnmos$3_826 a_n42003_8021# VSS VSS a_n41856_7802# nmos$3
Xnmos$3_815 a_n43512_4097# VSS VSS a_n43365_3878# nmos$3
Xnmos$2_2758 WL_9 VSS SL_1N a_n79644_15869# nmos$2
Xnmos$2_2736 a_n79497_14342# VSS SL_1 a_n79183_14331# nmos$2
Xnmos$2_2747 WL_10 VSS SL_0N a_n81149_14561# nmos$2
Xnmos$3_859 a_n48021_9329# VSS VSS a_n47874_9110# nmos$3
Xnmos$3_848 a_n49530_8021# VSS VSS a_n49383_7802# nmos$3
Xnmos$3_837 a_n51035_4097# VSS VSS a_n50888_3878# nmos$3
Xnmos$2_325 WL_25 VSS SL_18N a_n54048_n5358# nmos$2
Xnmos$2_303 a_n49530_n5358# VSS a_n49069_n5289# SL_21N nmos$2
Xnmos$2_336 WL_24 VSS a_n50888_n3970# SL_20 nmos$2
Xnmos$2_314 WL_24 VSS a_n46369_n3970# SL_23 nmos$2
Xnmos$2_2769 a_n74975_14342# VSS SL_4 a_n74661_14331# nmos$2
Xnmos$2_358 a_n50888_n46# VSS SL_20 a_n50574_n57# nmos$2
Xnmos$2_369 WL_22 VSS a_n46369_n1354# SL_23 nmos$2
Xnmos$2_347 WL_22 VSS a_n50888_n1354# SL_20 nmos$2
Xpmos_1919 a_n47874_11726# VDD VDD a_n48021_11945# pmos
Xpmos_1908 a_n50888_3878# VDD VDD a_n51035_4097# pmos
Xnmos$2_4650 a_n40037_23487# VSS ML_3 m1_n39940_23695# nmos$2
Xnmos$2_4683 WL_6 VSS a_n46369_19574# SL_23 nmos$2
Xnmos$2_4672 a_n49383_18266# VSS SL_21 a_n49069_18255# nmos$2
Xnmos$2_4661 a_n47874_16958# VSS SL_22 a_n47560_16947# nmos$2
Xnmos$2_4694 a_n50888_16958# VSS SL_20 a_n50574_16947# nmos$2
Xnmos$5_152 VEVAL VSS m1_n36927_n2465# VSS nmos$5
Xnmos$5_130 VEVAL VSS m1_n33913_n9005# VSS nmos$5
Xnmos$5_141 VEVAL VSS m1_n38432_n5081# VSS nmos$5
Xnmos$2_3982 a_n34324_15650# VSS SL_31 a_n34010_15639# nmos$2
Xnmos$2_3960 WL_9 VSS a_n37338_15650# SL_29 nmos$2
Xnmos$2_3971 a_n35976_13253# VSS a_n35515_13023# SL_30N nmos$2
Xnmos$5_185 VEVAL VSS m1_n71550_n11621# VSS nmos$5
Xnmos$5_174 VEVAL VSS m1_n68546_n12929# VSS nmos$5
Xnmos$5_163 VEVAL VSS m1_n67041_n28774# VSS nmos$5
Xnmos$2_3993 a_n35829_11726# VSS SL_30 a_n35515_11715# nmos$2
Xnmos$5_196 VEVAL VSS m1_n68546_n7697# VSS nmos$5
Xnmos$2_881 WL VSS a_n76483_n28971# PSL_3 nmos$2
Xnmos$2_870 a_n73156_n28982# VSS a_n32313_n28669# m1_n73059_n28774# nmos$2
Xnmos$2_892 a_n81149_n29051# VSS a_n80688_n28982# PSL_0N nmos$2
Xnmos_109 a_n41856_n46# VSS a_n42003_173# VSS nmos
Xnmos$2_1309 WL_21 VSS SL_4N a_n75122_173# nmos$2
Xnmos_610 a_n79497_7802# VSS a_n79644_8021# VSS nmos
Xnmos_632 a_n81002_14342# VSS a_n81149_14561# VSS nmos
Xnmos_621 a_n77988_11726# VSS a_n78135_11945# VSS nmos
Xnmos_643 a_n70456_10418# VSS a_n70603_10637# VSS nmos
Xnmos_676 a_n68957_19574# VSS a_n69104_19793# VSS nmos
Xnmos$2_3201 a_n74975_20882# VSS SL_4 a_n74661_20871# nmos$2
Xnmos_665 a_n68957_14342# VSS a_n69104_14561# VSS nmos
Xnmos_654 a_n73470_10418# VSS a_n73617_10637# VSS nmos
Xnmos$2_3234 a_n77674_24795# VSS ML_2 m1_n77577_25003# nmos$2
Xnmos$2_3223 a_n76630_23717# VSS a_n76169_23487# SL_3N nmos$2
Xnmos_698 a_n70456_20882# VSS a_n70603_21101# VSS nmos
Xnmos_687 a_n71961_20882# VSS a_n72108_21101# VSS nmos
Xnmos$2_3212 WL_5 VSS a_n76483_20882# SL_3 nmos$2
Xnmos$3_601 a_n69104_18485# VSS VSS a_n68957_18266# nmos$3
Xnmos$2_2500 WL_15 VSS a_n73470_7802# SL_5 nmos$2
Xnmos$2_3245 WL_0 VSS SL_3N a_n76630_27641# nmos$2
Xnmos$2_3278 a_n79497_27422# VSS SL_1 a_n79183_27411# nmos$2
Xnmos$2_3256 WL_1 VSS a_n74975_26114# SL_4 nmos$2
Xnmos$2_3267 a_n80688_24795# VSS ML_2 m1_n80591_25003# nmos$2
Xnmos$3_612 a_n73617_23717# VSS VSS a_n73470_23498# nmos$3
Xnmos$3_623 a_n75122_17177# VSS VSS a_n74975_16958# nmos$3
Xnmos$3_634 a_n81149_17177# VSS VSS a_n81002_16958# nmos$3
Xnmos$2_2533 a_n70142_7791# VSS ML_15 m1_n70045_7999# nmos$2
Xnmos$2_2522 WL_16 VSS a_n70456_6494# SL_7 nmos$2
Xnmos$2_2511 WL_17 VSS a_n67452_5186# SL_9 nmos$2
Xnmos$2_111 a_n46516_n13206# VSS a_n46055_n13137# SL_23N nmos$2
Xnmos$2_100 a_n42003_n10590# VSS a_n41542_n10521# SL_26N nmos$2
Xnmos$3_667 a_n78135_27641# VSS VSS a_n77988_27422# nmos$3
Xnmos$2_3289 a_n79183_26103# VSS ML_1 m1_n79086_26311# nmos$2
Xnmos$3_656 a_n76630_25025# VSS VSS a_n76483_24806# nmos$3
Xnmos$3_645 a_n81149_23717# VSS VSS a_n81002_23498# nmos$3
Xnmos$2_2544 WL_15 VSS a_n68957_7802# SL_8 nmos$2
Xnmos$2_2566 a_n74975_3878# VSS SL_4 a_n74661_3867# nmos$2
Xnmos$2_2555 a_n77674_2559# VSS ML_19 m1_n77577_2767# nmos$2
Xnmos$2_1821 a_n58558_173# VSS a_n58097_n57# SL_15N nmos$2
Xnmos$2_1810 WL_22 VSS a_n59916_n1354# SL_14 nmos$2
Xnmos$2_122 WL_29 VSS a_n44870_n10510# SL_24 nmos$2
Xnmos$2_133 a_n44556_n10521# VSS ML_29 m1_n44459_n10313# nmos$2
Xnmos$2_144 a_n46055_n9213# VSS ML_28 m1_n45958_n9005# nmos$2
Xnmos$3_678 a_n72108_26333# VSS VSS a_n71961_26114# nmos$3
Xnmos$3_689 a_n57062_18485# VSS VSS a_n56915_18266# nmos$3
Xnmos$2_2599 a_n79183_6483# VSS ML_16 m1_n79086_6691# nmos$2
Xnmos$2_2588 a_n79497_3878# VSS SL_1 a_n79183_3867# nmos$2
Xnmos$2_2577 WL_19 VSS SL_0N a_n81149_2789# nmos$2
Xnmos$2_1843 a_n55557_173# VSS a_n55096_n57# SL_17N nmos$2
Xnmos$2_1832 WL_22 VSS a_n55410_n1354# SL_17 nmos$2
Xnmos$2_1865 WL_23 VSS a_n53901_n2662# SL_18 nmos$2
Xnmos$2_1854 a_n58411_n2662# VSS SL_15 a_n58097_n2673# nmos$2
Xnmos$2_166 a_n41542_n9213# VSS ML_28 m1_n41445_n9005# nmos$2
Xnmos$2_155 WL_27 VSS a_n43365_n7894# SL_25 nmos$2
Xnmos$2_177 a_n40498_n7974# VSS a_n40037_n7905# SL_27N nmos$2
Xnmos$2_188 a_n49383_n13126# VSS SL_21 a_n49069_n13137# nmos$2
Xpmos_9 a_n32313_n28669# VDD a_n31996_n28654# VDD pmos
Xnmos$2_199 a_n49383_n11818# VSS SL_21 a_n49069_n11829# nmos$2
Xnmos$2_1898 a_n64124_n6597# VSS ML_26 m1_n64027_n6389# nmos$2
Xnmos$2_1887 WL_26 VSS a_n58411_n6586# SL_15 nmos$2
Xnmos$2_1876 a_n53587_n6597# VSS ML_26 m1_n53490_n6389# nmos$2
Xpmos_1716 a_n34324_9110# VDD VDD a_n34471_9329# pmos
Xpmos_1727 a_n38990_9329# VDD a_n38843_9110# VDD pmos
Xpmos_1705 a_n37485_6713# VDD a_n37338_6494# VDD pmos
Xpmos_1749 a_n37485_13253# VDD a_n37338_13034# VDD pmos
Xpmos_1738 a_n37485_9329# VDD a_n37338_9110# VDD pmos
Xpmos_909 a_n64438_2570# VDD VDD a_n64585_2789# pmos
Xnmos$2_5170 WL_20 VSS SL_19N a_n52543_1481# nmos$2
Xnmos$2_5181 WL_20 VSS a_n40351_1262# SL_27 nmos$2
Xnmos$2_5192 a_n43512_1481# VSS a_n43051_1251# SL_25N nmos$2
Xnmos$2_4480 a_n40351_13034# VSS SL_27 a_n40037_13023# nmos$2
Xnmos$2_4491 a_n41856_13034# VSS SL_26 a_n41542_13023# nmos$2
Xnmos$2_3790 WL_18 VSS a_n34324_3878# SL_31 nmos$2
Xnmos$2_1117 a_n76483_n9202# VSS SL_3 a_n76169_n9213# nmos$2
Xnmos$2_1106 WL_27 VSS SL_1N a_n79644_n7974# nmos$2
Xnmos$2_1128 a_n74661_n7905# VSS ML_27 m1_n74564_n7697# nmos$2
Xnmos$2_1139 WL_25 VSS SL_2N a_n78135_n5358# nmos$2
Xpmos$1_81 a_n28089_16424# VDD m1_n27919_16930# a_n27274_16918# pmos$1
Xpmos$1_70 OUTP VDD a_n27274_14042# m1_n28364_13965# pmos$1
Xpmos$1_92 a_n28089_20738# VDD a_n26151_21232# a_n27618_21232# pmos$1
Xnmos_440 a_n67452_n46# VSS a_n67599_173# VSS nmos
Xnmos_451 a_n67452_n2662# VSS a_n67599_n2742# VSS nmos
Xnmos_484 a_n59916_6494# VSS a_n60063_6713# VSS nmos
Xnmos_473 a_n55410_2570# VSS a_n55557_2789# VSS nmos
Xnmos_462 a_n59916_n1354# VSS a_n60063_n1434# VSS nmos
Xnmos$2_3042 a_n75122_23717# VSS a_n74661_23487# SL_4N nmos$2
Xnmos$2_3053 WL_5 VSS a_n67452_20882# SL_9 nmos$2
Xnmos$2_3020 WL_5 VSS a_n71961_20882# SL_6 nmos$2
Xnmos$2_3031 WL_5 VSS a_n73470_20882# SL_5 nmos$2
Xnmos_495 a_n64438_2570# VSS a_n64585_2789# VSS nmos
Xnmos$2_3086 WL_3 VSS a_n68957_23498# SL_8 nmos$2
Xnmos$2_3075 WL_3 VSS a_n70456_23498# SL_7 nmos$2
Xnmos$2_3064 a_n70456_20882# VSS SL_7 a_n70142_20871# nmos$2
Xnmos$3_442 a_n64585_14561# VSS VSS a_n64438_14342# nmos$3
Xnmos$2_2330 a_n58558_10637# VSS a_n58097_10407# SL_15N nmos$2
Xnmos$2_2341 a_n59916_9110# VSS SL_14 a_n59602_9099# nmos$2
Xnmos$3_431 a_n63077_9329# VSS VSS a_n62930_9110# nmos$3
Xnmos$3_420 a_n66090_6713# VSS VSS a_n65943_6494# nmos$3
Xnmos$2_3097 a_n76483_16958# VSS SL_3 a_n76169_16947# nmos$2
Xnmos$2_2363 a_n58558_14561# VSS a_n58097_14331# SL_15N nmos$2
Xnmos$2_2374 WL_10 VSS SL_14N a_n60063_14561# nmos$2
Xnmos$3_475 a_n58558_13253# VSS VSS a_n58411_13034# nmos$3
Xnmos$3_464 a_n57062_11945# VSS VSS a_n56915_11726# nmos$3
Xnmos$2_2352 a_n58097_11715# VSS ML_12 m1_n58000_11923# nmos$2
Xnmos$3_453 a_n54048_10637# VSS VSS a_n53901_10418# nmos$3
Xnmos$2_1640 a_n61572_n7974# VSS a_n61111_n7905# SL_13N nmos$2
Xnmos$2_2385 WL_9 VSS SL_15N a_n58558_15869# nmos$2
Xnmos$2_2396 a_n53587_14331# VSS ML_10 m1_n53490_14539# nmos$2
Xnmos$3_497 a_n73617_8021# VSS VSS a_n73470_7802# nmos$3
Xnmos$3_486 a_n67599_4097# VSS VSS a_n67452_3878# nmos$3
Xnmos$2_1673 a_n67599_n5358# VSS a_n67138_n5289# SL_9N nmos$2
Xnmos$2_1651 a_n63077_n5358# VSS a_n62616_n5289# SL_12N nmos$2
Xnmos$2_1662 a_n61111_n3981# VSS ML_24 m1_n61014_n3773# nmos$2
Xnmos$2_1695 a_n67138_n1365# VSS ML_22 m1_n67041_n1157# nmos$2
Xnmos$2_1684 a_n64438_n3970# VSS SL_11 a_n64124_n3981# nmos$2
Xpmos_2203 OUTP VDD VDD a_n28089_17862# pmos
Xpmos_1502 a_n58411_23498# VDD VDD a_n58558_23717# pmos
Xpmos_2214 a_n27274_22670# VDD VDD a_n27618_22670# pmos
Xpmos_2247 a_n37485_19793# VDD a_n37338_19574# VDD pmos
Xpmos_2225 a_n34324_16958# VDD VDD a_n34471_17177# pmos
Xpmos_2236 a_n38843_16958# VDD VDD a_n38990_17177# pmos
Xpmos_2269 a_n35829_23498# VDD VDD a_n35976_23717# pmos
Xpmos_1513 a_n55557_23717# VDD a_n55410_23498# VDD pmos
Xpmos_2258 a_n37338_22190# VDD VDD a_n37485_22409# pmos
Xpmos_1524 a_n63077_19793# VDD a_n62930_19574# VDD pmos
Xpmos_1535 a_n67452_18266# VDD VDD a_n67599_18485# pmos
Xpmos_1568 a_n64438_24806# VDD VDD a_n64585_25025# pmos
Xpmos_1557 a_n63077_21101# VDD a_n62930_20882# VDD pmos
Xpmos_1546 a_n67452_20882# VDD VDD a_n67599_21101# pmos
Xpmos_706 a_n64585_n13206# VDD a_n64438_n13126# VDD pmos
Xpmos_717 a_n66090_n10590# VDD a_n65943_n10510# VDD pmos
Xpmos_1579 a_n65943_24806# VDD VDD a_n66090_25025# pmos
Xpmos_728 a_n63077_n10590# VDD a_n62930_n10510# VDD pmos
Xpmos_739 a_n63077_n6666# VDD a_n62930_n6586# VDD pmos
Xnmos$2_5 a_n38529_n28982# VSS a_n32313_n28669# m1_n38432_n28774# nmos$2
Xnmos$5_707 VEVAL VSS m1_n67041_21079# VSS nmos$5
Xnmos$5_718 VEVAL VSS m1_n64027_17155# VSS nmos$5
Xnmos$5_729 VEVAL VSS m1_n65532_25003# VSS nmos$5
Xnmos_281 a_n71961_n13126# VSS a_n72108_n13206# VSS nmos
Xnmos_270 a_n68957_n28971# VSS a_n69104_n29051# VSS nmos
Xnmos_292 a_n74975_n6586# VSS a_n75122_n6666# VSS nmos
Xnmos$3_250 a_n78135_173# VSS VSS a_n77988_n46# nmos$3
Xnmos$2_2182 a_n61111_11715# VSS ML_12 m1_n61014_11923# nmos$2
Xnmos$2_2171 a_n63077_10637# VSS a_n62616_10407# SL_12N nmos$2
Xnmos$2_2160 WL_13 VSS SL_11N a_n64585_10637# nmos$2
Xnmos$2_2193 WL_14 VSS a_n64438_9110# SL_11 nmos$2
Xnmos$3_272 a_n73617_173# VSS VSS a_n73470_n46# nmos$3
Xnmos$3_283 a_n72108_n2742# VSS VSS a_n71961_n2662# nmos$3
Xnmos$3_294 a_n60063_n11898# VSS VSS a_n59916_n11818# nmos$3
Xnmos$3_261 a_n70603_n5358# VSS VSS a_n70456_n5278# nmos$3
Xnmos$2_1470 a_n58558_n11898# VSS a_n58097_n11829# SL_15N nmos$2
Xnmos$2_1481 WL_28 VSS a_n56915_n9202# SL_16 nmos$2
Xnmos$2_1492 a_n60063_n7974# VSS a_n59602_n7905# SL_14N nmos$2
Xpmos_2011 a_n43365_13034# VDD VDD a_n43512_13253# pmos
Xpmos_2000 a_n46369_13034# VDD VDD a_n46516_13253# pmos
Xpmos_2055 a_n44870_22190# VDD VDD a_n45017_22409# pmos
Xpmos_2044 a_n44870_19574# VDD VDD a_n45017_19793# pmos
Xpmos_2022 a_n41856_16958# VDD VDD a_n42003_17177# pmos
Xpmos_2033 a_n44870_16958# VDD VDD a_n45017_17177# pmos
Xpmos_1310 a_n72108_17177# VDD a_n71961_16958# VDD pmos
Xpmos_2066 a_n41856_23498# VDD VDD a_n42003_23717# pmos
Xpmos_1343 a_n70603_22409# VDD a_n70456_22190# VDD pmos
Xpmos_1332 a_n72108_22409# VDD a_n71961_22190# VDD pmos
Xpmos_2077 a_n46516_19793# VDD a_n46369_19574# VDD pmos
Xpmos_2088 a_n53901_19574# VDD VDD a_n54048_19793# pmos
Xpmos_1321 a_n73470_18266# VDD VDD a_n73617_18485# pmos
Xpmos_1387 a_n81149_23717# VDD a_n81002_23498# VDD pmos
Xpmos_2099 a_n52543_21101# VDD a_n52396_20882# VDD pmos
Xpmos_1365 a_n75122_18485# VDD a_n74975_18266# VDD pmos
Xpmos_1376 a_n79497_18266# VDD VDD a_n79644_18485# pmos
Xpmos_1354 a_n76483_16958# VDD VDD a_n76630_17177# pmos
Xpmos_503 a_n81002_n13126# VDD VDD a_n81149_n13206# pmos
Xpmos_514 a_n78135_n10590# VDD a_n77988_n10510# VDD pmos
Xpmos_525 a_n79644_n7974# VDD a_n79497_n7894# VDD pmos
Xpmos_1398 a_n76630_21101# VDD a_n76483_20882# VDD pmos
Xpmos_569 a_n81149_n1434# VDD a_n81002_n1354# VDD pmos
Xpmos_536 a_n76483_n7894# VDD VDD a_n76630_n7974# pmos
Xpmos_558 a_n81149_n4050# VDD a_n81002_n3970# VDD pmos
Xpmos_547 a_n77988_n3970# VDD VDD a_n78135_n4050# pmos
Xnmos_1252 a_n27274_31298# VSS a_n27618_31298# VSS nmos
Xnmos_1241 a_n27618_31298# VSS m1_n27919_31310# VSS nmos
Xnmos_1230 OUTP VSS a_n28089_26490# VSS nmos
Xnmos_1263 a_n40351_20882# VSS a_n40498_21101# VSS nmos
Xnmos_1274 a_n40351_10418# VSS a_n40498_10637# VSS nmos
Xnmos_1296 a_n53901_1262# VSS a_n54048_1481# VSS nmos
Xnmos_1285 a_n56915_1262# VSS a_n57062_1481# VSS nmos
Xnmos$5_20 VEVAL VSS m1_n45958_n12929# VSS nmos$5
Xnmos$5_31 VEVAL VSS m1_n39940_n9005# VSS nmos$5
Xnmos$5_53 VEVAL VSS m1_n50477_n10313# VSS nmos$5
Xnmos$5_64 VEVAL VSS m1_n48972_n7697# VSS nmos$5
Xnmos$5_42 VEVAL VSS m1_n42954_n6389# VSS nmos$5
Xnmos$5_97 VEVAL VSS m1_n45958_151# VSS nmos$5
Xnmos$5_75 VEVAL VSS m1_n50477_n1157# VSS nmos$5
Xnmos$5_86 VEVAL VSS m1_n48972_n2465# VSS nmos$5
Xnmos$5_526 VEVAL VSS m1_n76072_6691# VSS nmos$5
Xnmos$5_504 VEVAL VSS m1_n76072_1459# VSS nmos$5
Xnmos$5_515 VEVAL VSS m1_n80591_1459# VSS nmos$5
Xnmos$5_559 VEVAL VSS m1_n77577_14539# VSS nmos$5
Xnmos$5_548 VEVAL VSS m1_n79086_11923# VSS nmos$5
Xnmos$5_537 VEVAL VSS m1_n74564_9307# VSS nmos$5
Xpmos$3_27 PC VDD ML_5 VDD pmos$3
Xpmos$3_16 PC VDD ML_15 VDD pmos$3
Xpmos_1140 a_n79497_2570# VDD VDD a_n79644_2789# pmos
Xpmos_1151 a_n79644_1481# VDD a_n79497_1262# VDD pmos
Xpmos_300 a_n35829_n9202# VDD VDD a_n35976_n9282# pmos
Xpmos_1184 a_n77988_11726# VDD VDD a_n78135_11945# pmos
Xpmos_1195 a_n81149_9329# VDD a_n81002_9110# VDD pmos
Xpmos_1162 a_n81149_8021# VDD a_n81002_7802# VDD pmos
Xpmos_1173 a_n76630_5405# VDD a_n76483_5186# VDD pmos
Xpmos_333 a_n38843_n1354# VDD VDD a_n38990_n1434# pmos
Xpmos_322 a_n38990_n4050# VDD a_n38843_n3970# VDD pmos
Xpmos_311 a_n35829_n3970# VDD VDD a_n35976_n4050# pmos
Xpmos_377 ML_23 VDD m2_n30953_n488# VDD pmos
Xpmos_344 a_n34324_n2662# VDD VDD a_n34471_n2742# pmos
Xpmos_355 a_n26151_n6090# VDD VDD a_n26495_n6090# pmos
Xpmos_366 OUTP VDD VDD a_n28089_n3708# pmos
Xnmos$2_4309 a_n54048_14561# VSS a_n53587_14331# SL_18N nmos$2
Xpmos_388 a_n27618_n338# VDD VDD m1_n27919_n326# pmos
Xpmos_399 a_n40351_n7894# VDD VDD a_n40498_n7974# pmos
Xnmos_1071 a_n44870_22190# VSS a_n45017_22409# VSS nmos
Xnmos$2_3608 a_n61425_20882# VSS SL_13 a_n61111_20871# nmos$2
Xnmos_1060 a_n41856_16958# VSS a_n42003_17177# VSS nmos
Xnmos_1082 a_n41856_23498# VSS a_n42003_23717# VSS nmos
Xnmos_1093 a_n53901_19574# VSS a_n54048_19793# VSS nmos
Xnmos$2_3619 WL_5 VSS a_n62930_20882# SL_12 nmos$2
Xnmos$2_2907 a_n67452_13034# VSS SL_9 a_n67138_13023# nmos$2
Xnmos$2_2929 a_n70603_15869# VSS a_n70142_15639# SL_7N nmos$2
Xnmos$2_2918 a_n68643_13023# VSS ML_11 m1_n68546_13231# nmos$2
Xnmos$2_518 a_n40351_n2662# VSS SL_27 a_n40037_n2673# nmos$2
Xnmos$2_507 a_n45017_n2742# VSS a_n44556_n2673# m2_n44135_352# nmos$2
Xnmos$3_1020 a_n38990_25025# VSS VSS a_n38843_24806# nmos$3
Xnmos$3_1042 a_n37485_1481# VSS VSS a_n37338_1262# nmos$3
Xnmos$3_1031 a_n46516_1481# VSS VSS a_n46369_1262# nmos$3
Xnmos$2_529 a_n46369_n10510# VSS SL_23 a_n46055_n10521# nmos$2
Xnmos$3_1053 a_n79644_1481# VSS VSS a_n79497_1262# nmos$3
Xnmos$2_4810 a_n47874_27422# VSS SL_22 a_n47560_27411# nmos$2
Xnmos$2_4843 a_n51035_27641# VSS a_n50574_27411# SL_20N nmos$2
Xnmos$2_4821 WL_1 VSS a_n46369_26114# SL_23 nmos$2
Xnmos$2_4832 a_n52082_24795# VSS ML_2 m1_n51985_25003# nmos$2
Xnmos$5_301 VEVAL VSS m1_n61014_n10313# VSS nmos$5
Xnmos$2_4876 a_n43512_27641# VSS a_n43051_27411# SL_25N nmos$2
Xnmos$2_4854 a_n54048_26333# VSS a_n53587_26103# SL_18N nmos$2
Xnmos$2_4865 a_n40498_25025# VSS a_n40037_24795# SL_27N nmos$2
Xnmos$5_323 VEVAL VSS m1_n64027_n10313# VSS nmos$5
Xnmos$5_312 VEVAL VSS m1_n67041_n6389# VSS nmos$5
Xnmos$5_334 VEVAL VSS m1_n65532_n3773# VSS nmos$5
Xnmos$2_4887 a_n41542_26103# VSS ML_1 m1_n41445_26311# nmos$2
Xnmos$2_4898 a_n43051_24795# VSS ML_2 m1_n42954_25003# nmos$2
Xnmos$5_367 VEVAL VSS m1_n54999_151# VSS nmos$5
Xnmos$5_345 VEVAL VSS m1_n65532_n2465# VSS nmos$5
Xnmos$5_356 VEVAL VSS m1_n58000_n5081# VSS nmos$5
Xnmos$5_389 VEVAL VSS m1_n58000_7999# VSS nmos$5
Xnmos$5_378 VEVAL VSS m1_n58000_1459# VSS nmos$5
Xpmos$1_9 OUTP VDD a_n27274_n8966# m1_n28364_n9043# pmos$1
Xnmos$5_890 VEVAL VSS m1_n45958_13231# VSS nmos$5
Xnmos$2_10 a_n34010_n28982# VSS a_n32313_n28669# m1_n33913_n28774# nmos$2
Xnmos$2_32 a_n45017_n29051# VSS a_n44556_n28982# PSL_24N nmos$2
Xnmos$2_21 a_n44870_n28971# VSS PSL_24 a_n44556_n28982# nmos$2
Xnmos$2_43 a_n49069_n28982# VSS a_n32313_n28669# m1_n48972_n28774# nmos$2
Xnmos$2_76 WL_31 VSS SL_25N a_n43512_n13206# nmos$2
Xnmos$2_65 a_n49530_n29051# VSS a_n49069_n28982# PSL_21N nmos$2
Xnmos$2_54 WL VSS PSL_19N a_n52543_n29051# nmos$2
Xnmos$2_87 WL_30 VSS a_n41856_n11818# SL_26 nmos$2
Xnmos$2_98 a_n40037_n10521# VSS ML_29 m1_n39940_n10313# nmos$2
Xpmos_152 a_n53901_n2662# VDD VDD a_n54048_n2742# pmos
Xpmos_130 a_n48021_n6666# VDD a_n47874_n6586# VDD pmos
Xpmos_141 a_n52543_n4050# VDD a_n52396_n3970# VDD pmos
Xnmos_825 a_n56915_27422# VSS a_n57062_27641# VSS nmos
Xnmos_814 a_n61425_27422# VSS a_n61572_27641# VSS nmos
Xnmos_803 a_n64438_23498# VSS a_n64585_23717# VSS nmos
Xpmos_163 a_n49530_n1434# VDD a_n49383_n1354# VDD pmos
Xpmos_185 a_n43365_n5278# VDD VDD a_n43512_n5358# pmos
Xpmos_174 a_n50888_n3970# VDD VDD a_n51035_n4050# pmos
Xnmos_869 a_n27618_8290# VSS m1_n27919_8302# VSS nmos
Xnmos$2_4106 WL_15 VSS SL_27N a_n40498_8021# nmos$2
Xnmos_858 a_n26495_5414# VSS m1_n26796_5426# VSS nmos
Xnmos$2_4128 WL_18 VSS a_n49383_3878# SL_21 nmos$2
Xnmos_847 ML_20 VSS VSS a_n28485_2636# nmos
Xnmos$2_4117 a_n47560_2559# VSS ML_19 m1_n47463_2767# nmos$2
Xnmos_836 a_n27618_2538# VSS m1_n27919_2550# VSS nmos
Xpmos_196 a_n46369_n6586# VDD VDD a_n46516_n6666# pmos
Xnmos$2_3427 a_n58558_19793# VSS a_n58097_19563# SL_15N nmos$2
Xnmos$2_3405 a_n58097_16947# VSS ML_8 m1_n58000_17155# nmos$2
Xnmos$2_3416 WL_8 VSS SL_14N a_n60063_17177# nmos$2
Xnmos$2_4139 a_n51035_2789# VSS a_n50574_2559# SL_20N nmos$2
Xnmos$2_3438 a_n58558_21101# VSS a_n58097_20871# SL_15N nmos$2
Xnmos$2_3449 WL_4 VSS SL_14N a_n60063_22409# nmos$2
Xnmos$3_805 a_n34471_14561# VSS VSS a_n34324_14342# nmos$3
Xnmos$2_2715 WL_13 VSS a_n81002_10418# SL_0 nmos$2
Xnmos$2_2704 a_n79497_9110# VSS SL_1 a_n79183_9099# nmos$2
Xnmos$3_816 a_n43512_6713# VSS VSS a_n43365_6494# nmos$3
Xnmos$2_2737 WL_11 VSS a_n77988_13034# SL_2 nmos$2
Xnmos$2_2748 WL_11 VSS a_n81002_13034# SL_0 nmos$2
Xnmos$2_2726 a_n79183_11715# VSS ML_12 m1_n79086_11923# nmos$2
Xnmos$3_827 a_n40498_8021# VSS VSS a_n40351_7802# nmos$3
Xnmos$3_849 a_n46516_8021# VSS VSS a_n46369_7802# nmos$3
Xnmos$3_838 a_n51035_5405# VSS VSS a_n50888_5186# nmos$3
Xnmos$2_326 a_n52396_n5278# VSS SL_19 a_n52082_n5289# nmos$2
Xnmos$2_304 a_n49383_n5278# VSS SL_21 a_n49069_n5289# nmos$2
Xnmos$2_315 a_n48021_n4050# VSS a_n47560_n3981# SL_22N nmos$2
Xnmos$2_2759 a_n79644_15869# VSS a_n79183_15639# SL_1N nmos$2
Xnmos$2_359 WL_21 VSS SL_20N a_n51035_173# nmos$2
Xnmos$2_348 a_n52082_n1365# VSS ML_22 m1_n51985_n1157# nmos$2
Xnmos$2_337 a_n50888_n3970# VSS SL_20 a_n50574_n3981# nmos$2
Xpmos_1909 a_n50888_1262# VDD VDD a_n51035_1481# pmos
Xnmos$2_4651 a_n40498_23717# VSS a_n40037_23487# SL_27N nmos$2
Xnmos$2_4640 a_n41542_20871# VSS ML_5 m1_n41445_21079# nmos$2
Xnmos$2_4684 WL_6 VSS a_n47874_19574# SL_22 nmos$2
Xnmos$2_4673 a_n49069_18255# VSS ML_7 m1_n48972_18463# nmos$2
Xnmos$2_4662 WL_8 VSS SL_22N a_n48021_17177# nmos$2
Xnmos$5_120 VEVAL VSS m1_n38432_n11621# VSS nmos$5
Xnmos$5_131 VEVAL VSS m1_n35418_n9005# VSS nmos$5
Xnmos$5_142 VEVAL VSS m1_n38432_n3773# VSS nmos$5
Xnmos$2_4695 a_n51035_17177# VSS a_n50574_16947# SL_20N nmos$2
Xnmos$2_3983 a_n35515_15639# VSS ML_9 m1_n35418_15847# nmos$2
Xnmos$2_3961 a_n37338_15650# VSS SL_29 a_n37024_15639# nmos$2
Xnmos$2_3972 WL_10 VSS SL_30N a_n35976_14561# nmos$2
Xnmos$2_3950 a_n38990_13253# VSS a_n38529_13023# SL_28N nmos$2
Xnmos$5_153 VEVAL VSS m1_n38432_n2465# VSS nmos$5
Xnmos$5_175 VEVAL VSS m1_n70045_n12929# VSS nmos$5
Xnmos$5_164 VEVAL VSS m1_n65532_n28774# VSS nmos$5
Xnmos$5_186 VEVAL VSS m1_n71550_n9005# VSS nmos$5
Xnmos$2_3994 WL_14 VSS a_n35829_9110# SL_30 nmos$2
Xnmos$5_197 VEVAL VSS m1_n68546_n6389# VSS nmos$5
Xnmos$2_871 a_n75122_n29051# VSS a_n74661_n28982# PSL_4N nmos$2
Xnmos$2_882 a_n74975_n28971# VSS PSL_4 a_n74661_n28982# nmos$2
Xnmos$2_860 a_n73470_n28971# VSS PSL_5 a_n73156_n28982# nmos$2
Xnmos$2_893 WL VSS PSL_0N a_n81149_n29051# nmos$2
Xnmos_600 a_n76483_3878# VSS a_n76630_4097# VSS nmos
Xnmos_633 a_n81002_15650# VSS a_n81149_15869# VSS nmos
Xnmos_622 a_n76483_11726# VSS a_n76630_11945# VSS nmos
Xnmos_611 a_n76483_5186# VSS a_n76630_5405# VSS nmos
Xnmos$2_3202 a_n77674_22179# VSS ML_4 m1_n77577_22387# nmos$2
Xnmos_677 a_n71961_16958# VSS a_n72108_17177# VSS nmos
Xnmos_666 a_n68957_13034# VSS a_n69104_13253# VSS nmos
Xnmos_655 a_n73470_11726# VSS a_n73617_11945# VSS nmos
Xnmos_644 a_n70456_9110# VSS a_n70603_9329# VSS nmos
Xnmos$2_3235 WL_2 VSS SL_2N a_n78135_25025# nmos$2
Xnmos_699 a_n70456_23498# VSS a_n70603_23717# VSS nmos
Xnmos$2_3224 WL_3 VSS SL_3N a_n76630_23717# nmos$2
Xnmos_688 a_n74975_22190# VSS a_n75122_22409# VSS nmos
Xnmos$2_3213 WL_5 VSS SL_2N a_n78135_21101# nmos$2
Xnmos$2_3246 a_n74975_27422# VSS SL_4 a_n74661_27411# nmos$2
Xnmos$2_3257 a_n74975_26114# VSS SL_4 a_n74661_26103# nmos$2
Xnmos$2_3268 WL_2 VSS a_n81002_24806# SL_0 nmos$2
Xnmos$3_613 a_n72108_23717# VSS VSS a_n71961_23498# nmos$3
Xnmos$3_602 a_n72108_18485# VSS VSS a_n71961_18266# nmos$3
Xnmos$3_624 a_n75122_18485# VSS VSS a_n74975_18266# nmos$3
Xnmos$2_2501 WL_15 VSS SL_4N a_n75122_8021# nmos$2
Xnmos$2_2523 WL_16 VSS SL_7N a_n70603_6713# nmos$2
Xnmos$2_2512 a_n67452_5186# VSS SL_9 a_n67138_5175# nmos$2
Xnmos$2_101 a_n42003_n11898# VSS a_n41542_n11829# SL_26N nmos$2
Xnmos$3_657 a_n76630_27641# VSS VSS a_n76483_27422# nmos$3
Xnmos$2_3279 a_n77988_27422# VSS SL_2 a_n77674_27411# nmos$2
Xnmos$3_668 a_n67599_26333# VSS VSS a_n67452_26114# nmos$3
Xnmos$3_646 a_n78135_23717# VSS VSS a_n77988_23498# nmos$3
Xnmos$3_635 a_n79644_19793# VSS VSS a_n79497_19574# nmos$3
Xnmos$2_2534 WL_15 VSS a_n70456_7802# SL_7 nmos$2
Xnmos$2_2545 WL_17 VSS a_n68957_5186# SL_8 nmos$2
Xnmos$2_2567 a_n74661_3867# VSS ML_18 m1_n74564_4075# nmos$2
Xnmos$2_2556 a_n78135_2789# VSS a_n77674_2559# SL_2N nmos$2
Xnmos$2_1822 WL_21 VSS SL_15N a_n58558_173# nmos$2
Xnmos$2_1811 a_n60063_n1434# VSS a_n59602_n1365# SL_14N nmos$2
Xnmos$2_112 a_n44870_n13126# VSS SL_24 a_n44556_n13137# nmos$2
Xnmos$2_134 a_n44556_n11829# VSS ML_30 m1_n44459_n11621# nmos$2
Xnmos$2_123 WL_30 VSS m2_n44135_352# a_n45017_n11898# nmos$2
Xnmos$2_1800 WL_24 VSS a_n58411_n3970# SL_15 nmos$2
Xnmos$3_679 a_n73617_26333# VSS VSS a_n73470_26114# nmos$3
Xnmos$2_2589 WL_18 VSS SL_1N a_n79644_4097# nmos$2
Xnmos$2_2578 a_n81149_2789# VSS a_n80688_2559# SL_0N nmos$2
Xnmos$2_1844 WL_21 VSS SL_17N a_n55557_173# nmos$2
Xnmos$2_1833 a_n55410_n1354# VSS SL_17 a_n55096_n1365# nmos$2
Xnmos$2_1855 WL_23 VSS a_n58411_n2662# SL_15 nmos$2
Xnmos$2_145 a_n46516_n9282# VSS a_n46055_n9213# SL_23N nmos$2
Xnmos$2_167 WL_28 VSS a_n41856_n9202# SL_26 nmos$2
Xnmos$2_156 a_n44556_n7905# VSS ML_27 m1_n44459_n7697# nmos$2
Xnmos$2_178 WL_27 VSS SL_26N a_n42003_n7974# nmos$2
Xnmos$2_1866 a_n55557_n2742# VSS a_n55096_n2673# SL_17N nmos$2
Xnmos$2_189 WL_31 VSS SL_21N a_n49530_n13206# nmos$2
Xnmos$2_1888 a_n58411_n6586# VSS SL_15 a_n58097_n6597# nmos$2
Xnmos$2_1877 a_n53901_n6586# VSS SL_18 a_n53587_n6597# nmos$2
Xnmos$2_1899 a_n64438_n6586# VSS SL_11 a_n64124_n6597# nmos$2
Xpmos_1717 a_n34471_9329# VDD a_n34324_9110# VDD pmos
Xpmos_1706 a_n37485_8021# VDD a_n37338_7802# VDD pmos
Xpmos_1739 a_n37485_11945# VDD a_n37338_11726# VDD pmos
Xpmos_1728 a_n38843_9110# VDD VDD a_n38990_9329# pmos
Xnmos$2_5171 a_n52543_1481# VSS a_n52082_1251# SL_19N nmos$2
Xnmos$2_5160 a_n76483_1262# VSS SL_3 a_n76169_1251# nmos$2
Xnmos$2_5182 a_n40351_1262# VSS SL_27 a_n40037_1251# nmos$2
Xnmos$2_5193 WL_20 VSS SL_26N a_n42003_1481# nmos$2
Xnmos$2_4492 a_n43512_15869# VSS a_n43051_15639# SL_25N nmos$2
Xnmos$2_4470 WL_10 VSS SL_26N a_n42003_14561# nmos$2
Xnmos$2_4481 WL_11 VSS a_n40351_13034# SL_27 nmos$2
Xnmos$2_3791 a_n35515_3867# VSS ML_18 m1_n35418_4075# nmos$2
Xnmos$2_3780 a_n34010_2559# VSS ML_19 m1_n33913_2767# nmos$2
Xnmos$2_690 a_n35976_n5358# VSS a_n35515_n5289# SL_30N nmos$2
Xnmos$2_1107 a_n77988_n7894# VSS SL_2 a_n77674_n7905# nmos$2
Xnmos$2_1118 WL_28 VSS a_n76483_n9202# SL_3 nmos$2
Xnmos$2_1129 a_n76630_n7974# VSS a_n76169_n7905# SL_3N nmos$2
Xpmos$1_82 OUTP VDD a_n27274_16918# m1_n28364_16841# pmos$1
Xpmos$1_71 a_n28089_14986# VDD m1_n27919_15492# a_n27274_15480# pmos$1
Xpmos$1_60 OUTP VDD m1_n26796_9740# a_n26151_9728# pmos$1
Xpmos$1_93 a_n28089_20738# VDD m1_n27919_21244# a_n27274_21232# pmos$1
Xnmos_441 a_n65943_n46# VSS a_n66090_173# VSS nmos
Xnmos_452 a_n65943_n2662# VSS a_n66090_n2742# VSS nmos
Xnmos_430 a_n64438_n5278# VSS a_n64585_n5358# VSS nmos
Xnmos$2_3010 WL_6 VSS a_n71961_19574# SL_6 nmos$2
Xnmos_485 a_n59916_7802# VSS a_n60063_8021# VSS nmos
Xnmos_474 a_n56915_2570# VSS a_n57062_2789# VSS nmos
Xnmos_463 a_n59916_n46# VSS a_n60063_173# VSS nmos
Xnmos$2_3043 a_n72108_23717# VSS a_n71647_23487# SL_6N nmos$2
Xnmos$2_3021 a_n71961_20882# VSS SL_6 a_n71647_20871# nmos$2
Xnmos$2_3032 a_n73470_20882# VSS SL_5 a_n73156_20871# nmos$2
Xnmos_496 a_n64438_3878# VSS a_n64585_4097# VSS nmos
Xnmos$2_3076 WL_3 VSS SL_7N a_n70603_23717# nmos$2
Xnmos$2_3065 a_n70603_21101# VSS a_n70142_20871# SL_7N nmos$2
Xnmos$2_3054 a_n67452_20882# VSS SL_9 a_n67138_20871# nmos$2
Xnmos$3_443 a_n66090_14561# VSS VSS a_n65943_14342# nmos$3
Xnmos$2_2320 a_n55096_11715# VSS ML_12 m1_n54999_11923# nmos$2
Xnmos$2_2331 WL_13 VSS a_n56915_10418# SL_16 nmos$2
Xnmos$2_2342 a_n59916_10418# VSS SL_14 a_n59602_10407# nmos$2
Xnmos$3_432 a_n63077_10637# VSS VSS a_n62930_10418# nmos$3
Xnmos$3_421 a_n66090_8021# VSS VSS a_n65943_7802# nmos$3
Xnmos$3_410 a_n63077_2789# VSS VSS a_n62930_2570# nmos$3
Xnmos$2_3087 a_n76630_17177# VSS a_n76169_16947# SL_3N nmos$2
Xnmos$2_3098 a_n76169_16947# VSS ML_8 m1_n76072_17155# nmos$2
Xnmos$3_476 a_n58558_14561# VSS VSS a_n58411_14342# nmos$3
Xnmos$2_2375 WL_10 VSS a_n59916_14342# SL_14 nmos$2
Xnmos$2_2364 WL_11 VSS a_n56915_13034# SL_16 nmos$2
Xnmos$2_2353 WL_12 VSS a_n56915_11726# SL_16 nmos$2
Xnmos$3_454 a_n54048_9329# VSS VSS a_n53901_9110# nmos$3
Xnmos$3_465 a_n58558_9329# VSS VSS a_n58411_9110# nmos$3
Xnmos$2_1630 a_n62616_n9213# VSS ML_28 m1_n62519_n9005# nmos$2
Xnmos$2_2386 a_n58558_15869# VSS a_n58097_15639# SL_15N nmos$2
Xnmos$2_2397 WL_11 VSS SL_16N a_n57062_13253# nmos$2
Xnmos$3_498 a_n72108_8021# VSS VSS a_n71961_7802# nmos$3
Xnmos$3_487 a_n69104_2789# VSS VSS a_n68957_2570# nmos$3
Xnmos$2_1641 a_n61111_n7905# VSS ML_27 m1_n61014_n7697# nmos$2
Xnmos$2_1652 WL_25 VSS SL_11N a_n64585_n5358# nmos$2
Xnmos$2_1663 WL_24 VSS a_n61425_n3970# SL_13 nmos$2
Xnmos$2_1696 WL_22 VSS SL_9N a_n67599_n1434# nmos$2
Xnmos$2_1674 a_n67138_n5289# VSS ML_25 m1_n67041_n5081# nmos$2
Xnmos$2_1685 WL_24 VSS SL_10N a_n66090_n4050# nmos$2
Xpmos_2204 ML_7 VDD a_n28485_21330# VDD pmos
Xpmos_2215 a_n27618_22670# VDD VDD m1_n27919_22682# pmos
Xpmos_2226 a_n34471_17177# VDD a_n34324_16958# VDD pmos
Xpmos_2237 a_n38990_17177# VDD a_n38843_16958# VDD pmos
Xpmos_2259 a_n37338_23498# VDD VDD a_n37485_23717# pmos
Xpmos_1514 a_n56915_23498# VDD VDD a_n57062_23717# pmos
Xpmos_1503 a_n57062_23717# VDD a_n56915_23498# VDD pmos
Xpmos_1525 a_n63077_18485# VDD a_n62930_18266# VDD pmos
Xpmos_2248 a_n37485_17177# VDD a_n37338_16958# VDD pmos
Xpmos_1569 a_n63077_25025# VDD a_n62930_24806# VDD pmos
Xpmos_1558 a_n64438_22190# VDD VDD a_n64585_22409# pmos
Xpmos_1547 a_n67452_22190# VDD VDD a_n67599_22409# pmos
Xpmos_1536 a_n67452_19574# VDD VDD a_n67599_19793# pmos
Xpmos_707 a_n66090_n13206# VDD a_n65943_n13126# VDD pmos
Xpmos_718 a_n67452_n9202# VDD VDD a_n67599_n9282# pmos
Xpmos_729 a_n64438_n9202# VDD VDD a_n64585_n9282# pmos
Xnmos$2_6 a_n35976_n29051# VSS a_n35515_n28982# PSL_30N nmos$2
Xnmos$5_708 VEVAL VSS m1_n67041_22387# VSS nmos$5
Xnmos$5_719 VEVAL VSS m1_n64027_23695# VSS nmos$5
Xnmos_260 a_n58411_n28971# VSS a_n58558_n29051# VSS nmos
Xnmos_282 a_n74975_n13126# VSS a_n75122_n13206# VSS nmos
Xnmos_271 a_n77988_n28971# VSS a_n78135_n29051# VSS nmos
Xnmos_293 a_n74975_n7894# VSS a_n75122_n7974# VSS nmos
Xnmos$2_2150 a_n61425_10418# VSS SL_13 a_n61111_10407# nmos$2
Xnmos$3_251 a_n75122_n1434# VSS VSS a_n74975_n1354# nmos$3
Xnmos$3_240 a_n79644_n5358# VSS VSS a_n79497_n5278# nmos$3
Xnmos$2_2172 WL_12 VSS SL_11N a_n64585_11945# nmos$2
Xnmos$2_2183 WL_14 VSS SL_12N a_n63077_9329# nmos$2
Xnmos$2_2161 WL_14 VSS SL_11N a_n64585_9329# nmos$2
Xnmos$3_273 a_n72108_173# VSS VSS a_n71961_n46# nmos$3
Xnmos$3_284 a_n69104_n2742# VSS VSS a_n68957_n2662# nmos$3
Xnmos$3_262 a_n70603_n4050# VSS VSS a_n70456_n3970# nmos$3
Xnmos$2_2194 a_n64438_9110# VSS SL_11 a_n64124_9099# nmos$2
Xnmos$2_1460 WL_30 VSS SL_14N a_n60063_n11898# nmos$2
Xnmos$2_1471 a_n58558_n10590# VSS a_n58097_n10521# SL_15N nmos$2
Xnmos$3_295 a_n57062_n10590# VSS VSS a_n56915_n10510# nmos$3
Xnmos$2_1482 WL_28 VSS SL_15N a_n58558_n9282# nmos$2
Xnmos$2_1493 WL_27 VSS a_n59916_n7894# SL_14 nmos$2
Xpmos_2001 a_n46369_15650# VDD VDD a_n46516_15869# pmos
Xpmos_2012 a_n42003_13253# VDD a_n41856_13034# VDD pmos
Xpmos_2045 a_n44870_20882# VDD VDD a_n45017_21101# pmos
Xpmos_1300 a_n70603_18485# VDD a_n70456_18266# VDD pmos
Xpmos_2023 a_n42003_17177# VDD a_n41856_16958# VDD pmos
Xpmos_2034 a_n43512_17177# VDD a_n43365_16958# VDD pmos
Xpmos_2067 a_n40498_23717# VDD a_n40351_23498# VDD pmos
Xpmos_2056 a_n43512_23717# VDD a_n43365_23498# VDD pmos
Xpmos_1344 a_n70603_23717# VDD a_n70456_23498# VDD pmos
Xpmos_1333 a_n71961_22190# VDD VDD a_n72108_22409# pmos
Xpmos_2089 a_n52543_19793# VDD a_n52396_19574# VDD pmos
Xpmos_2078 a_n46516_18485# VDD a_n46369_18266# VDD pmos
Xpmos_1322 a_n73470_16958# VDD VDD a_n73617_17177# pmos
Xpmos_1311 a_n73617_17177# VDD a_n73470_16958# VDD pmos
Xpmos_1377 a_n79497_19574# VDD VDD a_n79644_19793# pmos
Xpmos_1355 a_n75122_17177# VDD a_n74975_16958# VDD pmos
Xpmos_1366 a_n79497_16958# VDD VDD a_n79644_17177# pmos
Xpmos_504 a_n81149_n13206# VDD a_n81002_n13126# VDD pmos
Xpmos_526 a_n75122_n10590# VDD a_n74975_n10510# VDD pmos
Xpmos_515 a_n81149_n9282# VDD a_n81002_n9202# VDD pmos
Xpmos_1388 a_n81002_22190# VDD VDD a_n81149_22409# pmos
Xpmos_1399 a_n77988_20882# VDD VDD a_n78135_21101# pmos
Xpmos_537 a_n75122_n7974# VDD a_n74975_n7894# VDD pmos
Xpmos_559 a_n81002_n3970# VDD VDD a_n81149_n4050# pmos
Xpmos_548 a_n75122_n4050# VDD a_n74975_n3970# VDD pmos
Xnmos_1220 a_n38843_24806# VSS a_n38990_25025# VSS nmos
Xnmos_1242 a_n28485_31396# VSS VSS m1_n28364_31221# nmos
Xnmos_1253 a_n27618_29860# VSS m1_n27919_29872# VSS nmos
Xnmos_1231 a_n26495_25546# VSS m1_n26796_25558# VSS nmos
Xnmos_1264 a_n40351_22190# VSS a_n40498_22409# VSS nmos
Xnmos_1275 a_n40351_11726# VSS a_n40498_11945# VSS nmos
Xnmos_1297 a_n49383_1262# VSS a_n49530_1481# VSS nmos
Xnmos_1286 a_n65943_1262# VSS a_n66090_1481# VSS nmos
Xnmos$5_10 VEVAL VSS m1_n48972_n28774# VSS nmos$5
Xnmos$5_21 VEVAL VSS m1_n45958_n10313# VSS nmos$5
Xnmos$5_43 VEVAL VSS m1_n47463_n12929# VSS nmos$5
Xnmos$5_54 VEVAL VSS m1_n50477_n11621# VSS nmos$5
Xnmos$5_32 VEVAL VSS m1_n41445_n9005# VSS nmos$5
Xnmos$5_65 VEVAL VSS m1_n47463_n6389# VSS nmos$5
Xnmos$5_98 VEVAL VSS m1_n44459_151# VSS nmos$5
Xnmos$5_76 VEVAL VSS m1_n51985_n1157# VSS nmos$5
Xnmos$5_87 VEVAL VSS m1_n39940_n5081# VSS nmos$5
Xnmos$5_516 VEVAL VSS m1_n80591_2767# VSS nmos$5
Xnmos$5_505 VEVAL VSS m1_n74564_1459# VSS nmos$5
Xnmos$5_549 VEVAL VSS m1_n79086_14539# VSS nmos$5
Xnmos$5_538 VEVAL VSS m1_n77577_9307# VSS nmos$5
Xnmos$5_527 VEVAL VSS m1_n76072_5383# VSS nmos$5
Xpmos$3_28 PC VDD ML_4 VDD pmos$3
Xpmos$3_17 PC VDD ML_16 VDD pmos$3
Xnmos$2_1290 a_n71647_n3981# VSS ML_24 m1_n71550_n3773# nmos$2
Xpmos_1130 a_n76630_2789# VDD a_n76483_2570# VDD pmos
Xpmos_1152 a_n79644_2789# VDD a_n79497_2570# VDD pmos
Xpmos_1141 a_n78135_1481# VDD a_n77988_1262# VDD pmos
Xpmos_301 a_n34471_n9282# VDD a_n34324_n9202# VDD pmos
Xpmos_1185 a_n76630_11945# VDD a_n76483_11726# VDD pmos
Xpmos_1163 a_n78135_8021# VDD a_n77988_7802# VDD pmos
Xpmos_1174 a_n77988_5186# VDD VDD a_n78135_5405# pmos
Xpmos_334 a_n38990_n1434# VDD a_n38843_n1354# VDD pmos
Xpmos_323 a_n38843_n3970# VDD VDD a_n38990_n4050# pmos
Xpmos_312 a_n34471_n4050# VDD a_n34324_n3970# VDD pmos
Xpmos_1196 a_n81002_11726# VDD VDD a_n81149_11945# pmos
Xpmos_345 a_n34324_n1354# VDD VDD a_n34471_n1434# pmos
Xpmos_356 a_n26495_n6090# VDD VDD m1_n26796_n6078# pmos
Xpmos_367 a_n26495_n4652# VDD VDD m1_n26796_n4640# pmos
Xpmos_389 m2_n30953_740# VDD m1_n28364_n415# VDD pmos
Xpmos_378 ML_22 VDD m2_n30953_740# VDD pmos
Xnmos$2_3609 WL_5 VSS a_n61425_20882# SL_13 nmos$2
Xnmos_1061 a_n43365_18266# VSS a_n43512_18485# VSS nmos
Xnmos_1050 a_n46369_13034# VSS a_n46516_13253# VSS nmos
Xnmos_1072 a_n44870_20882# VSS a_n45017_21101# VSS nmos
Xnmos_1094 a_n52396_19574# VSS a_n52543_19793# VSS nmos
Xnmos_1083 a_n47874_18266# VSS a_n48021_18485# VSS nmos
Xnmos$2_2908 a_n67452_14342# VSS SL_9 a_n67138_14331# nmos$2
Xnmos$2_2919 a_n70603_13253# VSS a_n70142_13023# SL_7N nmos$2
Xnmos$2_508 WL_23 VSS m2_n44135_352# a_n45017_n2742# nmos$2
Xnmos$3_1021 a_n38990_27641# VSS VSS a_n38843_27422# nmos$3
Xnmos$3_1010 a_n34471_21101# VSS VSS a_n34324_20882# nmos$3
Xnmos$3_1032 a_n48021_1481# VSS VSS a_n47874_1262# nmos$3
Xnmos$2_519 a_n44556_n2673# VSS ML_23 m1_n44459_n2465# nmos$2
Xnmos$3_1043 a_n35976_1481# VSS VSS a_n35829_1262# nmos$3
Xnmos$3_1054 a_n78135_1481# VSS VSS a_n77988_1262# nmos$3
Xnmos$2_4800 WL_2 VSS SL_21N a_n49530_25025# nmos$2
Xpmos_890 a_n58558_5405# VDD a_n58411_5186# VDD pmos
Xnmos$2_4811 a_n48021_27641# VSS a_n47560_27411# SL_22N nmos$2
Xnmos$2_4822 a_n48021_26333# VSS a_n47560_26103# SL_22N nmos$2
Xnmos$2_4833 a_n54048_25025# VSS a_n53587_24795# SL_18N nmos$2
Xnmos$2_4844 a_n50574_27411# VSS ML_0 m1_n50477_27619# nmos$2
Xnmos$2_4855 WL_1 VSS SL_18N a_n54048_26333# nmos$2
Xnmos$2_4866 WL_2 VSS SL_27N a_n40498_25025# nmos$2
Xnmos$5_335 VEVAL VSS m1_n65532_n1157# VSS nmos$5
Xnmos$5_302 VEVAL VSS m1_n61014_n11621# VSS nmos$5
Xnmos$5_324 VEVAL VSS m1_n64027_n9005# VSS nmos$5
Xnmos$5_313 VEVAL VSS m1_n65532_n6389# VSS nmos$5
Xnmos$2_4888 a_n42003_27641# VSS a_n41542_27411# SL_26N nmos$2
Xnmos$2_4877 WL_0 VSS a_n41856_27422# SL_26 nmos$2
Xnmos$2_4899 a_n43365_24806# VSS SL_25 a_n43051_24795# nmos$2
Xnmos$5_368 VEVAL VSS m1_n54999_n2465# VSS nmos$5
Xnmos$5_346 VEVAL VSS m1_n64027_n2465# VSS nmos$5
Xnmos$5_357 VEVAL VSS m1_n59505_n5081# VSS nmos$5
Xnmos$5_379 VEVAL VSS m1_n58000_2767# VSS nmos$5
Xnmos$5_880 VEVAL VSS m1_n41445_11923# VSS nmos$5
Xnmos$5_891 VEVAL VSS m1_n45958_14539# VSS nmos$5
Xnmos$2_11 a_n34471_n29051# VSS a_n34010_n28982# PSL_31N nmos$2
Xnmos$2_22 WL VSS a_n40351_n28971# PSL_27 nmos$2
Xnmos$2_33 a_n46055_n28982# VSS a_n32313_n28669# m1_n45958_n28774# nmos$2
Xnmos$2_44 a_n51035_n29051# VSS a_n50574_n28982# PSL_20N nmos$2
Xnmos$2_77 a_n41856_n13126# VSS SL_26 a_n41542_n13137# nmos$2
Xnmos$2_66 a_n46369_n28971# VSS PSL_23 a_n46055_n28982# nmos$2
Xnmos$2_55 a_n50888_n28971# VSS PSL_20 a_n50574_n28982# nmos$2
Xnmos$2_88 WL_29 VSS SL_26N a_n42003_n10590# nmos$2
Xnmos$2_99 a_n40351_n10510# VSS SL_27 a_n40037_n10521# nmos$2
Xpmos_120 a_n46516_n5358# VDD a_n46369_n5278# VDD pmos
Xpmos_142 a_n53901_n3970# VDD VDD a_n54048_n4050# pmos
Xpmos_131 a_n48021_n4050# VDD a_n47874_n3970# VDD pmos
Xnmos_826 a_n55410_27422# VSS a_n55557_27641# VSS nmos
Xnmos_815 a_n65943_24806# VSS a_n66090_25025# VSS nmos
Xnmos_804 a_n62930_23498# VSS a_n63077_23717# VSS nmos
Xpmos_153 a_n52543_173# VDD a_n52396_n46# VDD pmos
Xpmos_164 a_n49530_n2742# VDD a_n49383_n2662# VDD pmos
Xpmos_175 a_n50888_n2662# VDD VDD a_n51035_n2742# pmos
Xnmos$2_4107 WL_15 VSS SL_26N a_n42003_8021# nmos$2
Xnmos_859 a_n26151_5414# VSS a_n26495_5414# VSS nmos
Xnmos_837 a_n28485_4074# VSS VSS m1_n28364_3899# nmos
Xnmos$2_4129 a_n49530_4097# VSS a_n49069_3867# SL_21N nmos$2
Xnmos$2_4118 WL_19 VSS a_n46369_2570# SL_23 nmos$2
Xnmos_848 ML_21 VSS VSS a_n28485_1198# nmos
Xpmos_197 a_n46369_n5278# VDD VDD a_n46516_n5358# pmos
Xpmos_186 a_n42003_n4050# VDD a_n41856_n3970# VDD pmos
Xnmos$2_3406 a_n58097_18255# VSS ML_7 m1_n58000_18463# nmos$2
Xnmos$2_3417 a_n60063_18485# VSS a_n59602_18255# SL_14N nmos$2
Xnmos$2_3439 a_n58411_22190# VSS SL_15 a_n58097_22179# nmos$2
Xnmos$2_3428 WL_6 VSS SL_15N a_n58558_19793# nmos$2
Xnmos$3_806 a_n34471_13253# VSS VSS a_n34324_13034# nmos$3
Xnmos$2_2716 WL_12 VSS SL_0N a_n81149_11945# nmos$2
Xnmos$2_2705 WL_14 VSS SL_1N a_n79644_9329# nmos$2
Xnmos$3_817 a_n43512_5405# VSS VSS a_n43365_5186# nmos$3
Xnmos$2_2738 a_n77988_14342# VSS SL_2 a_n77674_14331# nmos$2
Xnmos$2_2749 a_n81002_13034# VSS SL_0 a_n80688_13023# nmos$2
Xnmos$2_2727 WL_14 VSS a_n79497_9110# SL_1 nmos$2
Xnmos$3_839 a_n51035_6713# VSS VSS a_n50888_6494# nmos$3
Xnmos$3_828 a_n46516_2789# VSS VSS a_n46369_2570# nmos$3
Xnmos$2_327 WL_25 VSS a_n52396_n5278# SL_19 nmos$2
Xnmos$2_305 WL_25 VSS a_n49383_n5278# SL_21 nmos$2
Xnmos$2_316 a_n47874_n3970# VSS SL_22 a_n47560_n3981# nmos$2
Xnmos$2_349 a_n52396_n1354# VSS SL_19 a_n52082_n1365# nmos$2
Xnmos$2_338 a_n51035_n4050# VSS a_n50574_n3981# SL_20N nmos$2
Xnmos$2_4641 a_n41856_23498# VSS SL_26 a_n41542_23487# nmos$2
Xnmos$2_4630 WL_5 VSS a_n40351_20882# SL_27 nmos$2
Xnmos$5_110 VEVAL VSS m1_n39940_n2465# VSS nmos$5
Xnmos$2_4652 a_n42003_23717# VSS a_n41542_23487# SL_26N nmos$2
Xnmos$2_4685 a_n47560_19563# VSS ML_6 m1_n47463_19771# nmos$2
Xnmos$2_4663 WL_7 VSS SL_22N a_n48021_18485# nmos$2
Xnmos$2_4674 WL_8 VSS a_n49383_16958# SL_21 nmos$2
Xnmos$2_3940 WL_10 VSS a_n37338_14342# SL_29 nmos$2
Xnmos$5_121 VEVAL VSS m1_n38432_n10313# VSS nmos$5
Xnmos$5_132 VEVAL VSS m1_n35418_n7697# VSS nmos$5
Xnmos$5_143 VEVAL VSS m1_n36927_n3773# VSS nmos$5
Xnmos$2_4696 WL_8 VSS SL_20N a_n51035_17177# nmos$2
Xnmos$2_3962 a_n37485_15869# VSS a_n37024_15639# SL_29N nmos$2
Xnmos$2_3973 WL_11 VSS SL_30N a_n35976_13253# nmos$2
Xnmos$2_3951 WL_11 VSS SL_28N a_n38990_13253# nmos$2
Xnmos$5_154 VEVAL VSS m1_n33913_n2465# VSS nmos$5
Xnmos$5_176 VEVAL VSS m1_n70045_n11621# VSS nmos$5
Xnmos$5_165 VEVAL VSS m1_n68546_n28774# VSS nmos$5
Xnmos$2_3984 a_n35976_15869# VSS a_n35515_15639# SL_30N nmos$2
Xnmos$2_3995 WL_11 VSS a_n35829_13034# SL_30 nmos$2
Xnmos$5_198 VEVAL VSS m1_n74564_n12929# VSS nmos$5
Xnmos$5_187 VEVAL VSS m1_n73059_n9005# VSS nmos$5
Xnmos$2_850 a_n71647_n28982# VSS a_n32313_n28669# m1_n71550_n28774# nmos$2
Xnmos$2_872 WL VSS PSL_7N a_n70603_n29051# nmos$2
Xnmos$2_861 a_n70603_n29051# VSS a_n70142_n28982# PSL_7N nmos$2
Xnmos$2_883 WL VSS a_n74975_n28971# PSL_4 nmos$2
Xnmos$2_894 WL VSS a_n79497_n28971# PSL_1 nmos$2
Xnmos_601 a_n79497_2570# VSS a_n79644_2789# VSS nmos
Xnmos_634 a_n79497_15650# VSS a_n79644_15869# VSS nmos
Xnmos_623 a_n79497_9110# VSS a_n79644_9329# VSS nmos
Xnmos_612 a_n76483_6494# VSS a_n76630_6713# VSS nmos
Xnmos_656 a_n71961_14342# VSS a_n72108_14561# VSS nmos
Xnmos_667 a_n70456_13034# VSS a_n70603_13253# VSS nmos
Xnmos_645 a_n70456_11726# VSS a_n70603_11945# VSS nmos
Xnmos$2_3225 a_n74661_24795# VSS ML_2 m1_n74564_25003# nmos$2
Xnmos$2_3214 a_n76169_23487# VSS ML_3 m1_n76072_23695# nmos$2
Xnmos_689 a_n74975_20882# VSS a_n75122_21101# VSS nmos
Xnmos$2_3203 a_n78135_21101# VSS a_n77674_20871# SL_2N nmos$2
Xnmos_678 a_n71961_18266# VSS a_n72108_18485# VSS nmos
Xnmos$2_3236 WL_0 VSS a_n76483_27422# SL_3 nmos$2
Xnmos$2_3269 WL_0 VSS SL_0N a_n81149_27641# nmos$2
Xnmos$2_3247 WL_1 VSS SL_3N a_n76630_26333# nmos$2
Xnmos$2_3258 WL_2 VSS SL_1N a_n79644_25025# nmos$2
Xnmos$3_614 a_n67599_22409# VSS VSS a_n67452_22190# nmos$3
Xnmos$3_625 a_n76630_18485# VSS VSS a_n76483_18266# nmos$3
Xnmos$3_603 a_n72108_17177# VSS VSS a_n71961_16958# nmos$3
Xnmos$2_2502 WL_15 VSS a_n71961_7802# SL_6 nmos$2
Xnmos$2_2524 a_n70603_6713# VSS a_n70142_6483# SL_7N nmos$2
Xnmos$2_2513 a_n68957_5186# VSS SL_8 a_n68643_5175# nmos$2
Xnmos$2_102 a_n42003_n13206# VSS a_n41542_n13137# SL_26N nmos$2
Xnmos$3_658 a_n75122_27641# VSS VSS a_n74975_27422# nmos$3
Xnmos$3_647 a_n75122_21101# VSS VSS a_n74975_20882# nmos$3
Xnmos$3_636 a_n81149_19793# VSS VSS a_n81002_19574# nmos$3
Xnmos$2_2535 WL_15 VSS SL_7N a_n70603_8021# nmos$2
Xnmos$2_2557 a_n77674_3867# VSS ML_18 m1_n77577_4075# nmos$2
Xnmos$2_2546 a_n74975_2570# VSS SL_4 a_n74661_2559# nmos$2
Xnmos$2_1812 WL_22 VSS SL_14N a_n60063_n1434# nmos$2
Xnmos$2_135 a_n44556_n13137# VSS ML_31 m1_n44459_n12929# nmos$2
Xnmos$2_113 WL_30 VSS SL_23N a_n46516_n11898# nmos$2
Xnmos$2_124 WL_29 VSS m2_n44135_352# a_n45017_n10590# nmos$2
Xnmos$2_1801 a_n58097_n3981# VSS ML_24 m1_n58000_n3773# nmos$2
Xnmos$3_669 a_n67599_25025# VSS VSS a_n67452_24806# nmos$3
Xnmos$2_2579 WL_18 VSS SL_0N a_n81149_4097# nmos$2
Xnmos$2_2568 a_n79497_2570# VSS SL_1 a_n79183_2559# nmos$2
Xnmos$2_1845 a_n55096_n57# VSS ML_21 m1_n54999_151# nmos$2
Xnmos$2_1823 WL_21 VSS a_n58411_n46# SL_15 nmos$2
Xnmos$2_1834 a_n56601_n1365# VSS ML_22 m1_n56504_n1157# nmos$2
Xnmos$2_1856 WL_23 VSS a_n56915_n2662# SL_16 nmos$2
Xnmos$2_157 a_n44556_n9213# VSS ML_28 m1_n44459_n9005# nmos$2
Xnmos$2_168 a_n41856_n9202# VSS SL_26 a_n41542_n9213# nmos$2
Xnmos$2_146 WL_27 VSS a_n44870_n7894# SL_24 nmos$2
Xnmos$2_1867 WL_23 VSS SL_17N a_n55557_n2742# nmos$2
Xnmos$2_179 a_n40037_n7905# VSS ML_27 m1_n39940_n7697# nmos$2
Xnmos$2_1889 a_n58097_n6597# VSS ML_26 m1_n58000_n6389# nmos$2
Xnmos$2_1878 WL_26 VSS a_n53901_n6586# SL_18 nmos$2
Xpmos_1718 a_n35829_9110# VDD VDD a_n35976_9329# pmos
Xpmos_1707 a_n34324_6494# VDD VDD a_n34471_6713# pmos
Xpmos_1729 a_n38990_11945# VDD a_n38843_11726# VDD pmos
Xnmos$2_5161 a_n74975_1262# VSS SL_4 a_n74661_1251# nmos$2
Xnmos$2_5150 WL_20 VSS a_n77988_1262# SL_2 nmos$2
Xnmos$2_5194 a_n40498_1481# VSS a_n40037_1251# SL_27N nmos$2
Xnmos$2_5183 a_n42003_1481# VSS a_n41542_1251# SL_26N nmos$2
Xnmos$2_5172 a_n41542_1251# VSS ML_20 m1_n41445_1459# nmos$2
Xnmos$2_4493 WL_9 VSS SL_25N a_n43512_15869# nmos$2
Xnmos$2_4460 a_n44870_15650# VSS SL_24 a_n44556_15639# nmos$2
Xnmos$2_4471 WL_10 VSS a_n40351_14342# SL_27 nmos$2
Xnmos$2_4482 a_n41856_14342# VSS SL_26 a_n41542_14331# nmos$2
Xnmos$2_3770 WL_1 VSS a_n58411_26114# SL_15 nmos$2
Xnmos$2_3781 a_n34471_2789# VSS a_n34010_2559# SL_31N nmos$2
Xnmos$2_3792 a_n34324_3878# VSS SL_31 a_n34010_3867# nmos$2
Xnmos$2_680 a_n35829_n9202# VSS SL_30 a_n35515_n9213# nmos$2
Xnmos$2_691 WL_25 VSS a_n34324_n5278# SL_31 nmos$2
Xnmos$2_1108 WL_28 VSS a_n79497_n9202# SL_1 nmos$2
Xnmos$2_1119 a_n77674_n9213# VSS ML_28 m1_n77577_n9005# nmos$2
Xpmos$1_72 OUTP VDD m1_n26796_14054# a_n26151_14042# pmos$1
Xpmos$1_61 a_n28089_9234# VDD m1_n27919_9740# a_n27274_9728# pmos$1
Xpmos$1_50 a_n28089_4920# VDD m1_n27919_5426# a_n27274_5414# pmos$1
Xpmos$1_94 a_n28089_22176# VDD a_n26151_22670# a_n27618_22670# pmos$1
Xpmos$1_83 a_n28089_19300# VDD m1_n27919_19806# a_n27274_19794# pmos$1
Xnmos_442 a_n62930_n1354# VSS a_n63077_n1434# VSS nmos
Xnmos_420 a_n62930_n9202# VSS a_n63077_n9282# VSS nmos
Xnmos_431 a_n64438_n3970# VSS a_n64585_n4050# VSS nmos
Xnmos$2_3000 WL_7 VSS SL_4N a_n75122_18485# nmos$2
Xnmos_475 a_n56915_3878# VSS a_n57062_4097# VSS nmos
Xnmos_464 a_n58411_n46# VSS a_n58558_173# VSS nmos
Xnmos_453 a_n55410_n5278# VSS a_n55557_n5358# VSS nmos
Xnmos$2_3044 a_n71647_23487# VSS ML_3 m1_n71550_23695# nmos$2
Xnmos$2_3022 WL_5 VSS SL_6N a_n72108_21101# nmos$2
Xnmos$2_3033 a_n75122_21101# VSS a_n74661_20871# SL_4N nmos$2
Xnmos$2_3011 a_n71961_19574# VSS SL_6 a_n71647_19563# nmos$2
Xnmos_486 a_n58411_7802# VSS a_n58558_8021# VSS nmos
Xnmos$3_400 a_n58558_5405# VSS VSS a_n58411_5186# nmos$3
Xnmos_497 a_n62930_3878# VSS a_n63077_4097# VSS nmos
Xnmos$2_3077 a_n70603_23717# VSS a_n70142_23487# SL_7N nmos$2
Xnmos$2_3055 a_n69104_22409# VSS a_n68643_22179# SL_8N nmos$2
Xnmos$2_3066 a_n70142_20871# VSS ML_5 m1_n70045_21079# nmos$2
Xnmos$2_2310 a_n57062_11945# VSS a_n56601_11715# SL_16N nmos$2
Xnmos$3_433 a_n63077_11945# VSS VSS a_n62930_11726# nmos$3
Xnmos$2_2332 WL_13 VSS a_n58411_10418# SL_15 nmos$2
Xnmos$2_2321 WL_14 VSS a_n56915_9110# SL_16 nmos$2
Xnmos$3_422 a_n64585_8021# VSS VSS a_n64438_7802# nmos$3
Xnmos$3_411 a_n63077_4097# VSS VSS a_n62930_3878# nmos$3
Xnmos$2_3088 WL_7 VSS a_n74975_18266# SL_4 nmos$2
Xnmos$2_3099 a_n76169_18255# VSS ML_7 m1_n76072_18463# nmos$2
Xnmos$2_2365 WL_10 VSS a_n58411_14342# SL_15 nmos$2
Xnmos$2_2354 a_n58411_13034# VSS SL_15 a_n58097_13023# nmos$2
Xnmos$3_444 a_n66090_13253# VSS VSS a_n65943_13034# nmos$3
Xnmos$3_466 a_n58558_11945# VSS VSS a_n58411_11726# nmos$3
Xnmos$2_2343 a_n59602_11715# VSS ML_12 m1_n59505_11923# nmos$2
Xnmos$3_455 a_n55557_10637# VSS VSS a_n55410_10418# nmos$3
Xnmos$2_1620 a_n61572_n9282# VSS a_n61111_n9213# SL_13N nmos$2
Xnmos$2_2376 WL_9 VSS a_n59916_15650# SL_14 nmos$2
Xnmos$3_477 a_n54048_14561# VSS VSS a_n53901_14342# nmos$3
Xnmos$2_2387 WL_10 VSS SL_17N a_n55557_14561# nmos$2
Xnmos$2_2398 a_n57062_13253# VSS a_n56601_13023# SL_16N nmos$2
Xnmos$3_499 a_n67599_6713# VSS VSS a_n67452_6494# nmos$3
Xnmos$3_488 a_n69104_4097# VSS VSS a_n68957_3878# nmos$3
Xnmos$2_1631 a_n64585_n7974# VSS a_n64124_n7905# SL_11N nmos$2
Xnmos$2_1642 WL_27 VSS SL_12N a_n63077_n7974# nmos$2
Xnmos$2_1653 a_n64585_n5358# VSS a_n64124_n5289# SL_11N nmos$2
Xnmos$2_1664 a_n61425_n3970# VSS SL_13 a_n61111_n3981# nmos$2
Xnmos$2_1697 a_n67599_n1434# VSS a_n67138_n1365# SL_9N nmos$2
Xnmos$2_1675 WL_25 VSS SL_9N a_n67599_n5358# nmos$2
Xnmos$2_1686 a_n66090_n4050# VSS a_n65629_n3981# SL_10N nmos$2
Xpmos_2216 a_n26495_21232# VDD COMP7 VDD pmos
Xpmos_2238 a_n38843_19574# VDD VDD a_n38990_19793# pmos
Xpmos_2227 a_n35829_16958# VDD VDD a_n35976_17177# pmos
Xpmos_2205 ML_9 VDD a_n28485_18454# VDD pmos
Xpmos_1504 a_n58558_23717# VDD a_n58411_23498# VDD pmos
Xpmos_1515 a_n55410_22190# VDD VDD a_n55557_22409# pmos
Xpmos_2249 a_n37338_20882# VDD VDD a_n37485_21101# pmos
Xpmos_1526 a_n61572_18485# VDD a_n61425_18266# VDD pmos
Xpmos_1548 a_n67452_23498# VDD VDD a_n67599_23717# pmos
Xpmos_1559 a_n63077_22409# VDD a_n62930_22190# VDD pmos
Xpmos_1537 a_n66090_19793# VDD a_n65943_19574# VDD pmos
Xpmos_708 a_n67452_n13126# VDD VDD a_n67599_n13206# pmos
Xpmos_719 a_n67452_n10510# VDD VDD a_n67599_n10590# pmos
Xnmos$2_4290 WL_12 VSS SL_20N a_n51035_11945# nmos$2
Xnmos$2_7 WL VSS PSL_30N a_n35976_n29051# nmos$2
Xnmos$5_709 VEVAL VSS m1_n67041_23695# VSS nmos$5
Xnmos_250 a_n40351_n6586# VSS a_n40498_n6666# VSS nmos
Xnmos_283 a_n74975_n11818# VSS a_n75122_n11898# VSS nmos
Xnmos_272 a_n81002_n28971# VSS a_n81149_n29051# VSS nmos
Xnmos_261 a_n64438_n28971# VSS a_n64585_n29051# VSS nmos
Xnmos_294 a_n71961_n7894# VSS a_n72108_n7974# VSS nmos
Xnmos$2_2140 a_n63077_8021# VSS a_n62616_7791# SL_12N nmos$2
Xnmos$3_230 a_n76630_n9282# VSS VSS a_n76483_n9202# nmos$3
Xnmos$3_241 a_n81149_n5358# VSS VSS a_n81002_n5278# nmos$3
Xnmos$2_2184 WL_12 VSS SL_12N a_n63077_11945# nmos$2
Xnmos$2_2173 WL_12 VSS a_n62930_11726# SL_12 nmos$2
Xnmos$2_2151 a_n61111_10407# VSS ML_13 m1_n61014_10615# nmos$2
Xnmos$2_2162 a_n63077_9329# VSS a_n62616_9099# SL_12N nmos$2
Xnmos$3_274 a_n67599_n1434# VSS VSS a_n67452_n1354# nmos$3
Xnmos$3_252 a_n76630_n1434# VSS VSS a_n76483_n1354# nmos$3
Xnmos$3_285 a_n54048_n13206# VSS VSS a_n53901_n13126# nmos$3
Xnmos$3_263 a_n67599_n4050# VSS VSS a_n67452_n3970# nmos$3
Xnmos$2_2195 WL_13 VSS SL_10N a_n66090_10637# nmos$2
Xnmos$2_1450 a_n58411_n13126# VSS SL_15 a_n58097_n13137# nmos$2
Xnmos$3_296 a_n57062_n11898# VSS VSS a_n56915_n11818# nmos$3
Xnmos$2_1461 a_n60063_n10590# VSS a_n59602_n10521# SL_14N nmos$2
Xnmos$2_1472 a_n58411_n10510# VSS SL_15 a_n58097_n10521# nmos$2
Xnmos$2_1483 a_n58558_n9282# VSS a_n58097_n9213# SL_15N nmos$2
Xnmos$2_1494 a_n59916_n7894# VSS SL_14 a_n59602_n7905# nmos$2
Xpmos_2002 a_n45017_15869# VDD a_n44870_15650# VDD pmos
Xpmos_2046 a_n43512_21101# VDD a_n43365_20882# VDD pmos
Xpmos_1301 a_n70603_19793# VDD a_n70456_19574# VDD pmos
Xpmos_2024 a_n43365_16958# VDD VDD a_n43512_17177# pmos
Xpmos_2035 a_n45017_17177# VDD a_n44870_16958# VDD pmos
Xpmos_2013 a_n42003_15869# VDD a_n41856_15650# VDD pmos
Xpmos_1334 a_n71961_23498# VDD VDD a_n72108_23717# pmos
Xpmos_2068 a_n41856_22190# VDD VDD a_n42003_22409# pmos
Xpmos_2057 a_n40498_21101# VDD a_n40351_20882# VDD pmos
Xpmos_1323 a_n73470_19574# VDD VDD a_n73617_19793# pmos
Xpmos_2079 a_n47874_18266# VDD VDD a_n48021_18485# pmos
Xpmos_1312 a_n74975_16958# VDD VDD a_n75122_17177# pmos
Xpmos_1345 a_n70456_23498# VDD VDD a_n70603_23717# pmos
Xpmos_1356 a_n77988_16958# VDD VDD a_n78135_17177# pmos
Xpmos_1367 a_n78135_17177# VDD a_n77988_16958# VDD pmos
Xpmos_505 a_n81002_n11818# VDD VDD a_n81149_n11898# pmos
Xpmos_516 a_n81002_n9202# VDD VDD a_n81149_n9282# pmos
Xpmos_1389 a_n79497_22190# VDD VDD a_n79644_22409# pmos
Xpmos_1378 a_n79644_17177# VDD a_n79497_16958# VDD pmos
Xpmos_527 a_n76483_n9202# VDD VDD a_n76630_n9282# pmos
Xpmos_538 a_n76483_n5278# VDD VDD a_n76630_n5358# pmos
Xpmos_549 a_n76483_n3970# VDD VDD a_n76630_n4050# pmos
Xnmos_1210 a_n35829_23498# VSS a_n35976_23717# VSS nmos
Xnmos_1254 a_n26495_31298# VSS VSS COMP0 nmos
Xnmos_1243 a_n28485_29958# VSS VSS m1_n28364_29783# nmos
Xnmos_1232 a_n27618_25546# VSS m1_n27919_25558# VSS nmos
Xnmos_1221 a_n38843_26114# VSS a_n38990_26333# VSS nmos
Xnmos_1265 a_n40351_24806# VSS a_n40498_25025# VSS nmos
Xnmos_1276 a_n40351_13034# VSS a_n40498_13253# VSS nmos
Xnmos_1287 a_n62930_1262# VSS a_n63077_1481# VSS nmos
Xnmos_1298 a_n40351_1262# VSS a_n40498_1481# VSS nmos
Xnmos$5_11 VEVAL VSS m1_n50477_n28774# VSS nmos$5
Xnmos$5_22 VEVAL VSS m1_n45958_n11621# VSS nmos$5
Xnmos$5_44 VEVAL VSS m1_n48972_n12929# VSS nmos$5
Xnmos$5_55 VEVAL VSS m1_n50477_n9005# VSS nmos$5
Xnmos$5_33 VEVAL VSS m1_n41445_n7697# VSS nmos$5
Xnmos$5_77 VEVAL VSS m1_n51985_151# VSS nmos$5
Xnmos$5_66 VEVAL VSS m1_n47463_n7697# VSS nmos$5
Xnmos$5_88 VEVAL VSS m1_n41445_n5081# VSS nmos$5
Xnmos$5_99 VEVAL VSS m1_n39940_n1157# VSS nmos$5
Xpmos_1890 a_n52396_7802# VDD VDD a_n52543_8021# pmos
Xnmos$5_517 VEVAL VSS m1_n80591_4075# VSS nmos$5
Xnmos$5_506 VEVAL VSS m1_n76072_2767# VSS nmos$5
Xnmos$5_539 VEVAL VSS m1_n77577_10615# VSS nmos$5
Xnmos$5_528 VEVAL VSS m1_n74564_5383# VSS nmos$5
Xpmos$3_18 PC VDD ML_14 VDD pmos$3
Xpmos$3_29 PC VDD ML_2 VDD pmos$3
Xnmos$2_1280 a_n73617_n5358# VSS a_n73156_n5289# SL_5N nmos$2
Xnmos$2_1291 WL_24 VSS SL_6N a_n72108_n4050# nmos$2
Xpmos_1120 a_n70603_8021# VDD a_n70456_7802# VDD pmos
Xpmos_1131 a_n77988_2570# VDD VDD a_n78135_2789# pmos
Xpmos_1142 a_n81149_1481# VDD a_n81002_1262# VDD pmos
Xpmos_1186 a_n75122_11945# VDD a_n74975_11726# VDD pmos
Xpmos_1164 a_n79497_7802# VDD VDD a_n79644_8021# pmos
Xpmos_1175 a_n76630_6713# VDD a_n76483_6494# VDD pmos
Xpmos_1153 a_n78135_5405# VDD a_n77988_5186# VDD pmos
Xpmos_302 a_n34471_n7974# VDD a_n34324_n7894# VDD pmos
Xpmos_324 a_n37338_n3970# VDD VDD a_n37485_n4050# pmos
Xpmos_313 a_n34324_n3970# VDD VDD a_n34471_n4050# pmos
Xpmos_1197 a_n81149_11945# VDD a_n81002_11726# VDD pmos
Xpmos_346 a_n35829_n1354# VDD VDD a_n35976_n1434# pmos
Xpmos_335 a_n38843_n2662# VDD VDD a_n38990_n2742# pmos
Xpmos_357 a_n28485_n5992# VDD m1_n28364_n6167# VDD pmos
Xpmos_368 a_n27618_n4652# VDD VDD m1_n27919_n4640# pmos
Xpmos_379 ML_24 VDD a_n28485_n3116# VDD pmos
Xnmos_1062 a_n43365_16958# VSS a_n43512_17177# VSS nmos
Xnmos_1051 a_n46369_15650# VSS a_n46516_15869# VSS nmos
Xnmos_1040 a_n41856_11726# VSS a_n42003_11945# VSS nmos
Xnmos_1073 a_n46369_22190# VSS a_n46516_22409# VSS nmos
Xnmos_1095 a_n52396_22190# VSS a_n52543_22409# VSS nmos
Xnmos_1084 a_n47874_16958# VSS a_n48021_17177# VSS nmos
Xnmos$3_1000 a_n35976_21101# VSS VSS a_n35829_20882# nmos$3
Xnmos$2_2909 a_n68957_13034# VSS SL_8 a_n68643_13023# nmos$2
Xnmos$2_509 a_n43051_n2673# VSS ML_23 m1_n42954_n2465# nmos$2
Xnmos$3_1022 a_n35976_27641# VSS VSS a_n35829_27422# nmos$3
Xnmos$3_1011 a_n34471_23717# VSS VSS a_n34324_23498# nmos$3
Xnmos$3_1033 a_n66090_1481# VSS VSS a_n65943_1262# nmos$3
Xnmos$3_1055 a_n70603_1481# VSS VSS a_n70456_1262# nmos$3
Xnmos$3_1044 a_n76630_1481# VSS VSS a_n76483_1262# nmos$3
Xpmos_880 a_n58411_6494# VDD VDD a_n58558_6713# pmos
Xnmos$2_4812 WL_0 VSS a_n47874_27422# SL_22 nmos$2
Xnmos$2_4823 WL_1 VSS SL_22N a_n48021_26333# nmos$2
Xnmos$2_4801 a_n49069_24795# VSS ML_2 m1_n48972_25003# nmos$2
Xnmos$2_4834 WL_2 VSS SL_18N a_n54048_25025# nmos$2
Xpmos_891 a_n58558_8021# VDD a_n58411_7802# VDD pmos
Xnmos$2_4845 a_n50888_27422# VSS SL_20 a_n50574_27411# nmos$2
Xnmos$2_4856 a_n52543_26333# VSS a_n52082_26103# SL_19N nmos$2
Xnmos$2_4867 WL_2 VSS SL_26N a_n42003_25025# nmos$2
Xnmos$5_303 VEVAL VSS m1_n65532_n12929# VSS nmos$5
Xnmos$5_314 VEVAL VSS m1_n65532_n7697# VSS nmos$5
Xnmos$5_325 VEVAL VSS m1_n64027_n7697# VSS nmos$5
Xnmos$2_4878 WL_0 VSS SL_26N a_n42003_27641# nmos$2
Xnmos$2_4889 a_n42003_26333# VSS a_n41542_26103# SL_26N nmos$2
Xnmos$5_336 VEVAL VSS m1_n67041_n1157# VSS nmos$5
Xnmos$5_347 VEVAL VSS m1_n64027_n5081# VSS nmos$5
Xnmos$5_358 VEVAL VSS m1_n59505_n3773# VSS nmos$5
Xnmos$5_369 VEVAL VSS m1_n58000_n2465# VSS nmos$5
Xnmos$5_870 VEVAL VSS m1_n47463_13231# VSS nmos$5
Xnmos$5_881 VEVAL VSS m1_n39940_11923# VSS nmos$5
Xnmos$5_892 VEVAL VSS m1_n45958_15847# VSS nmos$5
Xnmos$2_12 a_n38990_n29051# VSS a_n38529_n28982# PSL_28N nmos$2
Xnmos$2_34 WL VSS PSL_25N a_n43512_n29051# nmos$2
Xnmos$2_23 WL VSS a_n44870_n28971# PSL_24 nmos$2
Xnmos$2_67 WL_31 VSS SL_26N a_n42003_n13206# nmos$2
Xnmos$2_45 WL VSS PSL_21N a_n49530_n29051# nmos$2
Xnmos$2_56 WL VSS a_n52396_n28971# PSL_19 nmos$2
Xnmos$2_78 a_n41856_n10510# VSS SL_26 a_n41542_n10521# nmos$2
Xnmos$2_89 WL_30 VSS SL_26N a_n42003_n11898# nmos$2
Xpmos_110 a_n48021_n7974# VDD a_n47874_n7894# VDD pmos
Xpmos_121 a_n47874_n6586# VDD VDD a_n48021_n6666# pmos
Xpmos_132 a_n48021_n5358# VDD a_n47874_n5278# VDD pmos
Xpmos_143 a_n52396_n3970# VDD VDD a_n52543_n4050# pmos
Xnmos_816 a_n65943_26114# VSS a_n66090_26333# VSS nmos
Xnmos_805 a_n61425_23498# VSS a_n61572_23717# VSS nmos
Xpmos_165 a_n49530_173# VDD a_n49383_n46# VDD pmos
Xpmos_176 a_n50888_n46# VDD VDD a_n51035_173# pmos
Xpmos_154 a_n53901_n46# VDD VDD a_n54048_173# pmos
Xnmos_827 a_n58411_26114# VSS a_n58558_26333# VSS nmos
Xnmos$2_4108 WL_15 VSS a_n40351_7802# SL_27 nmos$2
Xnmos_849 ML_19 VSS VSS a_n28485_4074# nmos
Xnmos$2_4119 WL_19 VSS a_n47874_2570# SL_22 nmos$2
Xnmos_838 OUTP VSS a_n28089_2044# VSS nmos
Xpmos_198 a_n46369_n3970# VDD VDD a_n46516_n4050# pmos
Xpmos_187 a_n43365_n3970# VDD VDD a_n43512_n4050# pmos
Xnmos$2_3418 a_n59916_18266# VSS SL_14 a_n59602_18255# nmos$2
Xnmos$2_3407 WL_8 VSS SL_15N a_n58558_17177# nmos$2
Xnmos$2_3429 a_n58097_19563# VSS ML_6 m1_n58000_19771# nmos$2
Xnmos$3_807 a_n34471_15869# VSS VSS a_n34324_15650# nmos$3
Xnmos$2_2706 WL_14 VSS a_n81002_9110# SL_0 nmos$2
Xnmos$2_2739 WL_11 VSS SL_1N a_n79644_13253# nmos$2
Xnmos$2_2728 WL_12 VSS a_n79497_11726# SL_1 nmos$2
Xnmos$2_2717 a_n81149_11945# VSS a_n80688_11715# SL_0N nmos$2
Xnmos$3_818 a_n45017_5405# VSS VSS a_n44870_5186# nmos$3
Xnmos$3_829 a_n49530_2789# VSS VSS a_n49383_2570# nmos$3
Xnmos$2_306 WL_25 VSS SL_21N a_n49530_n5358# nmos$2
Xnmos$2_317 a_n47560_n3981# VSS ML_24 m1_n47463_n3773# nmos$2
Xnmos$2_328 a_n54048_n5358# VSS a_n53587_n5289# SL_18N nmos$2
Xnmos$2_339 WL_25 VSS SL_19N a_n52543_n5358# nmos$2
Xnmos$2_4642 WL_3 VSS a_n41856_23498# SL_26 nmos$2
Xnmos$2_4620 a_n40037_22179# VSS ML_4 m1_n39940_22387# nmos$2
Xnmos$2_4631 a_n41542_22179# VSS ML_4 m1_n41445_22387# nmos$2
Xnmos$5_100 VEVAL VSS m1_n41445_n1157# VSS nmos$5
Xnmos$2_4653 a_n42003_21101# VSS a_n41542_20871# SL_26N nmos$2
Xnmos$2_4664 a_n47874_18266# VSS SL_22 a_n47560_18255# nmos$2
Xnmos$2_4675 a_n49069_16947# VSS ML_8 m1_n48972_17155# nmos$2
Xnmos$2_3930 WL_12 VSS SL_29N a_n37485_11945# nmos$2
Xnmos$5_111 VEVAL VSS m1_n41445_n2465# VSS nmos$5
Xnmos$5_122 VEVAL VSS m1_n36927_n11621# VSS nmos$5
Xnmos$5_133 VEVAL VSS m1_n35418_n6389# VSS nmos$5
Xnmos$2_4686 a_n47874_19574# VSS SL_22 a_n47560_19563# nmos$2
Xnmos$2_4697 a_n50574_16947# VSS ML_8 m1_n50477_17155# nmos$2
Xnmos$2_3963 WL_9 VSS SL_29N a_n37485_15869# nmos$2
Xnmos$2_3974 WL_10 VSS a_n34324_14342# SL_31 nmos$2
Xnmos$2_3941 a_n37338_13034# VSS SL_29 a_n37024_13023# nmos$2
Xnmos$2_3952 a_n38843_13034# VSS SL_28 a_n38529_13023# nmos$2
Xnmos$5_144 VEVAL VSS m1_n36927_n1157# VSS nmos$5
Xnmos$5_155 VEVAL VSS m1_n35418_n2465# VSS nmos$5
Xnmos$5_166 VEVAL VSS m1_n70045_n28774# VSS nmos$5
Xnmos$5_177 VEVAL VSS m1_n70045_n10313# VSS nmos$5
Xnmos$2_3985 a_n34010_15639# VSS ML_9 m1_n33913_15847# nmos$2
Xnmos$2_3996 a_n35829_13034# VSS SL_30 a_n35515_13023# nmos$2
Xnmos$5_199 VEVAL VSS m1_n76072_n12929# VSS nmos$5
Xnmos$2_840 WL VSS a_n61425_n28971# PSL_13 nmos$2
Xnmos$5_188 VEVAL VSS m1_n73059_n7697# VSS nmos$5
Xnmos$2_862 WL VSS PSL_4N a_n75122_n29051# nmos$2
Xnmos$2_851 a_n70456_n28971# VSS PSL_7 a_n70142_n28982# nmos$2
Xnmos$2_873 WL VSS PSL_8N a_n69104_n29051# nmos$2
Xnmos$2_884 a_n79183_n28982# VSS a_n32313_n28669# m1_n79086_n28774# nmos$2
Xnmos$2_895 a_n79497_n28971# VSS PSL_1 a_n79183_n28982# nmos$2
Xnmos_624 a_n79497_10418# VSS a_n79644_10637# VSS nmos
Xnmos_613 a_n77988_6494# VSS a_n78135_6713# VSS nmos
Xnmos_602 a_n81002_2570# VSS a_n81149_2789# VSS nmos
Xnmos_668 a_n70456_14342# VSS a_n70603_14561# VSS nmos
Xnmos_657 a_n71961_13034# VSS a_n72108_13253# VSS nmos
Xnmos_635 a_n76483_13034# VSS a_n76630_13253# VSS nmos
Xnmos_646 a_n68957_11726# VSS a_n69104_11945# VSS nmos
Xnmos$2_3226 a_n76630_25025# VSS a_n76169_24795# SL_3N nmos$2
Xnmos$2_3215 WL_3 VSS a_n76483_23498# SL_3 nmos$2
Xnmos$2_3204 WL_4 VSS SL_2N a_n78135_22409# nmos$2
Xnmos_679 a_n74975_16958# VSS a_n75122_17177# VSS nmos
Xnmos$2_3237 a_n76169_27411# VSS ML_0 m1_n76072_27619# nmos$2
Xnmos$2_3248 a_n77674_26103# VSS ML_1 m1_n77577_26311# nmos$2
Xnmos$2_3259 a_n79644_25025# VSS a_n79183_24795# SL_1N nmos$2
Xnmos$3_615 a_n67599_21101# VSS VSS a_n67452_20882# nmos$3
Xnmos$3_604 a_n73617_18485# VSS VSS a_n73470_18266# nmos$3
Xnmos$2_2503 WL_15 VSS SL_6N a_n72108_8021# nmos$2
Xnmos$2_2514 a_n68643_6483# VSS ML_16 m1_n68546_6691# nmos$2
Xnmos$3_659 a_n78135_26333# VSS VSS a_n77988_26114# nmos$3
Xnmos$3_648 a_n75122_22409# VSS VSS a_n74975_22190# nmos$3
Xnmos$3_637 a_n78135_19793# VSS VSS a_n77988_19574# nmos$3
Xnmos$3_626 a_n76630_17177# VSS VSS a_n76483_16958# nmos$3
Xnmos$2_2536 a_n70603_8021# VSS a_n70142_7791# SL_7N nmos$2
Xnmos$2_2525 a_n70142_6483# VSS ML_16 m1_n70045_6691# nmos$2
Xnmos$2_2558 WL_18 VSS a_n76483_3878# SL_3 nmos$2
Xnmos$2_2547 WL_19 VSS SL_3N a_n76630_2789# nmos$2
Xnmos$2_1813 a_n59602_n1365# VSS ML_22 m1_n59505_n1157# nmos$2
Xnmos$2_103 WL_31 VSS a_n43365_n13126# SL_25 nmos$2
Xnmos$2_114 a_n46516_n11898# VSS a_n46055_n11829# SL_23N nmos$2
Xnmos$2_125 a_n45017_n10590# VSS a_n44556_n10521# m2_n44135_352# nmos$2
Xnmos$2_1802 a_n58558_n4050# VSS a_n58097_n3981# SL_15N nmos$2
Xnmos$2_2569 WL_19 VSS a_n77988_2570# SL_2 nmos$2
Xnmos$2_1835 a_n55410_n46# VSS SL_17 a_n55096_n57# nmos$2
Xnmos$2_1824 a_n58097_n57# VSS ML_21 m1_n58000_151# nmos$2
Xnmos$2_1846 a_n55096_n1365# VSS ML_22 m1_n54999_n1157# nmos$2
Xnmos$2_136 WL_28 VSS a_n43365_n9202# SL_25 nmos$2
Xnmos$2_158 WL_28 VSS SL_27N a_n40498_n9282# nmos$2
Xnmos$2_147 WL_27 VSS SL_23N a_n46516_n7974# nmos$2
Xnmos$2_169 WL_27 VSS a_n41856_n7894# SL_26 nmos$2
Xnmos$2_1868 a_n55410_n2662# VSS SL_17 a_n55096_n2673# nmos$2
Xnmos$2_1857 a_n59916_n2662# VSS SL_14 a_n59602_n2673# nmos$2
Xnmos$2_1879 a_n55557_n6666# VSS a_n55096_n6597# SL_17N nmos$2
Xpmos_1708 a_n34324_5186# VDD VDD a_n34471_5405# pmos
Xpmos_1719 a_n34471_11945# VDD a_n34324_11726# VDD pmos
Xnmos$2_5140 a_n35515_1251# VSS ML_20 m1_n35418_1459# nmos$2
Xnmos$2_5151 WL_20 VSS SL_29N a_n37485_1481# nmos$2
Xnmos$2_5162 a_n78135_1481# VSS a_n77674_1251# SL_2N nmos$2
Xnmos$2_4450 a_n44870_13034# VSS SL_24 a_n44556_13023# nmos$2
Xnmos$2_5195 WL_20 VSS SL_27N a_n40498_1481# nmos$2
Xnmos$2_5173 a_n41856_1262# VSS SL_26 a_n41542_1251# nmos$2
Xnmos$2_5184 a_n46055_1251# VSS ML_20 m1_n45958_1459# nmos$2
Xnmos$2_4461 a_n46516_15869# VSS a_n46055_15639# SL_23N nmos$2
Xnmos$2_4472 WL_10 VSS SL_27N a_n40498_14561# nmos$2
Xnmos$2_4483 WL_11 VSS a_n41856_13034# SL_26 nmos$2
Xnmos$2_3760 WL_0 VSS a_n58411_27422# SL_15 nmos$2
Xnmos$2_3771 a_n58411_26114# VSS SL_15 a_n58097_26103# nmos$2
Xnmos$2_4494 a_n41542_15639# VSS ML_9 m1_n41445_15847# nmos$2
Xnmos$2_3782 WL_19 VSS SL_31N a_n34471_2789# nmos$2
Xnmos$2_3793 a_n34471_4097# VSS a_n34010_3867# SL_31N nmos$2
Xnmos$2_681 a_n35829_n7894# VSS SL_30 a_n35515_n7905# nmos$2
Xnmos$2_670 WL_27 VSS a_n34324_n7894# SL_31 nmos$2
Xnmos$2_692 a_n35976_n4050# VSS a_n35515_n3981# SL_30N nmos$2
Xnmos$2_1109 WL_27 VSS a_n79497_n7894# SL_1 nmos$2
Xpmos$1_40 a_n28089_3482# VDD a_n26151_3976# a_n27618_3976# pmos$1
Xpmos$1_73 a_n28089_14986# VDD a_n26151_15480# a_n27618_15480# pmos$1
Xpmos$1_62 OUTP VDD a_n27274_9728# m1_n28364_9651# pmos$1
Xpmos$1_51 a_n28089_7796# VDD m1_n27919_8302# a_n27274_8290# pmos$1
Xpmos$1_95 OUTP VDD a_n27274_21232# m1_n28364_21155# pmos$1
Xpmos$1_84 OUTP VDD a_n27274_19794# m1_n28364_19717# pmos$1
Xnmos_443 a_n61425_n1354# VSS a_n61572_n1434# VSS nmos
Xnmos_410 a_n67452_n10510# VSS a_n67599_n10590# VSS nmos
Xnmos_421 a_n64438_n9202# VSS a_n64585_n9282# VSS nmos
Xnmos_432 a_n61425_n3970# VSS a_n61572_n4050# VSS nmos
Xnmos$2_3001 a_n73470_19574# VSS SL_5 a_n73156_19563# nmos$2
Xnmos_476 a_n55410_3878# VSS a_n55557_4097# VSS nmos
Xnmos_465 a_n55410_n1354# VSS a_n55557_n1434# VSS nmos
Xnmos_454 a_n56915_n5278# VSS a_n57062_n5358# VSS nmos
Xnmos$2_3023 WL_4 VSS a_n71961_22190# SL_6 nmos$2
Xnmos$2_3034 a_n73156_22179# VSS ML_4 m1_n73059_22387# nmos$2
Xnmos$2_3012 WL_6 VSS SL_5N a_n73617_19793# nmos$2
Xnmos_487 a_n55410_6494# VSS a_n55557_6713# VSS nmos
Xnmos_498 a_n61425_3878# VSS a_n61572_4097# VSS nmos
Xnmos$2_3045 WL_3 VSS a_n71961_23498# SL_6 nmos$2
Xnmos$2_3056 a_n68643_22179# VSS ML_4 m1_n68546_22387# nmos$2
Xnmos$2_3067 a_n70142_22179# VSS ML_4 m1_n70045_22387# nmos$2
Xnmos$2_2311 WL_12 VSS a_n55410_11726# SL_17 nmos$2
Xnmos$3_434 a_n61572_11945# VSS VSS a_n61425_11726# nmos$3
Xnmos$2_2333 WL_13 VSS SL_14N a_n60063_10637# nmos$2
Xnmos$2_2300 a_n56601_9099# VSS ML_14 m1_n56504_9307# nmos$2
Xnmos$2_2322 WL_14 VSS a_n58411_9110# SL_15 nmos$2
Xnmos$3_401 a_n58558_8021# VSS VSS a_n58411_7802# nmos$3
Xnmos$3_423 a_n61572_6713# VSS VSS a_n61425_6494# nmos$3
Xnmos$3_412 a_n61572_4097# VSS VSS a_n61425_3878# nmos$3
Xnmos$2_3078 a_n67452_23498# VSS SL_9 a_n67138_23487# nmos$2
Xnmos$2_3089 a_n74975_18266# VSS SL_4 a_n74661_18255# nmos$2
Xnmos$3_445 a_n66090_15869# VSS VSS a_n65943_15650# nmos$3
Xnmos$2_2355 WL_11 VSS SL_15N a_n58558_13253# nmos$2
Xnmos$2_2366 a_n59916_13034# VSS SL_14 a_n59602_13023# nmos$2
Xnmos$2_2344 a_n60063_11945# VSS a_n59602_11715# SL_14N nmos$2
Xnmos$3_467 a_n58558_10637# VSS VSS a_n58411_10418# nmos$3
Xnmos$3_456 a_n55557_9329# VSS VSS a_n55410_9110# nmos$3
Xnmos$2_1621 WL_28 VSS a_n61425_n9202# SL_13 nmos$2
Xnmos$2_1610 WL_27 VSS SL_9N a_n67599_n7974# nmos$2
Xnmos$2_2377 a_n59602_15639# VSS ML_9 m1_n59505_15847# nmos$2
Xnmos$3_478 a_n54048_13253# VSS VSS a_n53901_13034# nmos$3
Xnmos$2_2388 a_n55557_13253# VSS a_n55096_13023# SL_17N nmos$2
Xnmos$2_2399 a_n56601_13023# VSS ML_11 m1_n56504_13231# nmos$2
Xnmos$3_489 a_n72108_2789# VSS VSS a_n71961_2570# nmos$3
Xnmos$2_1643 WL_28 VSS SL_12N a_n63077_n9282# nmos$2
Xnmos$2_1632 a_n63077_n7974# VSS a_n62616_n7905# SL_12N nmos$2
Xnmos$2_1654 a_n62616_n5289# VSS ML_25 m1_n62519_n5081# nmos$2
Xnmos$2_1698 a_n65943_n1354# VSS SL_10 a_n65629_n1365# nmos$2
Xnmos$2_1676 a_n65943_n5278# VSS SL_10 a_n65629_n5289# nmos$2
Xnmos$2_1687 a_n64124_n3981# VSS ML_24 m1_n64027_n3773# nmos$2
Xnmos$2_1665 WL_24 VSS SL_13N a_n61572_n4050# nmos$2
Xpmos_2217 a_n26151_21232# VDD VDD a_n26495_21232# pmos
Xpmos_2228 a_n34471_19793# VDD a_n34324_19574# VDD pmos
Xpmos_2206 ML_8 VDD a_n28485_19892# VDD pmos
Xpmos_1516 a_n54048_22409# VDD a_n53901_22190# VDD pmos
Xpmos_1505 a_n58558_22409# VDD a_n58411_22190# VDD pmos
Xpmos_2239 a_n38843_18266# VDD VDD a_n38990_18485# pmos
Xpmos_1549 a_n66090_23717# VDD a_n65943_23498# VDD pmos
Xpmos_1527 a_n61572_19793# VDD a_n61425_19574# VDD pmos
Xpmos_1538 a_n66090_18485# VDD a_n65943_18266# VDD pmos
Xpmos_709 a_n67452_n11818# VDD VDD a_n67599_n11898# pmos
Xnmos$2_4291 a_n50888_11726# VSS SL_20 a_n50574_11715# nmos$2
Xnmos$2_4280 a_n52082_10407# VSS ML_13 m1_n51985_10615# nmos$2
Xnmos$2_3590 a_n65943_22190# VSS SL_10 a_n65629_22179# nmos$2
Xnmos$3_990 a_n34471_19793# VSS VSS a_n34324_19574# nmos$3
Xnmos$2_8 a_n35829_n28971# VSS PSL_30 a_n35515_n28982# nmos$2
Xnmos_240 a_n26495_n338# VSS m1_n26796_n326# VSS nmos
Xnmos_251 a_n40351_n28971# VSS a_n40498_n29051# VSS nmos
Xnmos_273 a_n76483_n28971# VSS a_n76630_n29051# VSS nmos
Xnmos_262 a_n62930_n28971# VSS a_n63077_n29051# VSS nmos
Xnmos_284 a_n74975_n10510# VSS a_n75122_n10590# VSS nmos
Xnmos_295 a_n71961_n6586# VSS a_n72108_n6666# VSS nmos
Xnmos$2_2141 WL_15 VSS a_n62930_7802# SL_12 nmos$2
Xnmos$2_2130 a_n62930_6494# VSS SL_12 a_n62616_6483# nmos$2
Xnmos$3_220 a_n78135_n9282# VSS VSS a_n77988_n9202# nmos$3
Xnmos$3_231 a_n76630_n7974# VSS VSS a_n76483_n7894# nmos$3
Xnmos$3_242 a_n79644_n4050# VSS VSS a_n79497_n3970# nmos$3
Xnmos$2_2174 a_n62616_11715# VSS ML_12 m1_n62519_11923# nmos$2
Xnmos$2_2152 WL_14 VSS a_n61425_9110# SL_13 nmos$2
Xnmos$2_2163 a_n62616_9099# VSS ML_14 m1_n62519_9307# nmos$2
Xnmos$3_253 a_n76630_173# VSS VSS a_n76483_n46# nmos$3
Xnmos$3_275 a_n70603_n1434# VSS VSS a_n70456_n1354# nmos$3
Xnmos$3_264 a_n69104_n4050# VSS VSS a_n68957_n3970# nmos$3
Xnmos$2_2185 WL_13 VSS SL_12N a_n63077_10637# nmos$2
Xnmos$2_2196 a_n67599_10637# VSS a_n67138_10407# SL_9N nmos$2
Xnmos$3_286 a_n55557_n13206# VSS VSS a_n55410_n13126# nmos$3
Xnmos$2_1451 WL_31 VSS a_n58411_n13126# SL_15 nmos$2
Xnmos$2_1462 WL_29 VSS a_n59916_n10510# SL_14 nmos$2
Xnmos$3_297 a_n58558_n10590# VSS VSS a_n58411_n10510# nmos$3
Xnmos$2_1440 a_n53901_n10510# VSS SL_18 a_n53587_n10521# nmos$2
Xnmos$2_1473 a_n58097_n10521# VSS ML_29 m1_n58000_n10313# nmos$2
Xnmos$2_1484 WL_28 VSS a_n58411_n9202# SL_15 nmos$2
Xnmos$2_1495 a_n59602_n7905# VSS ML_27 m1_n59505_n7697# nmos$2
Xpmos_2003 a_n43512_15869# VDD a_n43365_15650# VDD pmos
Xpmos_2025 a_n42003_19793# VDD a_n41856_19574# VDD pmos
Xpmos_2036 a_n46369_16958# VDD VDD a_n46516_17177# pmos
Xpmos_2014 a_n43365_15650# VDD VDD a_n43512_15869# pmos
Xpmos_1335 a_n72108_23717# VDD a_n71961_23498# VDD pmos
Xpmos_2058 a_n41856_20882# VDD VDD a_n42003_21101# pmos
Xpmos_2047 a_n45017_21101# VDD a_n44870_20882# VDD pmos
Xpmos_1324 a_n72108_21101# VDD a_n71961_20882# VDD pmos
Xpmos_1302 a_n67599_18485# VDD a_n67452_18266# VDD pmos
Xpmos_1313 a_n73617_18485# VDD a_n73470_18266# VDD pmos
Xpmos_2069 a_n47874_16958# VDD VDD a_n48021_17177# pmos
Xpmos_1346 a_n70456_22190# VDD VDD a_n70603_22409# pmos
Xpmos_1357 a_n76630_17177# VDD a_n76483_16958# VDD pmos
Xpmos_1368 a_n81149_17177# VDD a_n81002_16958# VDD pmos
Xpmos_506 a_n81149_n11898# VDD a_n81002_n11818# VDD pmos
Xpmos_517 a_n81149_n10590# VDD a_n81002_n10510# VDD pmos
Xpmos_1379 a_n79644_19793# VDD a_n79497_19574# VDD pmos
Xpmos_528 a_n75122_n9282# VDD a_n74975_n9202# VDD pmos
Xpmos_539 a_n75122_n6666# VDD a_n74975_n6586# VDD pmos
Xnmos_1211 a_n34324_23498# VSS a_n34471_23717# VSS nmos
Xnmos_1200 a_n37338_20882# VSS a_n37485_21101# VSS nmos
Xnmos_1244 OUTP VSS a_n28089_29366# VSS nmos
Xnmos_1222 a_n38843_27422# VSS a_n38990_27641# VSS nmos
Xnmos_1233 a_n26495_25546# VSS VSS COMP4 nmos
Xnmos_1255 a_n27274_28422# VSS a_n27618_28422# VSS nmos
Xnmos_1266 a_n40351_26114# VSS a_n40498_26333# VSS nmos
Xnmos_1277 a_n40351_9110# VSS a_n40498_9329# VSS nmos
Xnmos_1288 a_n64438_1262# VSS a_n64585_1481# VSS nmos
Xnmos_1299 a_n37338_1262# VSS a_n37485_1481# VSS nmos
Xnmos$5_12 VEVAL VSS m1_n51985_n28774# VSS nmos$5
Xnmos$5_23 VEVAL VSS m1_n44459_n11621# VSS nmos$5
Xnmos$5_45 VEVAL VSS m1_n48972_n10313# VSS nmos$5
Xnmos$5_56 VEVAL VSS m1_n51985_n9005# VSS nmos$5
Xnmos$5_34 VEVAL VSS m1_n41445_n6389# VSS nmos$5
Xnmos$5_78 VEVAL VSS m1_n50477_151# VSS nmos$5
Xnmos$5_67 VEVAL VSS m1_n47463_n5081# VSS nmos$5
Xnmos$5_89 VEVAL VSS m1_n41445_n3773# VSS nmos$5
Xpmos_1891 a_n51035_8021# VDD a_n50888_7802# VDD pmos
Xpmos_1880 a_n51035_5405# VDD a_n50888_5186# VDD pmos
Xnmos$5_507 VEVAL VSS m1_n74564_2767# VSS nmos$5
Xnmos$5_529 VEVAL VSS m1_n77577_6691# VSS nmos$5
Xnmos$5_518 VEVAL VSS m1_n79086_4075# VSS nmos$5
Xpmos$3_19 PC VDD ML_12 VDD pmos$3
Xnmos$2_1281 a_n73156_n5289# VSS ML_25 m1_n73059_n5081# nmos$2
Xnmos$2_1270 WL_24 VSS a_n68957_n3970# SL_8 nmos$2
Xnmos$2_1292 a_n72108_n4050# VSS a_n71647_n3981# SL_6N nmos$2
Xpmos_1110 a_n73470_5186# VDD VDD a_n73617_5405# pmos
Xpmos_1121 a_n68957_7802# VDD VDD a_n69104_8021# pmos
Xpmos_1143 a_n81149_2789# VDD a_n81002_2570# VDD pmos
Xpmos_1132 a_n77988_1262# VDD VDD a_n78135_1481# pmos
Xpmos_1176 a_n76630_8021# VDD a_n76483_7802# VDD pmos
Xpmos_1154 a_n79497_5186# VDD VDD a_n79644_5405# pmos
Xpmos_1165 a_n79644_5405# VDD a_n79497_5186# VDD pmos
Xpmos_303 a_n35829_n7894# VDD VDD a_n35976_n7974# pmos
Xpmos_314 a_n35976_n6666# VDD a_n35829_n6586# VDD pmos
Xpmos_325 a_n35976_n4050# VDD a_n35829_n3970# VDD pmos
Xpmos_1187 a_n76483_11726# VDD VDD a_n76630_11945# pmos
Xpmos_1198 a_n78135_11945# VDD a_n77988_11726# VDD pmos
Xpmos_347 a_n34471_n2742# VDD a_n34324_n2662# VDD pmos
Xpmos_336 a_n38990_n2742# VDD a_n38843_n2662# VDD pmos
Xpmos_358 a_n27618_n6090# VDD VDD m1_n27919_n6078# pmos
Xpmos_369 OUTP VDD VDD a_n28089_n5146# pmos
Xnmos_1052 a_n44870_15650# VSS a_n45017_15869# VSS nmos
Xnmos_1030 a_n50888_14342# VSS a_n51035_14561# VSS nmos
Xnmos_1041 a_n44870_9110# VSS a_n45017_9329# VSS nmos
Xnmos_1074 a_n46369_20882# VSS a_n46516_21101# VSS nmos
Xnmos_1096 a_n52396_20882# VSS a_n52543_21101# VSS nmos
Xnmos_1063 a_n43365_19574# VSS a_n43512_19793# VSS nmos
Xnmos_1085 a_n49383_16958# VSS a_n49530_17177# VSS nmos
Xnmos$3_1023 a_n37485_27641# VSS VSS a_n37338_27422# nmos$3
Xnmos$3_1012 a_n34471_26333# VSS VSS a_n34324_26114# nmos$3
Xnmos$3_1001 a_n37485_22409# VSS VSS a_n37338_22190# nmos$3
Xnmos$3_1045 a_n34471_1481# VSS VSS a_n34324_1262# nmos$3
Xnmos$3_1034 a_n64585_1481# VSS VSS a_n64438_1262# nmos$3
Xpmos_881 a_n60063_5405# VDD a_n59916_5186# VDD pmos
Xpmos_870 a_n60063_4097# VDD a_n59916_3878# VDD pmos
Xnmos$2_4813 WL_0 VSS a_n46369_27422# SL_23 nmos$2
Xnmos$2_4824 a_n49069_26103# VSS ML_1 m1_n48972_26311# nmos$2
Xnmos$2_4802 WL_2 VSS a_n49383_24806# SL_21 nmos$2
Xpmos_892 a_n54048_5405# VDD a_n53901_5186# VDD pmos
Xnmos$2_4846 a_n50888_26114# VSS SL_20 a_n50574_26103# nmos$2
Xnmos$2_4857 WL_1 VSS SL_19N a_n52543_26333# nmos$2
Xnmos$2_4835 a_n52396_24806# VSS SL_19 a_n52082_24795# nmos$2
Xnmos$5_304 VEVAL VSS m1_n67041_n12929# VSS nmos$5
Xnmos$5_315 VEVAL VSS m1_n61014_n9005# VSS nmos$5
Xnmos$5_326 VEVAL VSS m1_n64027_n6389# VSS nmos$5
Xnmos$2_4879 a_n40498_27641# VSS a_n40037_27411# SL_27N nmos$2
Xnmos$2_4868 WL_2 VSS SL_25N a_n43512_25025# nmos$2
Xnmos$5_337 VEVAL VSS m1_n67041_151# VSS nmos$5
Xnmos$5_348 VEVAL VSS m1_n64027_n1157# VSS nmos$5
Xnmos$5_359 VEVAL VSS m1_n58000_n3773# VSS nmos$5
Xnmos$5_871 VEVAL VSS m1_n47463_14539# VSS nmos$5
Xnmos$5_860 VEVAL VSS m1_n51985_9307# VSS nmos$5
Xnmos$5_893 VEVAL VSS m1_n44459_15847# VSS nmos$5
Xnmos$5_882 VEVAL VSS m1_n44459_10615# VSS nmos$5
Xnmos$2_13 a_n34324_n28971# VSS PSL_31 a_n34010_n28982# nmos$2
Xnmos$2_35 a_n41856_n28971# VSS PSL_26 a_n41542_n28982# nmos$2
Xnmos$2_24 a_n44556_n28982# VSS a_n32313_n28669# m1_n44459_n28774# nmos$2
Xnmos$2_68 a_n40351_n13126# VSS SL_27 a_n40037_n13137# nmos$2
Xnmos$2_46 WL VSS a_n49383_n28971# PSL_21 nmos$2
Xnmos$2_57 WL VSS a_n50888_n28971# PSL_20 nmos$2
Xnmos$2_79 WL_29 VSS SL_25N a_n43512_n10590# nmos$2
Xpmos_100 a_n46516_n9282# VDD a_n46369_n9202# VDD pmos
Xpmos_111 a_n48021_n10590# VDD a_n47874_n10510# VDD pmos
Xpmos_133 a_n51035_n6666# VDD a_n50888_n6586# VDD pmos
Xpmos_122 a_n49383_n6586# VDD VDD a_n49530_n6666# pmos
Xnmos_806 a_n61425_24806# VSS a_n61572_25025# VSS nmos
Xnmos_817 a_n67452_24806# VSS a_n67599_25025# VSS nmos
Xpmos_166 a_n49383_n46# VDD VDD a_n49530_173# pmos
Xpmos_155 a_n52396_n46# VDD VDD a_n52543_173# pmos
Xpmos_144 a_n51035_n4050# VDD a_n50888_n3970# VDD pmos
Xnmos_828 a_n58411_24806# VSS a_n58558_25025# VSS nmos
Xnmos$2_4109 a_n40351_7802# VSS SL_27 a_n40037_7791# nmos$2
Xnmos_839 a_n28485_2636# VSS VSS m1_n28364_2461# nmos
Xpmos_177 a_n50888_n6586# VDD VDD a_n51035_n6666# pmos
Xpmos_199 a_n45017_n4050# VDD a_n44870_n3970# VDD pmos
Xpmos_188 a_n40498_n4050# VDD a_n40351_n3970# VDD pmos
Xnmos$2_3408 WL_7 VSS SL_15N a_n58558_18485# nmos$2
Xnmos$2_3419 WL_8 VSS a_n59916_16958# SL_14 nmos$2
Xnmos$2_2707 a_n81002_9110# VSS SL_0 a_n80688_9099# nmos$2
Xnmos$3_808 a_n40498_2789# VSS VSS a_n40351_2570# nmos$3
Xnmos$2_2718 WL_12 VSS a_n81002_11726# SL_0 nmos$2
Xnmos$2_2729 WL_13 VSS a_n79497_10418# SL_1 nmos$2
Xnmos$3_819 a_n45017_6713# VSS VSS a_n44870_6494# nmos$3
Xnmos$2_307 a_n49069_n5289# VSS ML_25 m1_n48972_n5081# nmos$2
Xnmos$2_318 WL_24 VSS a_n47874_n3970# SL_22 nmos$2
Xnmos$2_329 a_n52082_n3981# VSS ML_24 m1_n51985_n3773# nmos$2
Xnmos$2_4610 WL_3 VSS a_n44870_23498# SL_24 nmos$2
Xnmos$2_4621 a_n40498_22409# VSS a_n40037_22179# SL_27N nmos$2
Xnmos$2_4632 a_n43512_22409# VSS a_n43051_22179# SL_25N nmos$2
Xnmos$5_101 VEVAL VSS m1_n41445_151# VSS nmos$5
Xnmos$2_4643 a_n43512_23717# VSS a_n43051_23487# SL_25N nmos$2
Xnmos$2_4654 a_n42003_22409# VSS a_n41542_22179# SL_26N nmos$2
Xnmos$2_4676 a_n49530_18485# VSS a_n49069_18255# SL_21N nmos$2
Xnmos$2_4665 WL_8 VSS a_n46369_16958# SL_23 nmos$2
Xnmos$2_3931 WL_12 VSS a_n37338_11726# SL_29 nmos$2
Xnmos$2_3920 a_n38990_10637# VSS a_n38529_10407# SL_28N nmos$2
Xnmos$5_112 VEVAL VSS m1_n33913_n12929# VSS nmos$5
Xnmos$5_123 VEVAL VSS m1_n36927_n10313# VSS nmos$5
Xnmos$5_134 VEVAL VSS m1_n33913_n6389# VSS nmos$5
Xnmos$2_4687 a_n48021_19793# VSS a_n47560_19563# SL_22N nmos$2
Xnmos$2_4698 a_n54048_17177# VSS a_n53587_16947# SL_18N nmos$2
Xnmos$2_3953 a_n38843_14342# VSS SL_28 a_n38529_14331# nmos$2
Xnmos$2_3964 a_n34010_13023# VSS ML_11 m1_n33913_13231# nmos$2
Xnmos$2_3942 a_n37485_13253# VSS a_n37024_13023# SL_29N nmos$2
Xnmos$5_145 VEVAL VSS m1_n38432_n1157# VSS nmos$5
Xnmos$5_167 VEVAL VSS m1_n71550_n28774# VSS nmos$5
Xnmos$5_156 VEVAL VSS m1_n54999_n28774# VSS nmos$5
Xnmos$2_3986 a_n34471_15869# VSS a_n34010_15639# SL_31N nmos$2
Xnmos$2_3975 a_n35976_14561# VSS a_n35515_14331# SL_30N nmos$2
Xnmos$2_3997 WL_10 VSS a_n35829_14342# SL_30 nmos$2
Xnmos$2_830 a_n65629_n28982# VSS a_n32313_n28669# m1_n65532_n28774# nmos$2
Xnmos$5_178 VEVAL VSS m1_n68546_n10313# VSS nmos$5
Xnmos$5_189 VEVAL VSS m1_n73059_n6389# VSS nmos$5
Xnmos$2_852 WL VSS PSL_6N a_n72108_n29051# nmos$2
Xnmos$2_863 WL VSS a_n68957_n28971# PSL_8 nmos$2
Xnmos$2_841 a_n61111_n28982# VSS a_n32313_n28669# m1_n61014_n28774# nmos$2
Xnmos$2_885 a_n74661_n28982# VSS a_n32313_n28669# m1_n74564_n28774# nmos$2
Xnmos$2_874 WL VSS PSL_2N a_n78135_n29051# nmos$2
Xnmos$2_896 WL VSS a_n81002_n28971# PSL_0 nmos$2
Xnmos$5_690 VEVAL VSS m1_n56504_22387# VSS nmos$5
Xnmos_625 a_n81002_10418# VSS a_n81149_10637# VSS nmos
Xnmos_614 a_n77988_5186# VSS a_n78135_5405# VSS nmos
Xnmos_603 a_n81002_3878# VSS a_n81149_4097# VSS nmos
Xnmos_658 a_n74975_14342# VSS a_n75122_14561# VSS nmos
Xnmos_636 a_n76483_14342# VSS a_n76630_14561# VSS nmos
Xnmos_647 a_n71961_9110# VSS a_n72108_9329# VSS nmos
Xnmos$2_3216 a_n76483_23498# VSS SL_3 a_n76169_23487# nmos$2
Xnmos$2_3205 a_n76169_20871# VSS ML_5 m1_n76072_21079# nmos$2
Xnmos_669 a_n70456_15650# VSS a_n70603_15869# VSS nmos
Xnmos$2_3238 a_n76483_27422# VSS SL_3 a_n76169_27411# nmos$2
Xnmos$2_3249 a_n76630_26333# VSS a_n76169_26103# SL_3N nmos$2
Xnmos$2_3227 a_n74975_24806# VSS SL_4 a_n74661_24795# nmos$2
Xnmos$3_616 a_n70603_21101# VSS VSS a_n70456_20882# nmos$3
Xnmos$3_605 a_n73617_17177# VSS VSS a_n73470_16958# nmos$3
Xnmos$2_2504 a_n72108_8021# VSS a_n71647_7791# SL_6N nmos$2
Xnmos$2_2515 WL_16 VSS SL_8N a_n69104_6713# nmos$2
Xnmos$3_649 a_n76630_22409# VSS VSS a_n76483_22190# nmos$3
Xnmos$3_638 a_n78135_22409# VSS VSS a_n77988_22190# nmos$3
Xnmos$3_627 a_n76630_19793# VSS VSS a_n76483_19574# nmos$3
Xnmos$2_2537 WL_15 VSS a_n67452_7802# SL_9 nmos$2
Xnmos$2_2526 WL_17 VSS a_n70456_5186# SL_7 nmos$2
Xnmos$2_2548 a_n74661_2559# VSS ML_19 m1_n74564_2767# nmos$2
Xnmos$2_1803 a_n58558_n1434# VSS a_n58097_n1365# SL_15N nmos$2
Xnmos$2_104 a_n43365_n13126# VSS SL_25 a_n43051_n13137# nmos$2
Xnmos$2_115 a_n46055_n10521# VSS ML_29 m1_n45958_n10313# nmos$2
Xnmos$2_126 a_n43051_n10521# VSS ML_29 m1_n42954_n10313# nmos$2
Xnmos$2_2559 a_n76483_3878# VSS SL_3 a_n76169_3867# nmos$2
Xnmos$2_1836 WL_21 VSS a_n55410_n46# SL_17 nmos$2
Xnmos$2_1847 a_n56915_n46# VSS SL_16 a_n56601_n57# nmos$2
Xnmos$2_1814 a_n59602_n57# VSS ML_21 m1_n59505_151# nmos$2
Xnmos$2_1825 a_n53587_n1365# VSS ML_22 m1_n53490_n1157# nmos$2
Xnmos$2_137 a_n45017_n9282# VSS a_n44556_n9213# m2_n44135_352# nmos$2
Xnmos$2_159 a_n40351_n9202# VSS SL_27 a_n40037_n9213# nmos$2
Xnmos$2_148 a_n44870_n7894# VSS SL_24 a_n44556_n7905# nmos$2
Xnmos$2_1869 a_n56601_n2673# VSS ML_23 m1_n56504_n2465# nmos$2
Xnmos$2_1858 WL_23 VSS a_n59916_n2662# SL_14 nmos$2
Xpmos_1709 a_n35829_5186# VDD VDD a_n35976_5405# pmos
Xnmos$2_5130 a_n37485_1481# VSS a_n37024_1251# SL_29N nmos$2
Xnmos$2_5152 a_n37338_1262# VSS SL_29 a_n37024_1251# nmos$2
Xnmos$2_5141 a_n74661_1251# VSS ML_20 m1_n74564_1459# nmos$2
Xnmos$2_4440 a_n43365_14342# VSS SL_25 a_n43051_14331# nmos$2
Xnmos$2_5185 a_n46516_1481# VSS a_n46055_1251# SL_23N nmos$2
Xnmos$2_5174 a_n50574_1251# VSS ML_20 m1_n50477_1459# nmos$2
Xnmos$2_5163 a_n52396_1262# VSS SL_19 a_n52082_1251# nmos$2
Xnmos$2_4462 a_n45017_15869# VSS a_n44556_15639# m2_n44135_352# nmos$2
Xnmos$2_4473 a_n40498_14561# VSS a_n40037_14331# SL_27N nmos$2
Xnmos$2_4451 a_n46516_14561# VSS a_n46055_14331# SL_23N nmos$2
Xnmos$2_4484 a_n41542_13023# VSS ML_11 m1_n41445_13231# nmos$2
Xnmos$2_5196 a_n56601_1251# VSS ML_20 m1_n56504_1459# nmos$2
Xnmos$2_3761 WL_0 VSS a_n56915_27422# SL_16 nmos$2
Xnmos$2_3772 a_n59602_26103# VSS ML_1 m1_n59505_26311# nmos$2
Xnmos$2_3750 a_n59916_24806# VSS SL_14 a_n59602_24795# nmos$2
Xnmos$2_4495 a_n41856_15650# VSS SL_26 a_n41542_15639# nmos$2
Xnmos$2_3794 WL_18 VSS SL_31N a_n34471_4097# nmos$2
Xnmos$2_3783 WL_19 VSS a_n34324_2570# SL_31 nmos$2
Xnmos$2_660 WL_28 VSS SL_31N a_n34471_n9282# nmos$2
Xnmos$2_682 WL_27 VSS a_n35829_n7894# SL_30 nmos$2
Xnmos$2_671 WL_27 VSS SL_31N a_n34471_n7974# nmos$2
Xnmos$2_693 a_n34324_n3970# VSS SL_31 a_n34010_n3981# nmos$2
Xpmos$1_30 a_n28089_n6584# VDD a_n26151_n6090# a_n27618_n6090# pmos$1
Xpmos$1_63 a_n28089_10672# VDD m1_n27919_11178# a_n27274_11166# pmos$1
Xpmos$1_52 OUTP VDD a_n27274_8290# m1_n28364_8213# pmos$1
Xpmos$1_41 OUTP VDD m1_n26796_3988# a_n26151_3976# pmos$1
Xpmos$1_96 OUTP VDD m1_n26796_22682# a_n26151_22670# pmos$1
Xpmos$1_85 OUTP VDD m1_n26796_19806# a_n26151_19794# pmos$1
Xpmos$1_74 a_n28089_13548# VDD a_n26151_14042# a_n27618_14042# pmos$1
Xnmos_400 a_n64438_n13126# VSS a_n64585_n13206# VSS nmos
Xnmos_411 a_n65943_n11818# VSS a_n66090_n11898# VSS nmos
Xnmos_422 a_n64438_n6586# VSS a_n64585_n6666# VSS nmos
Xnmos_433 a_n62930_n3970# VSS a_n63077_n4050# VSS nmos
Xnmos_466 a_n56915_n1354# VSS a_n57062_n1434# VSS nmos
Xnmos_444 a_n64438_n1354# VSS a_n64585_n1434# VSS nmos
Xnmos_455 a_n56915_n3970# VSS a_n57062_n4050# VSS nmos
Xnmos$2_3035 a_n73617_22409# VSS a_n73156_22179# SL_5N nmos$2
Xnmos$2_3024 a_n71647_20871# VSS ML_5 m1_n71550_21079# nmos$2
Xnmos$2_3002 a_n73156_19563# VSS ML_6 m1_n73059_19771# nmos$2
Xnmos$2_3013 WL_7 VSS SL_5N a_n73617_18485# nmos$2
Xnmos_488 a_n55410_5186# VSS a_n55557_5405# VSS nmos
Xnmos_477 a_n58411_2570# VSS a_n58558_2789# VSS nmos
Xnmos_499 a_n65943_2570# VSS a_n66090_2789# VSS nmos
Xnmos$2_3046 a_n71961_23498# VSS SL_6 a_n71647_23487# nmos$2
Xnmos$2_3057 a_n67452_22190# VSS SL_9 a_n67138_22179# nmos$2
Xnmos$2_3068 a_n70456_22190# VSS SL_7 a_n70142_22179# nmos$2
Xnmos$2_2312 a_n56601_11715# VSS ML_12 m1_n56504_11923# nmos$2
Xnmos$2_2301 a_n55410_9110# VSS SL_17 a_n55096_9099# nmos$2
Xnmos$2_2323 a_n58411_9110# VSS SL_15 a_n58097_9099# nmos$2
Xnmos$3_402 a_n58558_6713# VSS VSS a_n58411_6494# nmos$3
Xnmos$3_424 a_n61572_5405# VSS VSS a_n61425_5186# nmos$3
Xnmos$3_413 a_n64585_2789# VSS VSS a_n64438_2570# nmos$3
Xnmos$2_3079 a_n68957_23498# VSS SL_8 a_n68643_23487# nmos$2
Xnmos$3_446 a_n64585_15869# VSS VSS a_n64438_15650# nmos$3
Xnmos$2_2356 a_n58411_14342# VSS SL_15 a_n58097_14331# nmos$2
Xnmos$3_457 a_n55557_11945# VSS VSS a_n55410_11726# nmos$3
Xnmos$2_2345 a_n59916_11726# VSS SL_14 a_n59602_11715# nmos$2
Xnmos$2_2334 a_n60063_9329# VSS a_n59602_9099# SL_14N nmos$2
Xnmos$3_435 a_n64585_9329# VSS VSS a_n64438_9110# nmos$3
Xnmos$2_1600 WL_28 VSS a_n64438_n9202# SL_11 nmos$2
Xnmos$2_1611 a_n67138_n7905# VSS ML_27 m1_n67041_n7697# nmos$2
Xnmos$2_2378 a_n59916_15650# VSS SL_14 a_n59602_15639# nmos$2
Xnmos$2_2367 a_n59602_14331# VSS ML_10 m1_n59505_14539# nmos$2
Xnmos$2_2389 WL_11 VSS SL_17N a_n55557_13253# nmos$2
Xnmos$3_479 a_n55557_13253# VSS VSS a_n55410_13034# nmos$3
Xnmos$3_468 a_n57062_13253# VSS VSS a_n56915_13034# nmos$3
Xnmos$2_1622 a_n61425_n9202# VSS SL_13 a_n61111_n9213# nmos$2
Xnmos$2_1633 a_n62616_n7905# VSS ML_27 m1_n62519_n7697# nmos$2
Xnmos$2_1644 a_n61572_n5358# VSS a_n61111_n5289# SL_13N nmos$2
Xnmos$2_1655 a_n62616_n3981# VSS ML_24 m1_n62519_n3773# nmos$2
Xnmos$2_1677 WL_25 VSS a_n65943_n5278# SL_10 nmos$2
Xnmos$2_1688 a_n65629_n5289# VSS ML_25 m1_n65532_n5081# nmos$2
Xnmos$2_1666 WL_24 VSS SL_12N a_n63077_n4050# nmos$2
Xnmos$2_1699 WL_22 VSS a_n65943_n1354# SL_10 nmos$2
Xpmos_2207 ML_4 VDD a_n28485_25644# VDD pmos
Xpmos_2218 a_n26495_21232# VDD VDD m1_n26796_21244# pmos
Xpmos_2229 a_n35829_19574# VDD VDD a_n35976_19793# pmos
Xpmos_1517 a_n55410_23498# VDD VDD a_n55557_23717# pmos
Xpmos_1506 a_n58558_21101# VDD a_n58411_20882# VDD pmos
Xpmos_1528 a_n62930_18266# VDD VDD a_n63077_18485# pmos
Xpmos_1539 a_n65943_18266# VDD VDD a_n66090_18485# pmos
Xnmos$2_4292 WL_12 VSS a_n50888_11726# SL_20 nmos$2
Xnmos$2_4270 a_n50888_10418# VSS SL_20 a_n50574_10407# nmos$2
Xnmos$2_4281 WL_14 VSS a_n52396_9110# SL_19 nmos$2
Xnmos$2_3580 a_n64124_22179# VSS ML_4 m1_n64027_22387# nmos$2
Xnmos$3_980 a_n42003_27641# VSS VSS a_n41856_27422# nmos$3
Xnmos$2_3591 WL_4 VSS a_n65943_22190# SL_10 nmos$2
Xnmos$3_991 a_n35976_17177# VSS VSS a_n35829_16958# nmos$3
Xnmos$2_2890 a_n75122_14561# VSS a_n74661_14331# SL_4N nmos$2
Xnmos$2_490 WL_22 VSS a_n41856_n1354# SL_26 nmos$2
Xnmos$2_9 WL VSS PSL_31N a_n34471_n29051# nmos$2
Xnmos_241 a_n26151_n338# VSS a_n26495_n338# VSS nmos
Xnmos_230 a_n27618_n1776# VSS m1_n27919_n1764# VSS nmos
Xnmos_252 a_n40351_n46# VSS a_n40498_173# VSS nmos
Xnmos_285 a_n71961_n11818# VSS a_n72108_n11898# VSS nmos
Xnmos_274 a_n79497_n28971# VSS a_n79644_n29051# VSS nmos
Xnmos_263 a_n61425_n28971# VSS a_n61572_n29051# VSS nmos
Xnmos_296 a_n73470_n7894# VSS a_n73617_n7974# VSS nmos
Xnmos$2_2120 a_n61425_5186# VSS SL_13 a_n61111_5175# nmos$2
Xnmos$2_2131 a_n63077_5405# VSS a_n62616_5175# SL_12N nmos$2
Xnmos$3_210 a_n75122_n10590# VSS VSS a_n74975_n10510# nmos$3
Xnmos$3_221 a_n81149_n9282# VSS VSS a_n81002_n9202# nmos$3
Xnmos$3_232 a_n76630_n6666# VSS VSS a_n76483_n6586# nmos$3
Xnmos$2_2175 a_n62930_11726# VSS SL_12 a_n62616_11715# nmos$2
Xnmos$2_2153 WL_14 VSS SL_13N a_n61572_9329# nmos$2
Xnmos$2_2164 WL_14 VSS a_n62930_9110# SL_12 nmos$2
Xnmos$2_2142 a_n61572_8021# VSS a_n61111_7791# SL_13N nmos$2
Xnmos$3_276 a_n70603_173# VSS VSS a_n70456_n46# nmos$3
Xnmos$3_254 a_n75122_173# VSS VSS a_n74975_n46# nmos$3
Xnmos$2_1430 a_n56601_n11829# VSS ML_30 m1_n56504_n11621# nmos$2
Xnmos$3_265 a_n69104_n5358# VSS VSS a_n68957_n5278# nmos$3
Xnmos$3_243 a_n81149_n4050# VSS VSS a_n81002_n3970# nmos$3
Xnmos$2_2186 a_n64124_10407# VSS ML_13 m1_n64027_10615# nmos$2
Xnmos$2_2197 a_n65943_10418# VSS SL_10 a_n65629_10407# nmos$2
Xnmos$2_1452 a_n58558_n13206# VSS a_n58097_n13137# SL_15N nmos$2
Xnmos$3_298 a_n58558_n11898# VSS VSS a_n58411_n11818# nmos$3
Xnmos$2_1463 a_n59916_n10510# VSS SL_14 a_n59602_n10521# nmos$2
Xnmos$3_287 a_n55557_n10590# VSS VSS a_n55410_n10510# nmos$3
Xnmos$2_1441 a_n55557_n10590# VSS a_n55096_n10521# SL_17N nmos$2
Xnmos$2_1474 WL_29 VSS a_n58411_n10510# SL_15 nmos$2
Xnmos$2_1485 a_n58411_n9202# VSS SL_15 a_n58097_n9213# nmos$2
Xnmos$2_1496 WL_27 VSS SL_15N a_n58558_n7974# nmos$2
Xpmos_2037 a_n45017_19793# VDD a_n44870_19574# VDD pmos
Xpmos_2026 a_n42003_18485# VDD a_n41856_18266# VDD pmos
Xpmos_2015 a_n40498_15869# VDD a_n40351_15650# VDD pmos
Xpmos_2004 a_n44870_15650# VDD VDD a_n45017_15869# pmos
Xpmos_2059 a_n42003_21101# VDD a_n41856_20882# VDD pmos
Xpmos_2048 a_n46369_20882# VDD VDD a_n46516_21101# pmos
Xpmos_1325 a_n71961_20882# VDD VDD a_n72108_21101# pmos
Xpmos_1314 a_n73617_19793# VDD a_n73470_19574# VDD pmos
Xpmos_1303 a_n68957_18266# VDD VDD a_n69104_18485# pmos
Xpmos_1347 a_n68957_23498# VDD VDD a_n69104_23717# pmos
Xpmos_1336 a_n73470_20882# VDD VDD a_n73617_21101# pmos
Xpmos_1358 a_n76630_18485# VDD a_n76483_18266# VDD pmos
Xpmos_507 a_n78135_n11898# VDD a_n77988_n11818# VDD pmos
Xpmos_1369 a_n81002_16958# VDD VDD a_n81149_17177# pmos
Xpmos_518 a_n81002_n10510# VDD VDD a_n81149_n10590# pmos
Xpmos_529 a_n76483_n10510# VDD VDD a_n76630_n10590# pmos
Xnmos_1201 a_n37338_22190# VSS a_n37485_22409# VSS nmos
Xnmos_1245 a_n26495_29860# VSS VSS COMP1 nmos
Xnmos_1223 a_n37338_27422# VSS a_n37485_27641# VSS nmos
Xnmos_1234 a_n28485_25644# VSS VSS m1_n28364_25469# nmos
Xnmos_1212 a_n34324_24806# VSS a_n34471_25025# VSS nmos
Xnmos_1256 a_n27618_28422# VSS m1_n27919_28434# VSS nmos
Xnmos_1267 a_n40351_23498# VSS a_n40498_23717# VSS nmos
Xnmos_1278 a_n40351_2570# VSS a_n40498_2789# VSS nmos
Xnmos_1289 a_n61425_1262# VSS a_n61572_1481# VSS nmos
Xnmos$5_13 VEVAL VSS m1_n39940_n12929# VSS nmos$5
Xnmos$5_46 VEVAL VSS m1_n48972_n11621# VSS nmos$5
Xnmos$5_24 VEVAL VSS m1_n44459_n10313# VSS nmos$5
Xnmos$5_35 VEVAL VSS m1_n39940_n6389# VSS nmos$5
Xnmos$5_79 VEVAL VSS m1_n47463_n1157# VSS nmos$5
Xnmos$5_57 VEVAL VSS m1_n51985_n6389# VSS nmos$5
Xnmos$5_68 VEVAL VSS m1_n48972_n5081# VSS nmos$5
Xpmos_1881 a_n51035_6713# VDD a_n50888_6494# VDD pmos
Xpmos_1870 a_n52396_1262# VDD VDD a_n52543_1481# pmos
Xpmos_1892 a_n47874_5186# VDD VDD a_n48021_5405# pmos
Xnmos$5_508 VEVAL VSS m1_n77577_1459# VSS nmos$5
Xnmos$5_519 VEVAL VSS m1_n79086_5383# VSS nmos$5
Xnmos$2_1271 WL_25 VSS a_n71961_n5278# SL_6 nmos$2
Xnmos$2_1260 WL_24 VSS a_n70456_n3970# SL_7 nmos$2
Xnmos$2_1282 WL_24 VSS a_n73470_n3970# SL_5 nmos$2
Xnmos$2_1293 WL_24 VSS SL_5N a_n73617_n4050# nmos$2
Xpmos_1100 a_n74975_5186# VDD VDD a_n75122_5405# pmos
Xpmos_1122 a_n67599_8021# VDD a_n67452_7802# VDD pmos
Xpmos_1111 a_n67599_5405# VDD a_n67452_5186# VDD pmos
Xpmos_1133 a_n76630_1481# VDD a_n76483_1262# VDD pmos
Xpmos_1177 a_n77988_7802# VDD VDD a_n78135_8021# pmos
Xpmos_1155 a_n78135_6713# VDD a_n77988_6494# VDD pmos
Xpmos_1166 a_n79644_6713# VDD a_n79497_6494# VDD pmos
Xpmos_1144 a_n81002_1262# VDD VDD a_n81149_1481# pmos
Xpmos_304 a_n34324_n7894# VDD VDD a_n34471_n7974# pmos
Xpmos_315 a_n37338_n5278# VDD VDD a_n37485_n5358# pmos
Xpmos_1199 a_n79497_11726# VDD VDD a_n79644_11945# pmos
Xpmos_1188 a_n77988_10418# VDD VDD a_n78135_10637# pmos
Xpmos_337 a_n38990_173# VDD a_n38843_n46# VDD pmos
Xpmos_348 a_n35829_n2662# VDD VDD a_n35976_n2742# pmos
Xpmos_359 a_n27274_n6090# VDD VDD a_n27618_n6090# pmos
Xpmos_326 a_n37485_n5358# VDD a_n37338_n5278# VDD pmos
Xnmos_1020 a_n53901_13034# VSS a_n54048_13253# VSS nmos
Xnmos_1053 a_n41856_14342# VSS a_n42003_14561# VSS nmos
Xnmos_1042 a_n44870_10418# VSS a_n45017_10637# VSS nmos
Xnmos_1031 a_n50888_9110# VSS a_n51035_9329# VSS nmos
Xnmos_1075 a_n46369_23498# VSS a_n46516_23717# VSS nmos
Xnmos_1064 a_n41856_19574# VSS a_n42003_19793# VSS nmos
Xnmos_1086 a_n49383_18266# VSS a_n49530_18485# VSS nmos
Xnmos_1097 a_n53901_20882# VSS a_n54048_21101# VSS nmos
Xnmos$3_1013 a_n34471_25025# VSS VSS a_n34324_24806# nmos$3
Xnmos$3_1002 a_n35976_22409# VSS VSS a_n35829_22190# nmos$3
Xnmos$3_1024 a_n40498_1481# VSS VSS a_n40351_1262# nmos$3
Xnmos$3_1046 a_n38990_1481# VSS VSS a_n38843_1262# nmos$3
Xnmos$3_1035 a_n55557_1481# VSS VSS a_n55410_1262# nmos$3
Xpmos_860 a_n54048_4097# VDD a_n53901_3878# VDD pmos
Xpmos_871 a_n59916_3878# VDD VDD a_n60063_4097# pmos
Xnmos$2_4814 a_n47560_27411# VSS ML_0 m1_n47463_27619# nmos$2
Xnmos$2_4825 WL_1 VSS a_n49383_26114# SL_21 nmos$2
Xnmos$2_4803 a_n49383_24806# VSS SL_21 a_n49069_24795# nmos$2
Xpmos_893 a_n55410_6494# VDD VDD a_n55557_6713# pmos
Xpmos_882 a_n59916_5186# VDD VDD a_n60063_5405# pmos
Xnmos$2_4858 a_n52543_27641# VSS a_n52082_27411# SL_19N nmos$2
Xnmos$2_4836 a_n52082_27411# VSS ML_0 m1_n51985_27619# nmos$2
Xnmos$2_4847 a_n50574_26103# VSS ML_1 m1_n50477_26311# nmos$2
Xnmos$5_305 VEVAL VSS m1_n67041_n11621# VSS nmos$5
Xnmos$5_316 VEVAL VSS m1_n62519_n9005# VSS nmos$5
Xnmos$2_4869 WL_2 VSS a_n41856_24806# SL_26 nmos$2
Xnmos$5_338 VEVAL VSS m1_n65532_151# VSS nmos$5
Xnmos$5_327 VEVAL VSS m1_n61014_n5081# VSS nmos$5
Xnmos$5_349 VEVAL VSS m1_n64027_n3773# VSS nmos$5
Xnmos$5_872 VEVAL VSS m1_n48972_13231# VSS nmos$5
Xnmos$5_861 VEVAL VSS m1_n51985_10615# VSS nmos$5
Xnmos$5_850 VEVAL VSS m1_n48972_7999# VSS nmos$5
Xnmos$5_894 VEVAL VSS m1_n39940_14539# VSS nmos$5
Xnmos$5_883 VEVAL VSS m1_n44459_9307# VSS nmos$5
Xnmos$2_1090 a_n79497_n9202# VSS SL_1 a_n79183_n9213# nmos$2
Xnmos$2_14 WL VSS a_n35829_n28971# PSL_30 nmos$2
Xnmos$2_25 a_n46516_n29051# VSS a_n46055_n28982# PSL_23N nmos$2
Xnmos$2_69 a_n40037_n13137# VSS ML_31 m1_n39940_n12929# nmos$2
Xnmos$2_36 WL VSS a_n41856_n28971# PSL_26 nmos$2
Xnmos$2_47 WL VSS PSL_22N a_n48021_n29051# nmos$2
Xnmos$2_58 a_n52543_n29051# VSS a_n52082_n28982# PSL_19N nmos$2
Xpmos_112 a_n48021_n9282# VDD a_n47874_n9202# VDD pmos
Xpmos_101 a_n47874_n9202# VDD VDD a_n48021_n9282# pmos
Xpmos_123 a_n49530_n6666# VDD a_n49383_n6586# VDD pmos
Xpmos_134 a_n51035_n5358# VDD a_n50888_n5278# VDD pmos
Xnmos_807 a_n61425_26114# VSS a_n61572_26333# VSS nmos
Xpmos_167 a_n46516_173# VDD a_n46369_n46# VDD pmos
Xpmos_156 a_n51035_173# VDD a_n50888_n46# VDD pmos
Xpmos_145 a_n51035_n1434# VDD a_n50888_n1354# VDD pmos
Xnmos_818 a_n67452_26114# VSS a_n67599_26333# VSS nmos
Xnmos_829 a_n59916_24806# VSS a_n60063_25025# VSS nmos
Xpmos_178 a_n41856_n6586# VDD VDD a_n42003_n6666# pmos
Xpmos_189 a_n41856_n3970# VDD VDD a_n42003_n4050# pmos
Xnmos$2_3409 WL_8 VSS a_n58411_16958# SL_15 nmos$2
Xnmos$2_2719 a_n81002_11726# VSS SL_0 a_n80688_11715# nmos$2
Xnmos$2_2708 WL_14 VSS SL_0N a_n81149_9329# nmos$2
Xnmos$3_809 a_n42003_2789# VSS VSS a_n41856_2570# nmos$3
Xnmos$2_308 a_n49383_n3970# VSS SL_21 a_n49069_n3981# nmos$2
Xnmos$2_319 a_n50888_n5278# VSS SL_20 a_n50574_n5289# nmos$2
Xnmos$2_4611 WL_3 VSS m2_n44135_352# a_n45017_23717# nmos$2
Xnmos$2_4622 WL_4 VSS a_n40351_22190# SL_27 nmos$2
Xnmos$2_4633 WL_5 VSS SL_25N a_n43512_21101# nmos$2
Xnmos$2_4600 a_n46516_22409# VSS a_n46055_22179# SL_23N nmos$2
Xpmos_690 a_n55557_n10590# VDD a_n55410_n10510# VDD pmos
Xnmos$2_4644 WL_3 VSS SL_25N a_n43512_23717# nmos$2
Xnmos$2_4655 a_n47560_16947# VSS ML_8 m1_n47463_17155# nmos$2
Xnmos$2_4666 WL_8 VSS a_n47874_16958# SL_22 nmos$2
Xnmos$2_3910 a_n37024_10407# VSS ML_13 m1_n36927_10615# nmos$2
Xnmos$2_3921 a_n38529_10407# VSS ML_13 m1_n38432_10615# nmos$2
Xnmos$5_102 VEVAL VSS m1_n39940_151# VSS nmos$5
Xnmos$5_113 VEVAL VSS m1_n35418_n12929# VSS nmos$5
Xnmos$5_124 VEVAL VSS m1_n36927_n9005# VSS nmos$5
Xnmos$2_4677 a_n49530_19793# VSS a_n49069_19563# SL_21N nmos$2
Xnmos$2_4688 a_n50574_18255# VSS ML_7 m1_n50477_18463# nmos$2
Xnmos$2_4699 a_n52396_18266# VSS SL_19 a_n52082_18255# nmos$2
Xnmos$2_3954 a_n38990_15869# VSS a_n38529_15639# SL_28N nmos$2
Xnmos$2_3965 a_n34471_13253# VSS a_n34010_13023# SL_31N nmos$2
Xnmos$2_3943 WL_11 VSS SL_29N a_n37485_13253# nmos$2
Xnmos$2_3932 a_n37024_11715# VSS ML_12 m1_n36927_11923# nmos$2
Xnmos$5_146 VEVAL VSS m1_n38432_151# VSS nmos$5
Xnmos$5_168 VEVAL VSS m1_n73059_n28774# VSS nmos$5
Xnmos$5_157 VEVAL VSS m1_n58000_n28774# VSS nmos$5
Xnmos$5_135 VEVAL VSS m1_n33913_n7697# VSS nmos$5
Xnmos$2_3987 WL_9 VSS SL_31N a_n34471_15869# nmos$2
Xnmos$2_3998 a_n35829_14342# VSS SL_30 a_n35515_14331# nmos$2
Xnmos$2_3976 a_n35515_13023# VSS ML_11 m1_n35418_13231# nmos$2
Xnmos$5_179 VEVAL VSS m1_n68546_n11621# VSS nmos$5
Xnmos$2_831 a_n64438_n28971# VSS PSL_11 a_n64124_n28982# nmos$2
Xnmos$2_820 a_n58558_n29051# VSS a_n58097_n28982# PSL_15N nmos$2
Xnmos$2_864 WL VSS a_n71961_n28971# PSL_6 nmos$2
Xnmos$2_853 a_n71961_n28971# VSS PSL_6 a_n71647_n28982# nmos$2
Xnmos$2_842 a_n61425_n28971# VSS PSL_13 a_n61111_n28982# nmos$2
Xnmos$2_897 a_n69104_n13206# VSS a_n68643_n13137# SL_8N nmos$2
Xnmos$2_875 a_n78135_n29051# VSS a_n77674_n28982# PSL_2N nmos$2
Xnmos$2_886 a_n77674_n28982# VSS a_n32313_n28669# m1_n77577_n28774# nmos$2
Xnmos$5_680 VEVAL VSS m1_n58000_19771# VSS nmos$5
Xnmos$5_691 VEVAL VSS m1_n56504_23695# VSS nmos$5
Xnmos_615 a_n77988_7802# VSS a_n78135_8021# VSS nmos
Xnmos_604 a_n79497_3878# VSS a_n79644_4097# VSS nmos
Xnmos_659 a_n74975_13034# VSS a_n75122_13253# VSS nmos
Xnmos_637 a_n77988_13034# VSS a_n78135_13253# VSS nmos
Xnmos_648 a_n71961_10418# VSS a_n72108_10637# VSS nmos
Xnmos_626 a_n81002_9110# VSS a_n81149_9329# VSS nmos
Xnmos$2_3217 WL_3 VSS SL_2N a_n78135_23717# nmos$2
Xnmos$2_3206 a_n76169_22179# VSS ML_4 m1_n76072_22387# nmos$2
Xnmos$2_3239 WL_0 VSS SL_2N a_n78135_27641# nmos$2
Xnmos$2_3228 WL_2 VSS SL_3N a_n76630_25025# nmos$2
Xnmos$3_606 a_n73617_19793# VSS VSS a_n73470_19574# nmos$3
Xnmos$2_2505 a_n71647_7791# VSS ML_15 m1_n71550_7999# nmos$2
Xnmos$3_617 a_n70603_22409# VSS VSS a_n70456_22190# nmos$3
Xnmos$3_639 a_n78135_21101# VSS VSS a_n77988_20882# nmos$3
Xnmos$3_628 a_n75122_19793# VSS VSS a_n74975_19574# nmos$3
Xnmos$2_2538 a_n68957_7802# VSS SL_8 a_n68643_7791# nmos$2
Xnmos$2_2516 a_n68957_6494# VSS SL_8 a_n68643_6483# nmos$2
Xnmos$2_2527 a_n70456_5186# VSS SL_7 a_n70142_5175# nmos$2
Xnmos$2_2549 a_n76630_2789# VSS a_n76169_2559# SL_3N nmos$2
Xnmos$2_1804 a_n58411_n1354# VSS SL_15 a_n58097_n1365# nmos$2
Xnmos$2_105 a_n45017_n13206# VSS a_n44556_n13137# m2_n44135_352# nmos$2
Xnmos$2_116 a_n46055_n11829# VSS ML_30 m1_n45958_n11621# nmos$2
Xnmos$2_1837 a_n56601_n57# VSS ML_21 m1_n56504_151# nmos$2
Xnmos$2_1815 a_n60063_173# VSS a_n59602_n57# SL_14N nmos$2
Xnmos$2_1826 a_n53901_n1354# VSS SL_18 a_n53587_n1365# nmos$2
Xnmos$2_127 WL_29 VSS a_n43365_n10510# SL_25 nmos$2
Xnmos$2_138 a_n43365_n9202# VSS SL_25 a_n43051_n9213# nmos$2
Xnmos$2_149 a_n46516_n7974# VSS a_n46055_n7905# SL_23N nmos$2
Xnmos$2_1848 a_n55096_n2673# VSS ML_23 m1_n54999_n2465# nmos$2
Xnmos$2_1859 a_n56915_n2662# VSS SL_16 a_n56601_n2673# nmos$2
Xnmos$3_90 a_n48021_n2742# VSS VSS a_n47874_n2662# nmos$3
Xnmos$2_5120 a_n34471_1481# VSS a_n34010_1251# SL_31N nmos$2
Xnmos$2_5153 WL_20 VSS a_n35829_1262# SL_30 nmos$2
Xnmos$2_5131 a_n45017_1481# VSS a_n44556_1251# m2_n44135_352# nmos$2
Xnmos$2_5142 WL_20 VSS SL_3N a_n76630_1481# nmos$2
Xnmos$2_4441 WL_11 VSS m2_n44135_352# a_n45017_13253# nmos$2
Xnmos$2_4430 a_n43051_11715# VSS ML_12 m1_n42954_11923# nmos$2
Xnmos$2_5186 WL_20 VSS SL_23N a_n46516_1481# nmos$2
Xnmos$2_5175 WL_20 VSS SL_22N a_n48021_1481# nmos$2
Xnmos$2_5164 a_n52082_1251# VSS ML_20 m1_n51985_1459# nmos$2
Xnmos$2_4463 a_n43051_15639# VSS ML_9 m1_n42954_15847# nmos$2
Xnmos$2_4474 a_n40351_14342# VSS SL_27 a_n40037_14331# nmos$2
Xnmos$2_4452 a_n44870_14342# VSS SL_24 a_n44556_14331# nmos$2
Xnmos$2_5197 a_n57062_1481# VSS a_n56601_1251# SL_16N nmos$2
Xnmos$2_3762 a_n58097_27411# VSS ML_0 m1_n58000_27619# nmos$2
Xnmos$2_3773 a_n59916_26114# VSS SL_14 a_n59602_26103# nmos$2
Xnmos$2_3740 a_n55096_24795# VSS ML_2 m1_n54999_25003# nmos$2
Xnmos$2_3751 a_n59602_24795# VSS ML_2 m1_n59505_25003# nmos$2
Xnmos$2_4496 WL_9 VSS a_n41856_15650# SL_26 nmos$2
Xnmos$2_4485 a_n43512_13253# VSS a_n43051_13023# SL_25N nmos$2
Xnmos$2_3795 a_n34010_3867# VSS ML_18 m1_n33913_4075# nmos$2
Xnmos$2_3784 a_n35976_2789# VSS a_n35515_2559# SL_30N nmos$2
Xnmos$2_661 a_n34324_n9202# VSS SL_31 a_n34010_n9213# nmos$2
Xnmos$2_650 WL_27 VSS SL_28N a_n38990_n7974# nmos$2
Xnmos$2_672 a_n34471_n7974# VSS a_n34010_n7905# SL_31N nmos$2
Xnmos$2_683 WL_28 VSS a_n35829_n9202# SL_30 nmos$2
Xnmos$2_694 WL_24 VSS SL_30N a_n35976_n4050# nmos$2
Xpmos$1_20 OUTP VDD m1_n26796_n6078# a_n26151_n6090# pmos$1
Xpmos$1_31 a_n28089_n5146# VDD a_n26151_n4652# a_n27618_n4652# pmos$1
Xpmos$1_64 OUTP VDD a_n27274_11166# m1_n28364_11089# pmos$1
Xpmos$1_53 OUTP VDD m1_n26796_8302# a_n26151_8290# pmos$1
Xpmos$1_42 a_n28089_3482# VDD m1_n27919_3988# a_n27274_3976# pmos$1
Xpmos$1_97 OUTP VDD a_n27274_22670# m1_n28364_22593# pmos$1
Xpmos$1_86 a_n28089_17862# VDD m1_n27919_18368# a_n27274_18356# pmos$1
Xpmos$1_75 OUTP VDD a_n27274_15480# m1_n28364_15403# pmos$1
Xnmos_401 a_n64438_n11818# VSS a_n64585_n11898# VSS nmos
Xnmos_412 a_n65943_n10510# VSS a_n66090_n10590# VSS nmos
Xnmos_423 a_n64438_n7894# VSS a_n64585_n7974# VSS nmos
Xnmos_434 a_n65943_n5278# VSS a_n66090_n5358# VSS nmos
Xnmos_467 a_n56915_n46# VSS a_n57062_173# VSS nmos
Xnmos_445 a_n64438_n46# VSS a_n64585_173# VSS nmos
Xnmos_456 a_n55410_n3970# VSS a_n55557_n4050# VSS nmos
Xnmos$2_3025 a_n73617_21101# VSS a_n73156_20871# SL_5N nmos$2
Xnmos$2_3003 WL_6 VSS SL_4N a_n75122_19793# nmos$2
Xnmos$2_3014 WL_8 VSS SL_5N a_n73617_17177# nmos$2
Xnmos_489 a_n56915_6494# VSS a_n57062_6713# VSS nmos
Xnmos_478 a_n59916_2570# VSS a_n60063_2789# VSS nmos
Xnmos$2_3047 WL_3 VSS SL_6N a_n72108_23717# nmos$2
Xnmos$2_3058 WL_4 VSS a_n67452_22190# SL_9 nmos$2
Xnmos$2_3036 WL_5 VSS SL_4N a_n75122_21101# nmos$2
Xnmos$2_2313 a_n53901_11726# VSS SL_18 a_n53587_11715# nmos$2
Xnmos$2_2302 WL_13 VSS SL_16N a_n57062_10637# nmos$2
Xnmos$2_2324 WL_14 VSS SL_15N a_n58558_9329# nmos$2
Xnmos$3_425 a_n63077_6713# VSS VSS a_n62930_6494# nmos$3
Xnmos$3_403 a_n54048_5405# VSS VSS a_n53901_5186# nmos$3
Xnmos$3_414 a_n66090_2789# VSS VSS a_n65943_2570# nmos$3
Xnmos$2_3069 WL_4 VSS SL_7N a_n70603_22409# nmos$2
Xnmos$2_2357 a_n58097_14331# VSS ML_10 m1_n58000_14539# nmos$2
Xnmos$3_447 a_n61572_13253# VSS VSS a_n61425_13034# nmos$3
Xnmos$3_458 a_n54048_11945# VSS VSS a_n53901_11726# nmos$3
Xnmos$2_2346 WL_12 VSS SL_14N a_n60063_11945# nmos$2
Xnmos$3_436 a_n64585_10637# VSS VSS a_n64438_10418# nmos$3
Xnmos$2_2335 a_n59602_9099# VSS ML_14 m1_n59505_9307# nmos$2
Xnmos$2_1601 WL_28 VSS SL_10N a_n66090_n9282# nmos$2
Xnmos$2_1612 a_n67599_n7974# VSS a_n67138_n7905# SL_9N nmos$2
Xnmos$2_2379 WL_9 VSS SL_14N a_n60063_15869# nmos$2
Xnmos$3_469 a_n57062_14561# VSS VSS a_n56915_14342# nmos$3
Xnmos$2_2368 a_n60063_13253# VSS a_n59602_13023# SL_14N nmos$2
Xnmos$2_1623 WL_28 VSS SL_13N a_n61572_n9282# nmos$2
Xnmos$2_1634 WL_27 VSS SL_11N a_n64585_n7974# nmos$2
Xnmos$2_1645 a_n61111_n5289# VSS ML_25 m1_n61014_n5081# nmos$2
Xnmos$2_1667 WL_25 VSS SL_12N a_n63077_n5358# nmos$2
Xnmos$2_1678 a_n67138_n3981# VSS ML_24 m1_n67041_n3773# nmos$2
Xnmos$2_1689 a_n65629_n3981# VSS ML_24 m1_n65532_n3773# nmos$2
Xnmos$2_1656 WL_24 VSS SL_11N a_n64585_n4050# nmos$2
Xpmos_2219 OUTP VDD VDD a_n28089_20738# pmos
Xpmos_2208 ML_5 VDD a_n28485_24206# VDD pmos
Xpmos_1507 a_n55410_20882# VDD VDD a_n55557_21101# pmos
Xpmos_1518 a_n54048_23717# VDD a_n53901_23498# VDD pmos
Xpmos_1529 a_n62930_16958# VDD VDD a_n63077_17177# pmos
Xnmos$2_4260 a_n48021_11945# VSS a_n47560_11715# SL_22N nmos$2
Xnmos$2_4271 WL_13 VSS a_n50888_10418# SL_20 nmos$2
Xnmos$2_4282 a_n52396_9110# VSS SL_19 a_n52082_9099# nmos$2
Xnmos_990 a_n53901_5186# VSS a_n54048_5405# VSS nmos
Xnmos$2_3581 a_n64438_22190# VSS SL_11 a_n64124_22179# nmos$2
Xnmos$2_3570 a_n65629_16947# VSS ML_8 m1_n65532_17155# nmos$2
Xnmos$2_4293 WL_14 VSS SL_19N a_n52543_9329# nmos$2
Xnmos$3_970 a_n51035_25025# VSS VSS a_n50888_24806# nmos$3
Xnmos$2_3592 a_n67599_21101# VSS a_n67138_20871# SL_9N nmos$2
Xnmos$3_981 a_n40498_27641# VSS VSS a_n40351_27422# nmos$3
Xnmos$3_992 a_n37485_18485# VSS VSS a_n37338_18266# nmos$3
Xnmos$2_2880 WL_11 VSS SL_6N a_n72108_13253# nmos$2
Xnmos$2_2891 WL_11 VSS a_n73470_13034# SL_5 nmos$2
Xnmos$2_480 a_n40351_n1354# VSS SL_27 a_n40037_n1365# nmos$2
Xnmos$2_491 WL_21 VSS SL_25N a_n43512_173# nmos$2
Xnmos_242 a_n26495_1100# VSS VSS COMP21 nmos
Xnmos_231 m2_n30953_740# VSS VSS m1_n28364_n415# nmos
Xnmos_220 ML_25 VSS VSS a_n28485_n4554# nmos
Xnmos_253 a_n40351_n2662# VSS a_n40498_n2742# VSS nmos
Xnmos_275 a_n68957_n13126# VSS a_n69104_n13206# VSS nmos
Xnmos_264 a_n67452_n28971# VSS a_n67599_n29051# VSS nmos
Xnmos_286 a_n71961_n10510# VSS a_n72108_n10590# VSS nmos
Xnmos_297 a_n73470_n9202# VSS a_n73617_n9282# VSS nmos
Xnmos$2_2110 a_n64438_7802# VSS SL_11 a_n64124_7791# nmos$2
Xnmos$2_2121 WL_17 VSS SL_13N a_n61572_5405# nmos$2
Xnmos$2_2132 a_n62930_5186# VSS SL_12 a_n62616_5175# nmos$2
Xnmos$3_211 a_n78135_n13206# VSS VSS a_n77988_n13126# nmos$3
Xnmos$3_222 a_n79644_n9282# VSS VSS a_n79497_n9202# nmos$3
Xnmos$3_233 a_n75122_n7974# VSS VSS a_n74975_n7894# nmos$3
Xnmos$3_200 a_n67599_n6666# VSS VSS a_n67452_n6586# nmos$3
Xnmos$2_2165 a_n62616_10407# VSS ML_13 m1_n62519_10615# nmos$2
Xnmos$2_2154 a_n61572_9329# VSS a_n61111_9099# SL_13N nmos$2
Xnmos$2_2143 a_n61425_7802# VSS SL_13 a_n61111_7791# nmos$2
Xnmos$3_255 a_n79644_n2742# VSS VSS a_n79497_n2662# nmos$3
Xnmos$2_1420 a_n55410_n13126# VSS SL_17 a_n55096_n13137# nmos$2
Xnmos$3_266 a_n72108_n5358# VSS VSS a_n71961_n5278# nmos$3
Xnmos$3_244 a_n78135_n4050# VSS VSS a_n77988_n3970# nmos$3
Xnmos$2_2176 a_n64585_11945# VSS a_n64124_11715# SL_11N nmos$2
Xnmos$2_2187 a_n66090_10637# VSS a_n65629_10407# SL_10N nmos$2
Xnmos$2_2198 a_n67138_10407# VSS ML_13 m1_n67041_10615# nmos$2
Xnmos$3_277 a_n67599_173# VSS VSS a_n67452_n46# nmos$3
Xnmos$3_299 a_n58558_n13206# VSS VSS a_n58411_n13126# nmos$3
Xnmos$2_1453 WL_31 VSS SL_14N a_n60063_n13206# nmos$2
Xnmos$2_1431 WL_30 VSS SL_16N a_n57062_n11898# nmos$2
Xnmos$3_288 a_n55557_n11898# VSS VSS a_n55410_n11818# nmos$3
Xnmos$2_1442 a_n53587_n11829# VSS ML_30 m1_n53490_n11621# nmos$2
Xnmos$2_1464 a_n59602_n10521# VSS ML_29 m1_n59505_n10313# nmos$2
Xnmos$2_1475 WL_29 VSS a_n56915_n10510# SL_16 nmos$2
Xnmos$2_1486 a_n59916_n9202# VSS SL_14 a_n59602_n9213# nmos$2
Xnmos$2_1497 a_n58558_n7974# VSS a_n58097_n7905# SL_15N nmos$2
Xpmos_2027 a_n43365_18266# VDD VDD a_n43512_18485# pmos
Xpmos_2016 a_n41856_15650# VDD VDD a_n42003_15869# pmos
Xpmos_2005 a_n44870_14342# VDD VDD a_n45017_14561# pmos
Xpmos_2049 a_n46369_22190# VDD VDD a_n46516_22409# pmos
Xpmos_1326 a_n74975_20882# VDD VDD a_n75122_21101# pmos
Xpmos_1304 a_n68957_19574# VDD VDD a_n69104_19793# pmos
Xpmos_2038 a_n45017_18485# VDD a_n44870_18266# VDD pmos
Xpmos_1315 a_n74975_18266# VDD VDD a_n75122_18485# pmos
Xpmos_1348 a_n67599_23717# VDD a_n67452_23498# VDD pmos
Xpmos_1337 a_n73470_22190# VDD VDD a_n73617_22409# pmos
Xpmos_1359 a_n77988_18266# VDD VDD a_n78135_18485# pmos
Xpmos_508 a_n79497_n11818# VDD VDD a_n79644_n11898# pmos
Xpmos_519 a_n81002_n7894# VDD VDD a_n81149_n7974# pmos
Xnmos_1202 a_n38843_22190# VSS a_n38990_22409# VSS nmos
Xnmos_1224 a_n28485_27082# VSS VSS m1_n28364_26907# nmos
Xnmos_1235 OUTP VSS a_n28089_25052# VSS nmos
Xnmos_1213 a_n34324_26114# VSS a_n34471_26333# VSS nmos
Xnmos_1246 a_n26151_29860# VSS a_n26495_29860# VSS nmos
Xnmos_1257 a_n26151_28422# VSS a_n26495_28422# VSS nmos
Xnmos_1268 a_n40351_14342# VSS a_n40498_14561# VSS nmos
Xnmos_1279 a_n40351_3878# VSS a_n40498_4097# VSS nmos
Xnmos$2_4090 a_n40498_5405# VSS a_n40037_5175# SL_27N nmos$2
Xnmos$5_14 VEVAL VSS m1_n41445_n12929# VSS nmos$5
Xnmos$5_47 VEVAL VSS m1_n47463_n10313# VSS nmos$5
Xnmos$5_25 VEVAL VSS m1_n44459_n9005# VSS nmos$5
Xnmos$5_36 VEVAL VSS m1_n39940_n7697# VSS nmos$5
Xnmos$5_58 VEVAL VSS m1_n51985_n7697# VSS nmos$5
Xnmos$5_69 VEVAL VSS m1_n48972_n3773# VSS nmos$5
Xpmos_1882 a_n52396_6494# VDD VDD a_n52543_6713# pmos
Xpmos_1860 a_n49530_1481# VDD a_n49383_1262# VDD pmos
Xpmos_1871 a_n51035_1481# VDD a_n50888_1262# VDD pmos
Xpmos_1893 a_n46516_5405# VDD a_n46369_5186# VDD pmos
Xnmos$5_509 VEVAL VSS m1_n77577_2767# VSS nmos$5
Xnmos$2_1272 a_n71647_n5289# VSS ML_25 m1_n71550_n5081# nmos$2
Xnmos$2_1250 a_n67452_n5278# VSS SL_9 a_n67138_n5289# nmos$2
Xnmos$2_1261 WL_24 VSS SL_7N a_n70603_n4050# nmos$2
Xnmos$2_1294 WL_25 VSS SL_5N a_n73617_n5358# nmos$2
Xnmos$2_1283 a_n73470_n3970# VSS SL_5 a_n73156_n3981# nmos$2
Xpmos_1101 a_n73617_6713# VDD a_n73470_6494# VDD pmos
Xpmos_1123 a_n69104_8021# VDD a_n68957_7802# VDD pmos
Xpmos_1112 a_n68957_5186# VDD VDD a_n69104_5405# pmos
Xpmos_1134 a_n76630_4097# VDD a_n76483_3878# VDD pmos
Xpmos_1167 a_n79644_8021# VDD a_n79497_7802# VDD pmos
Xpmos_1156 a_n79497_6494# VDD VDD a_n79644_6713# pmos
Xpmos_1145 a_n81002_2570# VDD VDD a_n81149_2789# pmos
Xpmos_316 a_n35976_n5358# VDD a_n35829_n5278# VDD pmos
Xpmos_305 a_n34324_n5278# VDD VDD a_n34471_n5358# pmos
Xpmos_1189 a_n75122_10637# VDD a_n74975_10418# VDD pmos
Xpmos_1178 a_n75122_8021# VDD a_n74975_7802# VDD pmos
Xpmos_338 a_n38843_n46# VDD VDD a_n38990_173# pmos
Xpmos_349 a_n34471_n1434# VDD a_n34324_n1354# VDD pmos
Xpmos_327 a_n37485_n6666# VDD a_n37338_n6586# VDD pmos
Xnmos_1010 a_n47874_11726# VSS a_n48021_11945# VSS nmos
Xnmos_1021 a_n53901_15650# VSS a_n54048_15869# VSS nmos
Xnmos_1032 a_n50888_10418# VSS a_n51035_10637# VSS nmos
Xnmos_1043 a_n46369_9110# VSS a_n46516_9329# VSS nmos
Xnmos_1076 a_n44870_23498# VSS a_n45017_23717# VSS nmos
Xnmos_1087 a_n49383_19574# VSS a_n49530_19793# VSS nmos
Xnmos_1065 a_n44870_16958# VSS a_n45017_17177# VSS nmos
Xnmos_1054 a_n41856_13034# VSS a_n42003_13253# VSS nmos
Xnmos_1098 a_n53901_22190# VSS a_n54048_22409# VSS nmos
Xnmos$3_1014 a_n34471_27641# VSS VSS a_n34324_27422# nmos$3
Xnmos$3_1003 a_n37485_21101# VSS VSS a_n37338_20882# nmos$3
Xnmos$3_1025 a_n42003_1481# VSS VSS a_n41856_1262# nmos$3
Xnmos$3_1036 a_n54048_1481# VSS VSS a_n53901_1262# nmos$3
Xnmos$3_1047 a_n67599_1481# VSS VSS a_n67452_1262# nmos$3
Xpmos_1690 a_n37485_1481# VDD a_n37338_1262# VDD pmos
Xpmos_861 a_n55410_3878# VDD VDD a_n55557_4097# pmos
Xpmos_872 a_n57062_4097# VDD a_n56915_3878# VDD pmos
Xpmos_850 a_n55410_2570# VDD VDD a_n55557_2789# pmos
Xnmos$2_4804 WL_0 VSS SL_21N a_n49530_27641# nmos$2
Xnmos$2_4815 a_n47874_26114# VSS SL_22 a_n47560_26103# nmos$2
Xpmos_883 a_n60063_6713# VDD a_n59916_6494# VDD pmos
Xpmos_894 a_n55410_5186# VDD VDD a_n55557_5405# pmos
Xnmos$2_4837 WL_0 VSS a_n52396_27422# SL_19 nmos$2
Xnmos$2_4848 a_n51035_26333# VSS a_n50574_26103# SL_20N nmos$2
Xnmos$2_4826 a_n50888_24806# VSS SL_20 a_n50574_24795# nmos$2
Xnmos$5_306 VEVAL VSS m1_n67041_n10313# VSS nmos$5
Xnmos$5_317 VEVAL VSS m1_n62519_n7697# VSS nmos$5
Xnmos$2_4859 WL_0 VSS SL_19N a_n52543_27641# nmos$2
Xnmos$5_339 VEVAL VSS m1_n61014_n1157# VSS nmos$5
Xnmos$5_328 VEVAL VSS m1_n62519_n5081# VSS nmos$5
Xnmos$5_862 VEVAL VSS m1_n51985_11923# VSS nmos$5
Xnmos$5_851 VEVAL VSS m1_n47463_7999# VSS nmos$5
Xnmos$5_840 VEVAL VSS m1_n50477_5383# VSS nmos$5
Xnmos$5_873 VEVAL VSS m1_n48972_14539# VSS nmos$5
Xnmos$5_895 VEVAL VSS m1_n39940_13231# VSS nmos$5
Xnmos$5_884 VEVAL VSS m1_n45958_9307# VSS nmos$5
Xnmos$2_1080 a_n79644_n11898# VSS a_n79183_n11829# SL_1N nmos$2
Xnmos$2_1091 a_n79183_n9213# VSS ML_28 m1_n79086_n9005# nmos$2
Xnmos$2_15 WL VSS a_n34324_n28971# PSL_31 nmos$2
Xnmos$2_26 WL VSS PSL_23N a_n46516_n29051# nmos$2
Xnmos$2_37 a_n40498_n29051# VSS a_n40037_n28982# PSL_27N nmos$2
Xnmos$2_48 a_n47874_n28971# VSS PSL_22 a_n47560_n28982# nmos$2
Xnmos$2_59 a_n54048_n29051# VSS a_n53587_n28982# PSL_18N nmos$2
Xpmos_113 a_n50888_n9202# VDD VDD a_n51035_n9282# pmos
Xpmos_102 a_n49530_n9282# VDD a_n49383_n9202# VDD pmos
Xpmos_124 a_n49530_n5358# VDD a_n49383_n5278# VDD pmos
Xnmos_808 a_n62930_26114# VSS a_n63077_26333# VSS nmos
Xpmos_157 a_n46516_n1434# VDD a_n46369_n1354# VDD pmos
Xpmos_146 a_n52396_n2662# VDD VDD a_n52543_n2742# pmos
Xpmos_135 a_n52396_n5278# VDD VDD a_n52543_n5358# pmos
Xnmos_819 a_n67452_27422# VSS a_n67599_27641# VSS nmos
Xpmos_168 a_n47874_n46# VDD VDD a_n48021_173# pmos
Xpmos_179 a_n40498_n6666# VDD a_n40351_n6586# VDD pmos
Xnmos$2_2709 a_n81149_9329# VSS a_n80688_9099# SL_0N nmos$2
Xnmos$2_309 WL_24 VSS SL_21N a_n49530_n4050# nmos$2
Xpmos_680 a_n58411_n7894# VDD VDD a_n58558_n7974# pmos
Xnmos$2_4612 a_n45017_23717# VSS a_n44556_23487# m2_n44135_352# nmos$2
Xnmos$2_4623 WL_4 VSS SL_26N a_n42003_22409# nmos$2
Xnmos$2_4601 WL_4 VSS SL_23N a_n46516_22409# nmos$2
Xpmos_691 a_n56915_n10510# VDD VDD a_n57062_n10590# pmos
Xnmos$2_4645 a_n41542_23487# VSS ML_3 m1_n41445_23695# nmos$2
Xnmos$2_4634 WL_5 VSS a_n41856_20882# SL_26 nmos$2
Xnmos$2_4656 WL_7 VSS a_n47874_18266# SL_22 nmos$2
Xnmos$2_4667 WL_7 VSS SL_21N a_n49530_18485# nmos$2
Xnmos$2_3900 a_n35515_11715# VSS ML_12 m1_n35418_11923# nmos$2
Xnmos$2_3922 WL_13 VSS SL_28N a_n38990_10637# nmos$2
Xnmos$2_3911 a_n37485_9329# VSS a_n37024_9099# SL_29N nmos$2
Xnmos$5_103 VEVAL VSS m1_n45958_n2465# VSS nmos$5
Xnmos$5_114 VEVAL VSS m1_n35418_n11621# VSS nmos$5
Xnmos$5_125 VEVAL VSS m1_n38432_n9005# VSS nmos$5
Xnmos$2_4678 WL_6 VSS SL_21N a_n49530_19793# nmos$2
Xnmos$2_4689 a_n51035_18485# VSS a_n50574_18255# SL_20N nmos$2
Xnmos$2_3955 WL_9 VSS a_n38843_15650# SL_28 nmos$2
Xnmos$2_3944 WL_10 VSS a_n38843_14342# SL_28 nmos$2
Xnmos$2_3933 a_n37485_11945# VSS a_n37024_11715# SL_29N nmos$2
Xnmos$5_147 VEVAL VSS m1_n36927_151# VSS nmos$5
Xnmos$5_158 VEVAL VSS m1_n56504_n28774# VSS nmos$5
Xnmos$5_136 VEVAL VSS m1_n33913_n5081# VSS nmos$5
Xnmos$2_3977 a_n35515_14331# VSS ML_10 m1_n35418_14539# nmos$2
Xnmos$2_3966 WL_11 VSS SL_31N a_n34471_13253# nmos$2
Xnmos$2_3988 a_n35829_9110# VSS SL_30 a_n35515_9099# nmos$2
Xnmos$5_169 VEVAL VSS m1_n79086_n28774# VSS nmos$5
Xnmos$2_821 WL VSS a_n59916_n28971# PSL_14 nmos$2
Xnmos$2_810 a_n55096_n28982# VSS a_n32313_n28669# m1_n54999_n28774# nmos$2
Xnmos$2_3999 WL_9 VSS a_n35829_15650# SL_30 nmos$2
Xnmos$2_854 WL VSS a_n67452_n28971# PSL_9 nmos$2
Xnmos$2_832 a_n67138_n28982# VSS a_n32313_n28669# m1_n67041_n28774# nmos$2
Xnmos$2_843 WL VSS a_n62930_n28971# PSL_12 nmos$2
Xnmos$2_898 WL_31 VSS SL_8N a_n69104_n13206# nmos$2
Xnmos$2_876 a_n76630_n29051# VSS a_n76169_n28982# PSL_3N nmos$2
Xnmos$2_887 WL VSS a_n77988_n28971# PSL_2 nmos$2
Xnmos$2_865 WL VSS a_n70456_n28971# PSL_7 nmos$2
Xnmos$5_681 VEVAL VSS m1_n58000_21079# VSS nmos$5
Xnmos$5_670 VEVAL VSS m1_n54999_17155# VSS nmos$5
Xnmos$5_692 VEVAL VSS m1_n54999_23695# VSS nmos$5
Xnmos_616 a_n76483_7802# VSS a_n76630_8021# VSS nmos
Xnmos_605 a_n79497_6494# VSS a_n79644_6713# VSS nmos
Xnmos_638 a_n77988_14342# VSS a_n78135_14561# VSS nmos
Xnmos_627 a_n81002_11726# VSS a_n81149_11945# VSS nmos
Xnmos_649 a_n74975_10418# VSS a_n75122_10637# VSS nmos
Xnmos$2_3207 WL_4 VSS a_n76483_22190# SL_3 nmos$2
Xnmos$2_3229 WL_2 VSS a_n74975_24806# SL_4 nmos$2
Xnmos$2_3218 a_n78135_23717# VSS a_n77674_23487# SL_2N nmos$2
Xnmos$3_607 a_n72108_19793# VSS VSS a_n71961_19574# nmos$3
Xnmos$2_2506 a_n71961_7802# VSS SL_6 a_n71647_7791# nmos$2
Xnmos$3_618 a_n70603_23717# VSS VSS a_n70456_23498# nmos$3
Xnmos$3_629 a_n78135_18485# VSS VSS a_n77988_18266# nmos$3
Xnmos$2_2539 WL_15 VSS SL_8N a_n69104_8021# nmos$2
Xnmos$2_2517 a_n69104_6713# VSS a_n68643_6483# SL_8N nmos$2
Xnmos$2_2528 a_n70142_5175# VSS ML_17 m1_n70045_5383# nmos$2
Xnmos$2_106 a_n43051_n13137# VSS ML_31 m1_n42954_n12929# nmos$2
Xnmos$2_117 a_n44870_n10510# VSS SL_24 a_n44556_n10521# nmos$2
Xnmos$2_1838 a_n57062_173# VSS a_n56601_n57# SL_16N nmos$2
Xnmos$2_1816 WL_21 VSS SL_14N a_n60063_173# nmos$2
Xnmos$2_1827 WL_22 VSS SL_17N a_n55557_n1434# nmos$2
Xnmos$2_1805 WL_22 VSS a_n56915_n1354# SL_16 nmos$2
Xnmos$2_128 a_n43365_n10510# VSS SL_25 a_n43051_n10521# nmos$2
Xnmos$2_139 a_n43051_n9213# VSS ML_28 m1_n42954_n9005# nmos$2
Xnmos$2_1849 a_n56915_n5278# VSS SL_16 a_n56601_n5289# nmos$2
Xnmos$3_80 a_n51035_173# VSS VSS a_n50888_n46# nmos$3
Xnmos$3_91 a_n46516_n2742# VSS VSS a_n46369_n2662# nmos$3
Xnmos$2_5110 WL_1 VSS a_n38843_26114# SL_28 nmos$2
Xnmos$2_5121 WL_20 VSS SL_31N a_n34471_1481# nmos$2
Xnmos$2_5132 WL_20 VSS m2_n44135_352# a_n45017_1481# nmos$2
Xnmos$2_5143 a_n76630_1481# VSS a_n76169_1251# SL_3N nmos$2
Xnmos$2_4431 a_n45017_11945# VSS a_n44556_11715# m2_n44135_352# nmos$2
Xnmos$2_4420 a_n44870_9110# VSS SL_24 a_n44556_9099# nmos$2
Xnmos$2_5154 a_n35829_1262# VSS SL_30 a_n35515_1251# nmos$2
Xnmos$2_5176 a_n47874_1262# VSS SL_22 a_n47560_1251# nmos$2
Xnmos$2_5165 WL_20 VSS SL_20N a_n51035_1481# nmos$2
Xnmos$2_3730 a_n55557_27641# VSS a_n55096_27411# SL_17N nmos$2
Xnmos$2_4464 a_n43365_15650# VSS SL_25 a_n43051_15639# nmos$2
Xnmos$2_4453 WL_10 VSS SL_23N a_n46516_14561# nmos$2
Xnmos$2_4475 a_n40037_13023# VSS ML_11 m1_n39940_13231# nmos$2
Xnmos$2_4442 a_n43051_13023# VSS ML_11 m1_n42954_13231# nmos$2
Xnmos$2_5187 a_n44870_1262# VSS SL_24 a_n44556_1251# nmos$2
Xnmos$2_5198 WL_20 VSS SL_16N a_n57062_1481# nmos$2
Xnmos$2_3763 a_n58558_27641# VSS a_n58097_27411# SL_15N nmos$2
Xnmos$2_3741 a_n55096_26103# VSS ML_1 m1_n54999_26311# nmos$2
Xnmos$2_3752 a_n60063_25025# VSS a_n59602_24795# SL_14N nmos$2
Xnmos$2_4497 WL_9 VSS SL_26N a_n42003_15869# nmos$2
Xnmos$2_4486 a_n43512_14561# VSS a_n43051_14331# SL_25N nmos$2
Xnmos$2_3774 WL_1 VSS a_n59916_26114# SL_14 nmos$2
Xnmos$2_3785 a_n35515_2559# VSS ML_19 m1_n35418_2767# nmos$2
Xnmos$2_3796 WL_19 VSS a_n37338_2570# SL_29 nmos$2
Xnmos$2_640 WL_28 VSS SL_29N a_n37485_n9282# nmos$2
Xnmos$2_662 a_n35976_n9282# VSS a_n35515_n9213# SL_30N nmos$2
Xnmos$2_651 a_n38990_n7974# VSS a_n38529_n7905# SL_28N nmos$2
Xnmos$2_673 a_n34010_n7905# VSS ML_27 m1_n33913_n7697# nmos$2
Xnmos$2_684 a_n34471_n5358# VSS a_n34010_n5289# SL_31N nmos$2
Xnmos$2_695 a_n35515_n3981# VSS ML_24 m1_n35418_n3773# nmos$2
Xpmos$1_10 a_n28089_n8022# VDD a_n26151_n7528# a_n27618_n7528# pmos$1
Xpmos$1_21 a_n28089_n6584# VDD m1_n27919_n6078# a_n27274_n6090# pmos$1
Xpmos$1_54 a_n28089_7796# VDD a_n26151_8290# a_n27618_8290# pmos$1
Xpmos$1_43 OUTP VDD a_n27274_3976# m1_n28364_3899# pmos$1
Xpmos$1_32 OUTP VDD m1_n26796_n1764# a_n26151_n1776# pmos$1
Xpmos$1_98 a_n28089_22176# VDD m1_n27919_22682# a_n27274_22670# pmos$1
Xpmos$1_87 a_n28089_19300# VDD a_n26151_19794# a_n27618_19794# pmos$1
Xpmos$1_76 a_n28089_12110# VDD m1_n27919_12616# a_n27274_12604# pmos$1
Xpmos$1_65 OUTP VDD m1_n26796_11178# a_n26151_11166# pmos$1
Xnmos_402 a_n64438_n10510# VSS a_n64585_n10590# VSS nmos
Xnmos_413 a_n65943_n9202# VSS a_n66090_n9282# VSS nmos
Xnmos_424 a_n62930_n6586# VSS a_n63077_n6666# VSS nmos
Xnmos_446 a_n62930_n46# VSS a_n63077_173# VSS nmos
Xnmos_435 a_n67452_n5278# VSS a_n67599_n5358# VSS nmos
Xnmos_457 a_n58411_n5278# VSS a_n58558_n5358# VSS nmos
Xnmos$2_3015 a_n71961_22190# VSS SL_6 a_n71647_22179# nmos$2
Xnmos$2_3026 WL_4 VSS a_n73470_22190# SL_5 nmos$2
Xnmos$2_3004 a_n75122_19793# VSS a_n74661_19563# SL_4N nmos$2
Xnmos_479 a_n59916_3878# VSS a_n60063_4097# VSS nmos
Xnmos_468 a_n55410_n46# VSS a_n55557_173# VSS nmos
Xnmos$2_3037 a_n73470_23498# VSS SL_5 a_n73156_23487# nmos$2
Xnmos$2_3059 a_n68957_22190# VSS SL_8 a_n68643_22179# nmos$2
Xnmos$2_3048 WL_5 VSS SL_5N a_n73617_21101# nmos$2
Xnmos$2_2314 a_n53587_11715# VSS ML_12 m1_n53490_11923# nmos$2
Xnmos$2_2303 a_n57062_10637# VSS a_n56601_10407# SL_16N nmos$2
Xnmos$3_404 a_n54048_6713# VSS VSS a_n53901_6494# nmos$3
Xnmos$3_415 a_n66090_4097# VSS VSS a_n65943_3878# nmos$3
Xnmos$3_448 a_n61572_14561# VSS VSS a_n61425_14342# nmos$3
Xnmos$2_2347 WL_12 VSS a_n59916_11726# SL_14 nmos$2
Xnmos$2_2336 a_n60063_10637# VSS a_n59602_10407# SL_14N nmos$2
Xnmos$3_437 a_n66090_10637# VSS VSS a_n65943_10418# nmos$3
Xnmos$2_2325 a_n58558_9329# VSS a_n58097_9099# SL_15N nmos$2
Xnmos$3_426 a_n63077_5405# VSS VSS a_n62930_5186# nmos$3
Xnmos$2_1602 a_n64124_n9213# VSS ML_28 m1_n64027_n9005# nmos$2
Xnmos$2_2358 WL_10 VSS a_n56915_14342# SL_16 nmos$2
Xnmos$2_2369 WL_11 VSS a_n59916_13034# SL_14 nmos$2
Xnmos$3_459 a_n57062_9329# VSS VSS a_n56915_9110# nmos$3
Xnmos$2_1624 a_n61111_n9213# VSS ML_28 m1_n61014_n9005# nmos$2
Xnmos$2_1613 a_n64124_n7905# VSS ML_27 m1_n64027_n7697# nmos$2
Xnmos$2_1635 WL_27 VSS a_n62930_n7894# SL_12 nmos$2
Xnmos$2_1646 WL_25 VSS SL_13N a_n61572_n5358# nmos$2
Xnmos$2_1668 a_n66090_n5358# VSS a_n65629_n5289# SL_10N nmos$2
Xnmos$2_1679 WL_24 VSS a_n65943_n3970# SL_10 nmos$2
Xnmos$2_1657 a_n62930_n3970# VSS SL_12 a_n62616_n3981# nmos$2
Xpmos_2209 ML_3 VDD a_n28485_27082# VDD pmos
Xpmos_1508 a_n54048_21101# VDD a_n53901_20882# VDD pmos
Xpmos_1519 a_n61572_17177# VDD a_n61425_16958# VDD pmos
Xnmos$2_4250 WL_14 VSS SL_21N a_n49530_9329# nmos$2
Xnmos_980 a_n47874_2570# VSS a_n48021_2789# VSS nmos
Xnmos$2_4261 a_n47874_11726# VSS SL_22 a_n47560_11715# nmos$2
Xnmos$2_4283 a_n52396_11726# VSS SL_19 a_n52082_11715# nmos$2
Xnmos$2_4272 WL_13 VSS SL_20N a_n51035_10637# nmos$2
Xnmos_991 a_n53901_6494# VSS a_n54048_6713# VSS nmos
Xnmos$2_3560 a_n67138_19563# VSS ML_6 m1_n67041_19771# nmos$2
Xnmos$2_3571 a_n65629_18255# VSS ML_7 m1_n65532_18463# nmos$2
Xnmos$2_4294 a_n52543_9329# VSS a_n52082_9099# SL_19N nmos$2
Xnmos$3_971 a_n51035_26333# VSS VSS a_n50888_26114# nmos$3
Xnmos$2_3593 a_n67138_23487# VSS ML_3 m1_n67041_23695# nmos$2
Xnmos$3_960 a_n48021_22409# VSS VSS a_n47874_22190# nmos$3
Xnmos$2_3582 a_n64124_20871# VSS ML_5 m1_n64027_21079# nmos$2
Xnmos$2_2870 WL_14 VSS SL_5N a_n73617_9329# nmos$2
Xnmos$3_982 a_n43512_26333# VSS VSS a_n43365_26114# nmos$3
Xnmos$3_993 a_n37485_17177# VSS VSS a_n37338_16958# nmos$3
Xnmos$2_2881 WL_10 VSS SL_4N a_n75122_14561# nmos$2
Xnmos$2_2892 a_n73617_13253# VSS a_n73156_13023# SL_5N nmos$2
Xnmos$2_470 a_n44870_n46# VSS SL_24 a_n44556_n57# nmos$2
Xnmos$2_481 a_n40037_n1365# VSS ML_22 m1_n39940_n1157# nmos$2
Xnmos$2_492 a_n43512_173# VSS a_n43051_n57# SL_25N nmos$2
Xnmos_232 a_n28485_1198# VSS VSS m1_n28364_1023# nmos
Xnmos_221 ML_22 VSS VSS m2_n30953_740# nmos
Xnmos_210 a_n27618_n4652# VSS m1_n27919_n4640# VSS nmos
Xnmos_243 OUTP VSS a_n28089_606# VSS nmos
Xnmos_276 a_n70456_n13126# VSS a_n70603_n13206# VSS nmos
Xnmos_265 a_n65943_n28971# VSS a_n66090_n29051# VSS nmos
Xnmos_254 a_n40351_n3970# VSS a_n40498_n4050# VSS nmos
Xnmos_287 a_n73470_n10510# VSS a_n73617_n10590# VSS nmos
Xnmos_298 a_n73470_n6586# VSS a_n73617_n6666# VSS nmos
Xnmos$2_2122 a_n61572_5405# VSS a_n61111_5175# SL_13N nmos$2
Xnmos$2_2111 a_n65629_5175# VSS ML_17 m1_n65532_5383# nmos$2
Xnmos$2_2100 WL_17 VSS a_n65943_5186# SL_10 nmos$2
Xnmos$3_212 a_n81149_n13206# VSS VSS a_n81002_n13126# nmos$3
Xnmos$3_201 a_n67599_n7974# VSS VSS a_n67452_n7894# nmos$3
Xnmos$3_223 a_n81149_n6666# VSS VSS a_n81002_n6586# nmos$3
Xnmos$2_2166 WL_13 VSS a_n62930_10418# SL_12 nmos$2
Xnmos$2_2155 a_n61111_9099# VSS ML_14 m1_n61014_9307# nmos$2
Xnmos$2_2144 a_n61111_7791# VSS ML_15 m1_n61014_7999# nmos$2
Xnmos$2_2133 WL_17 VSS SL_11N a_n64585_5405# nmos$2
Xnmos$3_245 a_n78135_n1434# VSS VSS a_n77988_n1354# nmos$3
Xnmos$3_256 a_n81149_n2742# VSS VSS a_n81002_n2662# nmos$3
Xnmos$2_1421 WL_31 VSS SL_16N a_n57062_n13206# nmos$2
Xnmos$3_234 a_n75122_n6666# VSS VSS a_n74975_n6586# nmos$3
Xnmos$2_1410 a_n70142_n6597# VSS ML_26 m1_n70045_n6389# nmos$2
Xnmos$3_267 a_n73617_n5358# VSS VSS a_n73470_n5278# nmos$3
Xnmos$2_2177 a_n63077_11945# VSS a_n62616_11715# SL_12N nmos$2
Xnmos$2_2199 WL_13 VSS SL_9N a_n67599_10637# nmos$2
Xnmos$2_2188 WL_14 VSS SL_10N a_n66090_9329# nmos$2
Xnmos$3_278 a_n69104_n1434# VSS VSS a_n68957_n1354# nmos$3
Xnmos$2_1454 WL_31 VSS a_n59916_n13126# SL_14 nmos$2
Xnmos$2_1432 a_n57062_n11898# VSS a_n56601_n11829# SL_16N nmos$2
Xnmos$3_289 a_n54048_n11898# VSS VSS a_n53901_n11818# nmos$3
Xnmos$2_1443 WL_29 VSS SL_17N a_n55557_n10590# nmos$2
Xnmos$2_1476 WL_30 VSS a_n58411_n11818# SL_15 nmos$2
Xnmos$2_1465 WL_29 VSS SL_14N a_n60063_n10590# nmos$2
Xnmos$2_1487 WL_28 VSS a_n59916_n9202# SL_14 nmos$2
Xnmos$2_1498 a_n58097_n7905# VSS ML_27 m1_n58000_n7697# nmos$2
Xpmos_2028 a_n43365_19574# VDD VDD a_n43512_19793# pmos
Xpmos_2017 a_n41856_14342# VDD VDD a_n42003_14561# pmos
Xpmos_2006 a_n43512_14561# VDD a_n43365_14342# VDD pmos
Xpmos_2039 a_n46369_19574# VDD VDD a_n46516_19793# pmos
Xpmos_1305 a_n67599_19793# VDD a_n67452_19574# VDD pmos
Xpmos_1316 a_n74975_19574# VDD VDD a_n75122_19793# pmos
Xpmos_1338 a_n73470_23498# VDD VDD a_n73617_23717# pmos
Xpmos_1349 a_n68957_22190# VDD VDD a_n69104_22409# pmos
Xpmos_1327 a_n73617_21101# VDD a_n73470_20882# VDD pmos
Xpmos_509 a_n79644_n11898# VDD a_n79497_n11818# VDD pmos
Xnmos_1236 a_n26495_26984# VSS m1_n26796_26996# VSS nmos
Xnmos_1225 a_n26151_25546# VSS a_n26495_25546# VSS nmos
Xnmos_1214 a_n35829_24806# VSS a_n35976_25025# VSS nmos
Xnmos_1203 a_n38843_20882# VSS a_n38990_21101# VSS nmos
Xnmos_1247 OUTP VSS a_n28089_30804# VSS nmos
Xnmos_1258 a_n26495_28422# VSS VSS COMP2 nmos
Xnmos_1269 a_n40351_15650# VSS a_n40498_15869# VSS nmos
Xnmos$2_4080 a_n40037_6483# VSS ML_16 m1_n39940_6691# nmos$2
Xnmos$2_4091 a_n41856_5186# VSS SL_26 a_n41542_5175# nmos$2
Xnmos$2_3390 WL_6 VSS a_n55410_19574# SL_17 nmos$2
Xnmos$5_15 VEVAL VSS m1_n41445_n11621# VSS nmos$5
Xnmos$5_26 VEVAL VSS m1_n45958_n9005# VSS nmos$5
Xnmos$5_37 VEVAL VSS m1_n42954_n7697# VSS nmos$5
Xnmos$3_790 a_n35976_10637# VSS VSS a_n35829_10418# nmos$3
Xnmos$5_48 VEVAL VSS m1_n47463_n11621# VSS nmos$5
Xnmos$5_59 VEVAL VSS m1_n50477_n7697# VSS nmos$5
Xpmos_1850 a_n42003_8021# VDD a_n41856_7802# VDD pmos
Xpmos_1861 a_n49530_4097# VDD a_n49383_3878# VDD pmos
Xpmos_1872 a_n52543_2789# VDD a_n52396_2570# VDD pmos
Xpmos_1894 a_n47874_6494# VDD VDD a_n48021_6713# pmos
Xpmos_1883 a_n52396_5186# VDD VDD a_n52543_5405# pmos
Xnmos$2_1240 a_n81002_n2662# VSS SL_0 a_n80688_n2673# nmos$2
Xnmos$2_1251 WL_25 VSS a_n67452_n5278# SL_9 nmos$2
Xnmos$2_1262 a_n70456_n3970# VSS SL_7 a_n70142_n3981# nmos$2
Xnmos$2_1295 WL_22 VSS SL_6N a_n72108_n1434# nmos$2
Xnmos$2_1273 a_n72108_n5358# VSS a_n71647_n5289# SL_6N nmos$2
Xnmos$2_1284 a_n73156_n3981# VSS ML_24 m1_n73059_n3773# nmos$2
Xpmos_1113 a_n67599_6713# VDD a_n67452_6494# VDD pmos
Xpmos_1124 a_n69104_6713# VDD a_n68957_6494# VDD pmos
Xpmos_1102 a_n74975_6494# VDD VDD a_n75122_6713# pmos
Xpmos_1157 a_n81002_6494# VDD VDD a_n81149_6713# pmos
Xpmos_1168 a_n75122_5405# VDD a_n74975_5186# VDD pmos
Xpmos_1135 a_n77988_3878# VDD VDD a_n78135_4097# pmos
Xpmos_1146 a_n81149_4097# VDD a_n81002_3878# VDD pmos
Xpmos_306 a_n34324_n6586# VDD VDD a_n34471_n6666# pmos
Xpmos_1179 a_n76483_7802# VDD VDD a_n76630_8021# pmos
Xpmos_339 a_n35976_173# VDD a_n35829_n46# VDD pmos
Xpmos_317 a_n37338_n6586# VDD VDD a_n37485_n6666# pmos
Xpmos_328 a_n37485_n4050# VDD a_n37338_n3970# VDD pmos
Xnmos_1011 a_n52396_9110# VSS a_n52543_9329# VSS nmos
Xnmos_1000 a_n50888_6494# VSS a_n51035_6713# VSS nmos
Xnmos_1022 a_n52396_15650# VSS a_n52543_15869# VSS nmos
Xnmos_1033 a_n50888_11726# VSS a_n51035_11945# VSS nmos
Xnmos_1044 a_n46369_10418# VSS a_n46516_10637# VSS nmos
Xnmos_1077 a_n41856_20882# VSS a_n42003_21101# VSS nmos
Xnmos_1066 a_n44870_18266# VSS a_n45017_18485# VSS nmos
Xnmos_1055 a_n43365_13034# VSS a_n43512_13253# VSS nmos
Xnmos_1099 a_n53901_23498# VSS a_n54048_23717# VSS nmos
Xnmos_1088 a_n47874_19574# VSS a_n48021_19793# VSS nmos
Xnmos$3_1015 a_n35976_26333# VSS VSS a_n35829_26114# nmos$3
Xnmos$3_1004 a_n38990_21101# VSS VSS a_n38843_20882# nmos$3
Xnmos$3_1026 a_n51035_1481# VSS VSS a_n50888_1262# nmos$3
Xnmos$3_1037 a_n63077_1481# VSS VSS a_n62930_1262# nmos$3
Xnmos$3_1048 a_n69104_1481# VSS VSS a_n68957_1262# nmos$3
Xpmos_1680 a_n37338_1262# VDD VDD a_n37485_1481# pmos
Xpmos_1691 a_n37485_2789# VDD a_n37338_2570# VDD pmos
Xpmos_851 a_n54048_2789# VDD a_n53901_2570# VDD pmos
Xpmos_862 a_n57062_2789# VDD a_n56915_2570# VDD pmos
Xpmos_840 a_n61425_n10510# VDD VDD a_n61572_n10590# pmos
Xnmos$2_4805 a_n49383_27422# VSS SL_21 a_n49069_27411# nmos$2
Xnmos$2_4816 WL_1 VSS a_n47874_26114# SL_22 nmos$2
Xpmos_895 a_n54048_6713# VDD a_n53901_6494# VDD pmos
Xpmos_884 a_n59916_6494# VDD VDD a_n60063_6713# pmos
Xpmos_873 a_n58411_3878# VDD VDD a_n58558_4097# pmos
Xnmos$2_4838 a_n52396_27422# VSS SL_19 a_n52082_27411# nmos$2
Xnmos$2_4849 WL_1 VSS SL_20N a_n51035_26333# nmos$2
Xnmos$2_4827 a_n51035_25025# VSS a_n50574_24795# SL_20N nmos$2
Xnmos$5_307 VEVAL VSS m1_n65532_n10313# VSS nmos$5
Xnmos$5_318 VEVAL VSS m1_n62519_n6389# VSS nmos$5
Xnmos$5_329 VEVAL VSS m1_n62519_n3773# VSS nmos$5
Xnmos$5_830 VEVAL VSS m1_n48972_1459# VSS nmos$5
Xnmos$5_863 VEVAL VSS m1_n50477_11923# VSS nmos$5
Xnmos$5_852 VEVAL VSS m1_n47463_9307# VSS nmos$5
Xnmos$5_841 VEVAL VSS m1_n50477_6691# VSS nmos$5
Xnmos$5_874 VEVAL VSS m1_n48972_15847# VSS nmos$5
Xnmos$5_896 VEVAL VSS m1_n41445_14539# VSS nmos$5
Xnmos$5_885 VEVAL VSS m1_n45958_10615# VSS nmos$5
Xnmos$2_1070 WL_29 VSS SL_0N a_n81149_n10590# nmos$2
Xnmos$2_1081 a_n77988_n11818# VSS SL_2 a_n77674_n11829# nmos$2
Xnmos$2_1092 a_n81002_n9202# VSS SL_0 a_n80688_n9213# nmos$2
Xnmos$2_16 a_n35515_n28982# VSS a_n32313_n28669# m1_n35418_n28774# nmos$2
Xnmos$2_38 WL VSS PSL_27N a_n40498_n29051# nmos$2
Xnmos$2_27 a_n41542_n28982# VSS a_n32313_n28669# m1_n41445_n28774# nmos$2
Xnmos$2_49 a_n48021_n29051# VSS a_n47560_n28982# PSL_22N nmos$2
Xpmos_114 a_n50888_n11818# VDD VDD a_n51035_n11898# pmos
Xpmos_103 a_n49383_n10510# VDD VDD a_n49530_n10590# pmos
Xpmos_125 a_n49383_n5278# VDD VDD a_n49530_n5358# pmos
Xpmos_158 a_n47874_n1354# VDD VDD a_n48021_n1434# pmos
Xpmos_147 a_n51035_n2742# VDD a_n50888_n2662# VDD pmos
Xpmos_136 a_n52396_n6586# VDD VDD a_n52543_n6666# pmos
Xnmos_809 a_n62930_24806# VSS a_n63077_25025# VSS nmos
Xpmos_169 a_n48021_n2742# VDD a_n47874_n2662# VDD pmos
Xpmos_670 a_n58411_n10510# VDD VDD a_n58558_n10590# pmos
Xnmos$2_4613 a_n43051_23487# VSS ML_3 m1_n42954_23695# nmos$2
Xnmos$2_4624 a_n40351_22190# VSS SL_27 a_n40037_22179# nmos$2
Xnmos$2_4602 a_n44870_20882# VSS SL_24 a_n44556_20871# nmos$2
Xpmos_692 a_n55557_n9282# VDD a_n55410_n9202# VDD pmos
Xpmos_681 a_n57062_n7974# VDD a_n56915_n7894# VDD pmos
Xnmos$2_4646 WL_3 VSS SL_27N a_n40498_23717# nmos$2
Xnmos$2_4635 a_n41856_20882# VSS SL_26 a_n41542_20871# nmos$2
Xnmos$2_4657 a_n48021_17177# VSS a_n47560_16947# SL_22N nmos$2
Xnmos$2_3901 WL_12 VSS SL_31N a_n34471_11945# nmos$2
Xnmos$2_3912 a_n37024_9099# VSS ML_14 m1_n36927_9307# nmos$2
Xnmos$5_104 VEVAL VSS m1_n44459_n2465# VSS nmos$5
Xnmos$5_115 VEVAL VSS m1_n35418_n10313# VSS nmos$5
Xnmos$2_4679 WL_6 VSS a_n49383_19574# SL_21 nmos$2
Xnmos$2_4668 a_n49383_16958# VSS SL_21 a_n49069_16947# nmos$2
Xnmos$2_3934 a_n37485_14561# VSS a_n37024_14331# SL_29N nmos$2
Xnmos$2_3945 a_n38529_14331# VSS ML_10 m1_n38432_14539# nmos$2
Xnmos$2_3923 a_n38843_10418# VSS SL_28 a_n38529_10407# nmos$2
Xnmos$5_148 VEVAL VSS m1_n33913_n1157# VSS nmos$5
Xnmos$5_159 VEVAL VSS m1_n59505_n28774# VSS nmos$5
Xnmos$5_126 VEVAL VSS m1_n38432_n6389# VSS nmos$5
Xnmos$5_137 VEVAL VSS m1_n35418_n5081# VSS nmos$5
Xnmos$2_3989 a_n35829_15650# VSS SL_30 a_n35515_15639# nmos$2
Xnmos$2_3956 a_n38529_15639# VSS ML_9 m1_n38432_15847# nmos$2
Xnmos$2_3967 a_n34010_14331# VSS ML_10 m1_n33913_14539# nmos$2
Xnmos$2_3978 a_n34324_14342# VSS SL_31 a_n34010_14331# nmos$2
Xnmos$2_822 a_n60063_n29051# VSS a_n59602_n28982# PSL_14N nmos$2
Xnmos$2_811 WL VSS PSL_16N a_n57062_n29051# nmos$2
Xnmos$2_800 WL_26 VSS SL_28N a_n38990_n6666# nmos$2
Xnmos$2_855 WL VSS a_n73470_n28971# PSL_5 nmos$2
Xnmos$2_833 WL VSS PSL_9N a_n67599_n29051# nmos$2
Xnmos$2_844 a_n63077_n29051# VSS a_n62616_n28982# PSL_12N nmos$2
Xnmos$2_888 a_n77988_n28971# VSS PSL_2 a_n77674_n28982# nmos$2
Xnmos$2_877 a_n79644_n29051# VSS a_n79183_n28982# PSL_1N nmos$2
Xnmos$2_866 WL VSS PSL_5N a_n73617_n29051# nmos$2
Xnmos$2_899 a_n67452_n13126# VSS SL_9 a_n67138_n13137# nmos$2
Xnmos$5_660 VEVAL VSS m1_n68546_27619# VSS nmos$5
Xnmos$5_671 VEVAL VSS m1_n56504_17155# VSS nmos$5
Xnmos$5_682 VEVAL VSS m1_n58000_22387# VSS nmos$5
Xnmos$5_693 VEVAL VSS m1_n61014_17155# VSS nmos$5
Xnmos_606 a_n79497_5186# VSS a_n79644_5405# VSS nmos
Xnmos_639 a_n77988_15650# VSS a_n78135_15869# VSS nmos
Xnmos_628 a_n79497_11726# VSS a_n79644_11945# VSS nmos
Xnmos_617 a_n76483_9110# VSS a_n76630_9329# VSS nmos
Xnmos$2_3208 a_n76483_22190# VSS SL_3 a_n76169_22179# nmos$2
Xnmos$2_3219 a_n77674_23487# VSS ML_3 m1_n77577_23695# nmos$2
Xnmos$3_619 a_n67599_23717# VSS VSS a_n67452_23498# nmos$3
Xnmos$3_608 a_n72108_22409# VSS VSS a_n71961_22190# nmos$3
Xnmos$2_2507 WL_15 VSS SL_5N a_n73617_8021# nmos$2
Xnmos$2_2518 WL_16 VSS a_n67452_6494# SL_9 nmos$2
Xnmos$2_2529 a_n70603_5405# VSS a_n70142_5175# SL_7N nmos$2
Xnmos$2_107 WL_31 VSS m2_n44135_352# a_n45017_n13206# nmos$2
Xnmos$2_1817 a_n59916_n46# VSS SL_14 a_n59602_n57# nmos$2
Xnmos$2_1828 a_n55557_n1434# VSS a_n55096_n1365# SL_17N nmos$2
Xnmos$2_1806 WL_22 VSS SL_15N a_n58558_n1434# nmos$2
Xnmos$2_129 a_n45017_n11898# VSS a_n44556_n11829# m2_n44135_352# nmos$2
Xnmos$2_118 WL_29 VSS SL_23N a_n46516_n10590# nmos$2
Xnmos$2_1839 WL_21 VSS SL_16N a_n57062_173# nmos$2
Xnmos$3_81 a_n46516_n1434# VSS VSS a_n46369_n1354# nmos$3
Xnmos$3_92 a_n40498_n5358# VSS VSS a_n40351_n5278# nmos$3
Xnmos$3_70 a_n46516_n4050# VSS VSS a_n46369_n3970# nmos$3
Xnmos$2_5100 WL_0 VSS a_n37338_27422# SL_29 nmos$2
Xnmos$2_5111 a_n38990_26333# VSS a_n38529_26103# SL_28N nmos$2
Xnmos$2_5122 a_n34010_1251# VSS ML_20 m1_n33913_1459# nmos$2
Xnmos$2_5133 a_n43051_1251# VSS ML_20 m1_n42954_1459# nmos$2
Xnmos$2_5144 a_n80688_1251# VSS ML_20 m1_n80591_1459# nmos$2
Xnmos$2_4432 WL_12 VSS a_n43365_11726# SL_25 nmos$2
Xnmos$2_4410 WL_13 VSS m2_n44135_352# a_n45017_10637# nmos$2
Xnmos$2_4421 WL_13 VSS a_n44870_10418# SL_24 nmos$2
Xnmos$2_5166 a_n51035_1481# VSS a_n50574_1251# SL_20N nmos$2
Xnmos$2_5177 WL_20 VSS a_n52396_1262# SL_19 nmos$2
Xnmos$2_5155 a_n77674_1251# VSS ML_20 m1_n77577_1459# nmos$2
Xnmos$2_3720 a_n57062_25025# VSS a_n56601_24795# SL_16N nmos$2
Xnmos$2_4465 WL_9 VSS a_n43365_15650# SL_25 nmos$2
Xnmos$2_4454 a_n46055_14331# VSS ML_10 m1_n45958_14539# nmos$2
Xnmos$2_4443 a_n45017_13253# VSS a_n44556_13023# m2_n44135_352# nmos$2
Xnmos$2_5188 WL_20 VSS a_n44870_1262# SL_24 nmos$2
Xnmos$2_5199 a_n55410_1262# VSS SL_17 a_n55096_1251# nmos$2
Xnmos$2_3742 a_n55096_27411# VSS ML_0 m1_n54999_27619# nmos$2
Xnmos$2_3764 WL_0 VSS SL_15N a_n58558_27641# nmos$2
Xnmos$2_3731 WL_1 VSS SL_17N a_n55557_26333# nmos$2
Xnmos$2_3753 WL_2 VSS a_n59916_24806# SL_14 nmos$2
Xnmos$2_4498 a_n40037_15639# VSS ML_9 m1_n39940_15847# nmos$2
Xnmos$2_4487 WL_10 VSS SL_25N a_n43512_14561# nmos$2
Xnmos$2_4476 a_n40498_13253# VSS a_n40037_13023# SL_27N nmos$2
Xnmos$2_3775 a_n60063_26333# VSS a_n59602_26103# SL_14N nmos$2
Xnmos$2_3786 a_n34324_2570# VSS SL_31 a_n34010_2559# nmos$2
Xnmos$2_3797 a_n37338_2570# VSS SL_29 a_n37024_2559# nmos$2
Xnmos$2_630 WL_30 VSS SL_29N a_n37485_n11898# nmos$2
Xnmos$2_641 a_n37338_n9202# VSS SL_29 a_n37024_n9213# nmos$2
Xnmos$2_663 WL_28 VSS SL_30N a_n35976_n9282# nmos$2
Xnmos$2_652 WL_27 VSS a_n38843_n7894# SL_28 nmos$2
Xnmos$2_674 a_n35829_n10510# VSS SL_30 a_n35515_n10521# nmos$2
Xnmos$2_685 WL_25 VSS SL_31N a_n34471_n5358# nmos$2
Xnmos$2_696 WL_24 VSS a_n34324_n3970# SL_31 nmos$2
Xnmos$5_490 VEVAL VSS m1_n73059_4075# VSS nmos$5
Xpmos$1_11 a_n28089_n9460# VDD a_n26151_n8966# a_n27618_n8966# pmos$1
Xpmos$1_22 OUTP VDD a_n27274_n6090# m1_n28364_n6167# pmos$1
Xpmos$1_55 OUTP VDD a_n27274_6852# m1_n28364_6775# pmos$1
Xpmos$1_44 a_n28089_2044# VDD a_n26151_2538# a_n27618_2538# pmos$1
Xpmos$1_33 a_n28089_n2270# VDD m1_n27919_n1764# a_n27274_n1776# pmos$1
Xpmos$1_88 OUTP VDD m1_n26796_18368# a_n26151_18356# pmos$1
Xpmos$1_77 OUTP VDD a_n27274_12604# m1_n28364_12527# pmos$1
Xpmos$1_66 a_n28089_9234# VDD a_n26151_9728# a_n27618_9728# pmos$1
Xpmos$1_99 OUTP VDD m1_n26796_21244# a_n26151_21232# pmos$1
Xnmos_403 a_n62930_n11818# VSS a_n63077_n11898# VSS nmos
Xnmos_414 a_n67452_n9202# VSS a_n67599_n9282# VSS nmos
Xnmos_425 a_n61425_n6586# VSS a_n61572_n6666# VSS nmos
Xnmos_447 a_n61425_n46# VSS a_n61572_173# VSS nmos
Xnmos_458 a_n59916_n5278# VSS a_n60063_n5358# VSS nmos
Xnmos_436 a_n67452_n3970# VSS a_n67599_n4050# VSS nmos
Xnmos$2_3016 a_n72108_22409# VSS a_n71647_22179# SL_6N nmos$2
Xnmos$2_3005 a_n73617_19793# VSS a_n73156_19563# SL_5N nmos$2
Xnmos_469 a_n55410_n2662# VSS a_n55557_n2742# VSS nmos
Xnmos$2_3038 a_n73617_23717# VSS a_n73156_23487# SL_5N nmos$2
Xnmos$2_3049 WL_3 VSS SL_5N a_n73617_23717# nmos$2
Xnmos$2_3027 a_n73470_22190# VSS SL_5 a_n73156_22179# nmos$2
Xnmos$2_2315 WL_12 VSS a_n53901_11726# SL_18 nmos$2
Xnmos$2_2304 a_n56601_10407# VSS ML_13 m1_n56504_10615# nmos$2
Xnmos$3_405 a_n55557_5405# VSS VSS a_n55410_5186# nmos$3
Xnmos$3_416 a_n64585_4097# VSS VSS a_n64438_3878# nmos$3
Xnmos$3_449 a_n63077_13253# VSS VSS a_n62930_13034# nmos$3
Xnmos$2_2348 WL_12 VSS a_n58411_11726# SL_15 nmos$2
Xnmos$2_2326 a_n58097_9099# VSS ML_14 m1_n58000_9307# nmos$2
Xnmos$2_2337 WL_14 VSS SL_14N a_n60063_9329# nmos$2
Xnmos$3_438 a_n66090_9329# VSS VSS a_n65943_9110# nmos$3
Xnmos$3_427 a_n63077_8021# VSS VSS a_n62930_7802# nmos$3
Xnmos$2_1603 a_n67138_n9213# VSS ML_28 m1_n67041_n9005# nmos$2
Xnmos$2_2359 WL_11 VSS a_n58411_13034# SL_15 nmos$2
Xnmos$2_1625 a_n63077_n9282# VSS a_n62616_n9213# SL_12N nmos$2
Xnmos$2_1614 WL_27 VSS a_n64438_n7894# SL_11 nmos$2
Xnmos$2_1636 a_n62930_n7894# VSS SL_12 a_n62616_n7905# nmos$2
Xnmos$2_1669 WL_25 VSS a_n64438_n5278# SL_11 nmos$2
Xnmos$2_1647 WL_25 VSS a_n61425_n5278# SL_13 nmos$2
Xnmos$2_1658 a_n63077_n4050# VSS a_n62616_n3981# SL_12N nmos$2
Xpmos_1509 a_n56915_20882# VDD VDD a_n57062_21101# pmos
Xnmos$2_4240 a_n47874_10418# VSS SL_22 a_n47560_10407# nmos$2
Xnmos_970 a_n46369_6494# VSS a_n46516_6713# VSS nmos
Xnmos$2_4262 WL_12 VSS a_n47874_11726# SL_22 nmos$2
Xnmos$2_4273 WL_13 VSS SL_18N a_n54048_10637# nmos$2
Xnmos$2_4251 a_n49383_9110# VSS SL_21 a_n49069_9099# nmos$2
Xnmos_992 a_n53901_7802# VSS a_n54048_8021# VSS nmos
Xnmos_981 a_n49383_2570# VSS a_n49530_2789# VSS nmos
Xnmos$2_3572 a_n65629_19563# VSS ML_6 m1_n65532_19771# nmos$2
Xnmos$2_3561 a_n67599_19793# VSS a_n67138_19563# SL_9N nmos$2
Xnmos$2_3550 a_n65943_16958# VSS SL_10 a_n65629_16947# nmos$2
Xnmos$2_4295 WL_12 VSS SL_19N a_n52543_11945# nmos$2
Xnmos$2_4284 WL_12 VSS SL_18N a_n54048_11945# nmos$2
Xnmos$3_961 a_n46516_26333# VSS VSS a_n46369_26114# nmos$3
Xnmos$3_950 a_n52543_23717# VSS VSS a_n52396_23498# nmos$3
Xnmos$2_3594 a_n65943_23498# VSS SL_10 a_n65629_23487# nmos$2
Xnmos$2_3583 a_n67138_20871# VSS ML_5 m1_n67041_21079# nmos$2
Xnmos$2_2860 a_n75122_11945# VSS a_n74661_11715# SL_4N nmos$2
Xnmos$3_983 a_n43512_25025# VSS VSS a_n43365_24806# nmos$3
Xnmos$3_972 a_n52543_25025# VSS VSS a_n52396_24806# nmos$3
Xnmos$3_994 a_n35976_18485# VSS VSS a_n35829_18266# nmos$3
Xnmos$2_2893 a_n73470_15650# VSS SL_5 a_n73156_15639# nmos$2
Xnmos$2_2882 a_n73470_14342# VSS SL_5 a_n73156_14331# nmos$2
Xnmos$2_2871 a_n72108_13253# VSS a_n71647_13023# SL_6N nmos$2
Xnmos$2_471 WL_21 VSS SL_23N a_n46516_173# nmos$2
Xnmos$2_460 a_n43365_n1354# VSS SL_25 a_n43051_n1365# nmos$2
Xnmos$2_493 a_n41542_n57# VSS ML_21 m1_n41445_151# nmos$2
Xnmos$2_482 WL_22 VSS SL_26N a_n42003_n1434# nmos$2
Xnmos_200 a_n26495_n4652# VSS m1_n26796_n4640# VSS nmos
Xnmos_233 a_n27618_1100# VSS m1_n27919_1112# VSS nmos
Xnmos_222 ML_23 VSS VSS m2_n30953_n488# nmos
Xnmos_211 a_n27618_n3214# VSS m1_n27919_n3202# VSS nmos
Xnmos_244 a_n26495_1100# VSS m1_n26796_1112# VSS nmos
Xnmos_255 a_n40351_n1354# VSS a_n40498_n1434# VSS nmos
Xnmos_266 a_n73470_n28971# VSS a_n73617_n29051# VSS nmos
Xnmos_277 a_n70456_n11818# VSS a_n70603_n11898# VSS nmos
Xnmos_288 a_n73470_n13126# VSS a_n73617_n13206# VSS nmos
Xnmos_299 a_n68957_n9202# VSS a_n69104_n9282# VSS nmos
Xnmos$2_2112 a_n65629_7791# VSS ML_15 m1_n65532_7999# nmos$2
Xnmos$2_2101 a_n67599_8021# VSS a_n67138_7791# SL_9N nmos$2
Xnmos$2_2123 WL_16 VSS SL_13N a_n61572_6713# nmos$2
Xnmos$3_213 a_n79644_n13206# VSS VSS a_n79497_n13126# nmos$3
Xnmos$3_224 a_n81149_n7974# VSS VSS a_n81002_n7894# nmos$3
Xnmos$3_202 a_n69104_n7974# VSS VSS a_n68957_n7894# nmos$3
Xnmos$2_2156 WL_13 VSS SL_13N a_n61572_10637# nmos$2
Xnmos$2_2145 WL_15 VSS a_n61425_7802# SL_13 nmos$2
Xnmos$2_2134 a_n64585_5405# VSS a_n64124_5175# SL_11N nmos$2
Xnmos$3_246 a_n81149_n1434# VSS VSS a_n81002_n1354# nmos$3
Xnmos$3_257 a_n78135_n2742# VSS VSS a_n77988_n2662# nmos$3
Xnmos$2_1400 a_n75122_n6666# VSS a_n74661_n6597# SL_4N nmos$2
Xnmos$2_1411 WL_26 VSS a_n70456_n6586# SL_7 nmos$2
Xnmos$3_235 a_n75122_n5358# VSS VSS a_n74975_n5278# nmos$3
Xnmos$2_2178 a_n61425_11726# VSS SL_13 a_n61111_11715# nmos$2
Xnmos$2_2167 a_n64585_10637# VSS a_n64124_10407# SL_11N nmos$2
Xnmos$2_2189 a_n66090_9329# VSS a_n65629_9099# SL_10N nmos$2
Xnmos$3_279 a_n69104_173# VSS VSS a_n68957_n46# nmos$3
Xnmos$2_1422 a_n56601_n13137# VSS ML_31 m1_n56504_n12929# nmos$2
Xnmos$2_1444 a_n55096_n11829# VSS ML_30 m1_n54999_n11621# nmos$2
Xnmos$2_1433 WL_29 VSS SL_16N a_n57062_n10590# nmos$2
Xnmos$3_268 a_n73617_n4050# VSS VSS a_n73470_n3970# nmos$3
Xnmos$2_1455 a_n59916_n13126# VSS SL_14 a_n59602_n13137# nmos$2
Xnmos$2_1466 a_n60063_n11898# VSS a_n59602_n11829# SL_14N nmos$2
Xnmos$2_1477 WL_30 VSS a_n56915_n11818# SL_16 nmos$2
Xnmos$2_1488 WL_28 VSS SL_14N a_n60063_n9282# nmos$2
Xnmos$2_1499 WL_27 VSS a_n56915_n7894# SL_16 nmos$2
Xpmos_2018 a_n40498_14561# VDD a_n40351_14342# VDD pmos
Xpmos_2007 a_n46369_14342# VDD VDD a_n46516_14561# pmos
Xpmos_2029 a_n41856_19574# VDD VDD a_n42003_19793# pmos
Xpmos_1306 a_n69104_19793# VDD a_n68957_19574# VDD pmos
Xpmos_1317 a_n72108_18485# VDD a_n71961_18266# VDD pmos
Xpmos_1328 a_n74975_23498# VDD VDD a_n75122_23717# pmos
Xpmos_1339 a_n67599_21101# VDD a_n67452_20882# VDD pmos
Xnmos_1226 a_n27618_26984# VSS m1_n27919_26996# VSS nmos
Xnmos_1215 a_n35829_26114# VSS a_n35976_26333# VSS nmos
Xnmos_1204 a_n38843_23498# VSS a_n38990_23717# VSS nmos
Xnmos_1248 a_n26495_29860# VSS m1_n26796_29872# VSS nmos
Xnmos_1259 a_n26495_28422# VSS m1_n26796_28434# VSS nmos
Xnmos_1237 a_n26151_26984# VSS a_n26495_26984# VSS nmos
Xnmos$2_4070 a_n44870_7802# VSS SL_24 a_n44556_7791# nmos$2
Xnmos$2_4081 a_n40351_5186# VSS SL_27 a_n40037_5175# nmos$2
Xnmos$2_4092 WL_17 VSS SL_25N a_n43512_5405# nmos$2
Xnmos$2_3380 a_n55410_18266# VSS SL_17 a_n55096_18255# nmos$2
Xnmos$2_3391 WL_6 VSS a_n53901_19574# SL_18 nmos$2
Xnmos$3_780 a_n35976_8021# VSS VSS a_n35829_7802# nmos$3
Xnmos$5_38 VEVAL VSS m1_n42954_n10313# VSS nmos$5
Xnmos$5_16 VEVAL VSS m1_n41445_n10313# VSS nmos$5
Xnmos$5_27 VEVAL VSS m1_n45958_n7697# VSS nmos$5
Xnmos$2_2690 a_n76630_11945# VSS a_n76169_11715# SL_3N nmos$2
Xnmos$3_791 a_n38990_9329# VSS VSS a_n38843_9110# nmos$3
Xnmos$5_49 VEVAL VSS m1_n50477_n12929# VSS nmos$5
Xnmos$2_290 a_n49069_n7905# VSS ML_27 m1_n48972_n7697# nmos$2
Xpmos_1851 a_n41856_7802# VDD VDD a_n42003_8021# pmos
Xpmos_1840 a_n43512_8021# VDD a_n43365_7802# VDD pmos
Xpmos_1862 a_n49383_3878# VDD VDD a_n49530_4097# pmos
Xpmos_1895 a_n46516_6713# VDD a_n46369_6494# VDD pmos
Xpmos_1884 a_n53901_6494# VDD VDD a_n54048_6713# pmos
Xpmos_1873 a_n52543_1481# VDD a_n52396_1262# VDD pmos
Xnmos$2_1230 a_n78135_n2742# VSS a_n77674_n2673# SL_2N nmos$2
Xnmos$2_1241 WL_23 VSS a_n81002_n2662# SL_0 nmos$2
Xnmos$2_1252 a_n68643_n5289# VSS ML_25 m1_n68546_n5081# nmos$2
Xnmos$2_1263 WL_24 VSS a_n67452_n3970# SL_9 nmos$2
Xnmos$2_1296 a_n72108_n1434# VSS a_n71647_n1365# SL_6N nmos$2
Xnmos$2_1274 WL_25 VSS SL_6N a_n72108_n5358# nmos$2
Xnmos$2_1285 a_n73617_n4050# VSS a_n73156_n3981# SL_5N nmos$2
Xpmos_1114 a_n68957_6494# VDD VDD a_n69104_6713# pmos
Xpmos_1125 a_n69104_5405# VDD a_n68957_5186# VDD pmos
Xpmos_1103 a_n73617_5405# VDD a_n73470_5186# VDD pmos
Xpmos_1158 a_n81149_5405# VDD a_n81002_5186# VDD pmos
Xpmos_1136 a_n75122_4097# VDD a_n74975_3878# VDD pmos
Xpmos_1147 a_n81002_3878# VDD VDD a_n81149_4097# pmos
Xpmos_307 a_n35829_n6586# VDD VDD a_n35976_n6666# pmos
Xpmos_1169 a_n75122_6713# VDD a_n74975_6494# VDD pmos
Xpmos_329 a_n37338_n1354# VDD VDD a_n37485_n1434# pmos
Xpmos_318 a_n38843_n5278# VDD VDD a_n38990_n5358# pmos
Xnmos_1001 a_n50888_7802# VSS a_n51035_8021# VSS nmos
Xnmos_1023 a_n47874_13034# VSS a_n48021_13253# VSS nmos
Xnmos_1034 a_n50888_13034# VSS a_n51035_13253# VSS nmos
Xnmos_1012 a_n52396_10418# VSS a_n52543_10637# VSS nmos
Xnmos_1078 a_n41856_22190# VSS a_n42003_22409# VSS nmos
Xnmos_1067 a_n46369_18266# VSS a_n46516_18485# VSS nmos
Xnmos_1056 a_n43365_14342# VSS a_n43512_14561# VSS nmos
Xnmos_1045 a_n46369_11726# VSS a_n46516_11945# VSS nmos
Xnmos_1089 a_n52396_16958# VSS a_n52543_17177# VSS nmos
Xnmos$3_1005 a_n38990_22409# VSS VSS a_n38843_22190# nmos$3
Xnmos$3_1016 a_n37485_26333# VSS VSS a_n37338_26114# nmos$3
Xnmos$3_1027 a_n43512_1481# VSS VSS a_n43365_1262# nmos$3
Xnmos$3_1038 a_n61572_1481# VSS VSS a_n61425_1262# nmos$3
Xnmos$3_1049 a_n75122_1481# VSS VSS a_n74975_1262# nmos$3
Xpmos_2360 a_n40351_23498# VDD VDD a_n40498_23717# pmos
Xpmos_1681 a_n38990_2789# VDD a_n38843_2570# VDD pmos
Xpmos_1670 a_n34471_1481# VDD a_n34324_1262# VDD pmos
Xpmos_1692 a_n35976_6713# VDD a_n35829_6494# VDD pmos
Xpmos_852 a_n54048_1481# VDD a_n53901_1262# VDD pmos
Xpmos_863 a_n58411_1262# VDD VDD a_n58558_1481# pmos
Xpmos_830 a_n55410_n2662# VDD VDD a_n55557_n2742# pmos
Xpmos_841 a_n61425_n11818# VDD VDD a_n61572_n11898# pmos
Xnmos$2_4806 a_n49530_27641# VSS a_n49069_27411# SL_21N nmos$2
Xpmos_885 a_n60063_8021# VDD a_n59916_7802# VDD pmos
Xpmos_896 a_n56915_6494# VDD VDD a_n57062_6713# pmos
Xpmos_874 a_n58558_1481# VDD a_n58411_1262# VDD pmos
Xnmos$2_4839 a_n54048_27641# VSS a_n53587_27411# SL_18N nmos$2
Xnmos$2_4817 a_n49530_26333# VSS a_n49069_26103# SL_21N nmos$2
Xnmos$2_4828 a_n50574_24795# VSS ML_2 m1_n50477_25003# nmos$2
Xnmos$5_308 VEVAL VSS m1_n65532_n11621# VSS nmos$5
Xnmos$5_319 VEVAL VSS m1_n61014_n7697# VSS nmos$5
Xnmos$5_820 VEVAL VSS m1_n41445_7999# VSS nmos$5
Xnmos$5_853 VEVAL VSS m1_n47463_10615# VSS nmos$5
Xnmos$5_842 VEVAL VSS m1_n51985_5383# VSS nmos$5
Xnmos$5_831 VEVAL VSS m1_n48972_2767# VSS nmos$5
Xnmos$5_875 VEVAL VSS m1_n47463_15847# VSS nmos$5
Xnmos$5_897 VEVAL VSS m1_n41445_13231# VSS nmos$5
Xnmos$5_864 VEVAL VSS m1_n50477_13231# VSS nmos$5
Xnmos$5_886 VEVAL VSS m1_n45958_11923# VSS nmos$5
Xnmos$2_1071 WL_30 VSS SL_1N a_n79644_n11898# nmos$2
Xnmos$2_1060 a_n81002_n13126# VSS SL_0 a_n80688_n13137# nmos$2
Xnmos$2_1082 a_n79644_n10590# VSS a_n79183_n10521# SL_1N nmos$2
Xnmos$2_1093 a_n81149_n9282# VSS a_n80688_n9213# SL_0N nmos$2
Xnmos$2_17 WL VSS PSL_28N a_n38990_n29051# nmos$2
Xnmos$2_28 a_n43365_n28971# VSS PSL_25 a_n43051_n28982# nmos$2
Xnmos$2_39 WL VSS a_n43365_n28971# PSL_25 nmos$2
Xpmos_104 a_n49530_n10590# VDD a_n49383_n10510# VDD pmos
Xpmos_115 a_n50888_n7894# VDD VDD a_n51035_n7974# pmos
Xpmos_148 a_n52396_n1354# VDD VDD a_n52543_n1434# pmos
Xpmos_137 a_n52543_n5358# VDD a_n52396_n5278# VDD pmos
Xpmos_126 a_n49383_n3970# VDD VDD a_n49530_n4050# pmos
Xpmos_159 a_n46516_n2742# VDD a_n46369_n2662# VDD pmos
Xpmos_2190 a_n28485_19892# VDD m1_n28364_19717# VDD pmos
Xpmos_660 a_n57062_n13206# VDD a_n56915_n13126# VDD pmos
Xpmos_671 a_n57062_n10590# VDD a_n56915_n10510# VDD pmos
Xnmos$2_4614 a_n43365_23498# VSS SL_25 a_n43051_23487# nmos$2
Xnmos$2_4603 a_n44870_22190# VSS SL_24 a_n44556_22179# nmos$2
Xpmos_682 a_n58558_n7974# VDD a_n58411_n7894# VDD pmos
Xpmos_693 a_n56915_n7894# VDD VDD a_n57062_n7974# pmos
Xnmos$2_4647 WL_3 VSS SL_26N a_n42003_23717# nmos$2
Xnmos$2_4625 WL_5 VSS SL_27N a_n40498_21101# nmos$2
Xnmos$2_4636 a_n41856_22190# VSS SL_26 a_n41542_22179# nmos$2
Xnmos$2_4658 a_n47560_18255# VSS ML_7 m1_n47463_18463# nmos$2
Xnmos$2_3902 a_n34010_11715# VSS ML_12 m1_n33913_11923# nmos$2
Xnmos$2_3913 WL_14 VSS SL_29N a_n37485_9329# nmos$2
Xnmos$5_105 VEVAL VSS m1_n42954_n2465# VSS nmos$5
Xnmos$5_116 VEVAL VSS m1_n33913_n10313# VSS nmos$5
Xnmos$2_4669 a_n49530_17177# VSS a_n49069_16947# SL_21N nmos$2
Xnmos$2_3935 WL_10 VSS SL_29N a_n37485_14561# nmos$2
Xnmos$2_3946 a_n38990_14561# VSS a_n38529_14331# SL_28N nmos$2
Xnmos$2_3924 a_n38843_11726# VSS SL_28 a_n38529_11715# nmos$2
Xnmos$5_149 VEVAL VSS m1_n35418_n1157# VSS nmos$5
Xnmos$5_127 VEVAL VSS m1_n38432_n7697# VSS nmos$5
Xnmos$5_138 VEVAL VSS m1_n35418_n3773# VSS nmos$5
Xnmos$2_3957 a_n38843_15650# VSS SL_28 a_n38529_15639# nmos$2
Xnmos$2_3968 a_n34471_14561# VSS a_n34010_14331# SL_31N nmos$2
Xnmos$2_3979 a_n34324_13034# VSS SL_31 a_n34010_13023# nmos$2
Xnmos$2_812 a_n58097_n28982# VSS a_n32313_n28669# m1_n58000_n28774# nmos$2
Xnmos$2_801 a_n38990_n6666# VSS a_n38529_n6597# SL_28N nmos$2
Xnmos$2_834 a_n66090_n29051# VSS a_n65629_n28982# PSL_10N nmos$2
Xnmos$2_845 WL VSS PSL_12N a_n63077_n29051# nmos$2
Xnmos$2_823 a_n53587_n28982# VSS a_n32313_n28669# m1_n53490_n28774# nmos$2
Xnmos$2_878 a_n76483_n28971# VSS PSL_3 a_n76169_n28982# nmos$2
Xnmos$2_889 a_n81002_n28971# VSS PSL_0 a_n80688_n28982# nmos$2
Xnmos$2_867 a_n68957_n28971# VSS PSL_8 a_n68643_n28982# nmos$2
Xnmos$2_856 a_n68643_n28982# VSS a_n32313_n28669# m1_n68546_n28774# nmos$2
Xnmos$5_661 VEVAL VSS m1_n70045_26311# VSS nmos$5
Xnmos$5_650 VEVAL VSS m1_n76072_26311# VSS nmos$5
Xnmos$5_672 VEVAL VSS m1_n56504_18463# VSS nmos$5
Xnmos$5_683 VEVAL VSS m1_n59505_22387# VSS nmos$5
Xnmos$5_694 VEVAL VSS m1_n61014_18463# VSS nmos$5
Xnmos_607 a_n81002_5186# VSS a_n81149_5405# VSS nmos
Xnmos_629 a_n79497_14342# VSS a_n79644_14561# VSS nmos
Xnmos_618 a_n76483_10418# VSS a_n76630_10637# VSS nmos
Xnmos$2_3209 a_n76483_20882# VSS SL_3 a_n76169_20871# nmos$2
Xnmos$3_609 a_n72108_21101# VSS VSS a_n71961_20882# nmos$3
Xnmos$2_2519 a_n67452_6494# VSS SL_9 a_n67138_6483# nmos$2
Xnmos$2_2508 WL_16 VSS SL_5N a_n73617_6713# nmos$2
Xnmos$2_108 WL_31 VSS SL_23N a_n46516_n13206# nmos$2
Xnmos$2_1818 WL_21 VSS a_n59916_n46# SL_14 nmos$2
Xnmos$2_1829 WL_22 VSS a_n53901_n1354# SL_18 nmos$2
Xnmos$2_1807 WL_22 VSS a_n58411_n1354# SL_15 nmos$2
Xnmos$2_119 WL_30 VSS a_n44870_n11818# SL_24 nmos$2
Xnmos$3_82 a_n49530_n1434# VSS VSS a_n49383_n1354# nmos$3
Xnmos$3_60 a_n49530_n7974# VSS VSS a_n49383_n7894# nmos$3
Xnmos$3_71 a_n48021_n4050# VSS VSS a_n47874_n3970# nmos$3
Xnmos$3_93 a_n42003_n5358# VSS VSS a_n41856_n5278# nmos$3
Xnmos$2_5101 a_n37024_27411# VSS ML_0 m1_n36927_27619# nmos$2
Xnmos$2_5112 a_n38843_26114# VSS SL_28 a_n38529_26103# nmos$2
Xnmos$2_5123 a_n38843_1262# VSS SL_28 a_n38529_1251# nmos$2
Xnmos$2_5134 a_n44556_1251# VSS ML_20 m1_n44459_1459# nmos$2
Xnmos$2_4400 WL_12 VSS SL_26N a_n42003_11945# nmos$2
Xnmos$2_4422 a_n44870_10418# VSS SL_24 a_n44556_10407# nmos$2
Xnmos$2_4411 WL_14 VSS m2_n44135_352# a_n45017_9329# nmos$2
Xnmos$2_5167 a_n50888_1262# VSS SL_20 a_n50574_1251# nmos$2
Xnmos$2_5156 WL_20 VSS a_n74975_1262# SL_4 nmos$2
Xnmos$2_5145 WL_20 VSS SL_0N a_n81149_1481# nmos$2
Xpmos_490 a_n69104_n7974# VDD a_n68957_n7894# VDD pmos
Xnmos$2_3721 a_n55410_27422# VSS SL_17 a_n55096_27411# nmos$2
Xnmos$2_3710 a_n66090_26333# VSS a_n65629_26103# SL_10N nmos$2
Xnmos$2_4466 WL_9 VSS m2_n44135_352# a_n45017_15869# nmos$2
Xnmos$2_4444 WL_11 VSS a_n43365_13034# SL_25 nmos$2
Xnmos$2_4455 WL_11 VSS a_n44870_13034# SL_24 nmos$2
Xnmos$2_4433 a_n43365_11726# VSS SL_25 a_n43051_11715# nmos$2
Xnmos$2_5189 a_n43365_1262# VSS SL_25 a_n43051_1251# nmos$2
Xnmos$2_5178 a_n54048_1481# VSS a_n53587_1251# SL_18N nmos$2
Xnmos$2_3743 a_n55557_26333# VSS a_n55096_26103# SL_17N nmos$2
Xnmos$2_3732 WL_1 VSS SL_16N a_n57062_26333# nmos$2
Xnmos$2_3754 WL_2 VSS SL_14N a_n60063_25025# nmos$2
Xnmos$2_4499 a_n40498_15869# VSS a_n40037_15639# SL_27N nmos$2
Xnmos$2_4477 WL_11 VSS SL_27N a_n40498_13253# nmos$2
Xnmos$2_4488 WL_11 VSS SL_25N a_n43512_13253# nmos$2
Xnmos$2_3765 a_n58411_27422# VSS SL_15 a_n58097_27411# nmos$2
Xnmos$2_3776 WL_1 VSS SL_14N a_n60063_26333# nmos$2
Xnmos$2_3787 WL_19 VSS SL_30N a_n35976_2789# nmos$2
Xnmos$2_620 WL_30 VSS a_n38843_n11818# SL_28 nmos$2
Xnmos$2_3798 a_n37024_2559# VSS ML_19 m1_n36927_2767# nmos$2
Xnmos$2_631 WL_30 VSS a_n37338_n11818# SL_29 nmos$2
Xnmos$2_642 WL_28 VSS a_n37338_n9202# SL_29 nmos$2
Xnmos$2_664 WL_28 VSS a_n34324_n9202# SL_31 nmos$2
Xnmos$2_653 a_n37338_n7894# VSS SL_29 a_n37024_n7905# nmos$2
Xnmos$2_675 WL_29 VSS a_n35829_n10510# SL_30 nmos$2
Xnmos$2_686 a_n34010_n5289# VSS ML_25 m1_n33913_n5081# nmos$2
Xnmos$2_697 WL_24 VSS SL_31N a_n34471_n4050# nmos$2
Xnmos$5_480 VEVAL VSS m1_n68546_2767# VSS nmos$5
Xnmos$5_491 VEVAL VSS m1_n71550_4075# VSS nmos$5
Xpmos$1_12 OUTP VDD a_n27274_n7528# m1_n28364_n7605# pmos$1
Xpmos$1_45 OUTP VDD m1_n26796_2550# a_n26151_2538# pmos$1
Xpmos$1_34 OUTP VDD a_n27274_n1776# m1_n28364_n1853# pmos$1
Xpmos$1_23 OUTP VDD a_n27274_n3214# m1_n28364_n3291# pmos$1
Xpmos$1_89 a_n28089_17862# VDD a_n26151_18356# a_n27618_18356# pmos$1
Xpmos$1_78 OUTP VDD m1_n26796_12616# a_n26151_12604# pmos$1
Xpmos$1_67 a_n28089_10672# VDD a_n26151_11166# a_n27618_11166# pmos$1
Xpmos$1_56 OUTP VDD m1_n26796_6864# a_n26151_6852# pmos$1
Xpmos$2_0 a_n31183_n28668# VDD OUTP VDD pmos$2
Xnmos_404 a_n62930_n10510# VSS a_n63077_n10590# VSS nmos
Xnmos_415 a_n67452_n6586# VSS a_n67599_n6666# VSS nmos
Xnmos_448 a_n62930_n2662# VSS a_n63077_n2742# VSS nmos
Xnmos_426 a_n61425_n7894# VSS a_n61572_n7974# VSS nmos
Xnmos_437 a_n65943_n3970# VSS a_n66090_n4050# VSS nmos
Xnmos$2_3017 a_n72108_21101# VSS a_n71647_20871# SL_6N nmos$2
Xnmos$2_3006 WL_6 VSS a_n73470_19574# SL_5 nmos$2
Xnmos_459 a_n59916_n3970# VSS a_n60063_n4050# VSS nmos
Xnmos$2_3039 WL_3 VSS a_n73470_23498# SL_5 nmos$2
Xnmos$2_3028 WL_4 VSS SL_4N a_n75122_22409# nmos$2
Xnmos$2_2305 WL_13 VSS a_n55410_10418# SL_17 nmos$2
Xnmos$3_406 a_n55557_6713# VSS VSS a_n55410_6494# nmos$3
Xnmos$2_2316 WL_12 VSS SL_17N a_n55557_11945# nmos$2
Xnmos$3_439 a_n66090_11945# VSS VSS a_n65943_11726# nmos$3
Xnmos$2_2327 a_n58411_10418# VSS SL_15 a_n58097_10407# nmos$2
Xnmos$2_2338 a_n59602_10407# VSS ML_13 m1_n59505_10615# nmos$2
Xnmos$3_428 a_n61572_8021# VSS VSS a_n61425_7802# nmos$3
Xnmos$3_417 a_n64585_5405# VSS VSS a_n64438_5186# nmos$3
Xnmos$2_2349 a_n58411_11726# VSS SL_15 a_n58097_11715# nmos$2
Xnmos$2_1604 WL_28 VSS SL_9N a_n67599_n9282# nmos$2
Xnmos$2_1626 WL_28 VSS SL_11N a_n64585_n9282# nmos$2
Xnmos$2_1615 WL_27 VSS SL_10N a_n66090_n7974# nmos$2
Xnmos$2_1637 WL_27 VSS a_n61425_n7894# SL_13 nmos$2
Xnmos$2_1648 a_n61425_n5278# VSS SL_13 a_n61111_n5289# nmos$2
Xnmos$2_1659 a_n64585_n4050# VSS a_n64124_n3981# SL_11N nmos$2
Xnmos$2_4241 a_n47560_9099# VSS ML_14 m1_n47463_9307# nmos$2
Xnmos$2_4230 a_n47874_9110# VSS SL_22 a_n47560_9099# nmos$2
Xnmos_971 a_n46369_5186# VSS a_n46516_5405# VSS nmos
Xnmos_960 a_n41856_2570# VSS a_n42003_2789# VSS nmos
Xnmos$2_4252 a_n49069_11715# VSS ML_12 m1_n48972_11923# nmos$2
Xnmos$2_4263 a_n50574_9099# VSS ML_14 m1_n50477_9307# nmos$2
Xnmos$2_4274 WL_14 VSS SL_18N a_n54048_9329# nmos$2
Xnmos_993 a_n52396_7802# VSS a_n52543_8021# VSS nmos
Xnmos_982 a_n49383_3878# VSS a_n49530_4097# VSS nmos
Xnmos$2_3562 WL_6 VSS SL_9N a_n67599_19793# nmos$2
Xnmos$2_3540 WL_7 VSS SL_10N a_n66090_18485# nmos$2
Xnmos$2_3551 WL_8 VSS SL_9N a_n67599_17177# nmos$2
Xnmos$2_4296 a_n52543_11945# VSS a_n52082_11715# SL_19N nmos$2
Xnmos$2_4285 a_n54048_11945# VSS a_n53587_11715# SL_18N nmos$2
Xnmos$3_962 a_n46516_25025# VSS VSS a_n46369_24806# nmos$3
Xnmos$3_951 a_n51035_23717# VSS VSS a_n50888_23498# nmos$3
Xnmos$2_3595 a_n67599_23717# VSS a_n67138_23487# SL_9N nmos$2
Xnmos$2_3573 a_n66090_22409# VSS a_n65629_22179# SL_10N nmos$2
Xnmos$2_3584 WL_5 VSS SL_9N a_n67599_21101# nmos$2
Xnmos$3_940 a_n51035_17177# VSS VSS a_n50888_16958# nmos$3
Xnmos$2_2861 a_n73156_11715# VSS ML_12 m1_n73059_11923# nmos$2
Xnmos$2_2850 a_n73156_9099# VSS ML_14 m1_n73059_9307# nmos$2
Xnmos$3_973 a_n52543_26333# VSS VSS a_n52396_26114# nmos$3
Xnmos$3_984 a_n45017_25025# VSS VSS a_n44870_24806# nmos$3
Xnmos$3_995 a_n38990_18485# VSS VSS a_n38843_18266# nmos$3
Xnmos$2_2894 WL_9 VSS a_n73470_15650# SL_5 nmos$2
Xnmos$2_2883 WL_10 VSS a_n73470_14342# SL_5 nmos$2
Xnmos$2_2872 a_n71647_13023# VSS ML_11 m1_n71550_13231# nmos$2
Xnmos$2_472 a_n46516_173# VSS a_n46055_n57# SL_23N nmos$2
Xnmos$2_461 a_n43051_n1365# VSS ML_22 m1_n42954_n1157# nmos$2
Xnmos$2_450 WL_24 VSS SL_23N a_n46516_n4050# nmos$2
Xnmos$2_494 a_n41856_n46# VSS SL_26 a_n41542_n57# nmos$2
Xnmos$2_483 WL_22 VSS a_n40351_n1354# SL_27 nmos$2
Xnmos_223 ML_24 VSS VSS a_n28485_n3116# nmos
Xnmos_201 a_n26151_n4652# VSS a_n26495_n4652# VSS nmos
Xnmos_212 a_n28485_n3116# VSS VSS m1_n28364_n3291# nmos
Xnmos_234 a_n27274_1100# VSS a_n27618_1100# VSS nmos
Xnmos_245 a_n40351_n13126# VSS a_n40498_n13206# VSS nmos
Xnmos_267 a_n70456_n28971# VSS a_n70603_n29051# VSS nmos
Xnmos_256 a_n40351_n5278# VSS a_n40498_n5358# VSS nmos
Xnmos_289 a_n73470_n11818# VSS a_n73617_n11898# VSS nmos
Xnmos_278 a_n70456_n10510# VSS a_n70603_n10590# VSS nmos
Xnmos$2_2102 WL_15 VSS a_n65943_7802# SL_10 nmos$2
Xnmos$2_2113 a_n65629_6483# VSS ML_16 m1_n65532_6691# nmos$2
Xnmos$3_214 a_n81149_n11898# VSS VSS a_n81002_n11818# nmos$3
Xnmos$3_203 a_n69104_n9282# VSS VSS a_n68957_n9202# nmos$3
Xnmos$2_2157 a_n61425_9110# VSS SL_13 a_n61111_9099# nmos$2
Xnmos$2_2146 WL_15 VSS SL_13N a_n61572_8021# nmos$2
Xnmos$2_2124 a_n63077_6713# VSS a_n62616_6483# SL_12N nmos$2
Xnmos$2_2135 a_n62616_5175# VSS ML_17 m1_n62519_5383# nmos$2
Xnmos$3_247 a_n79644_n1434# VSS VSS a_n79497_n1354# nmos$3
Xnmos$3_258 a_n75122_n2742# VSS VSS a_n74975_n2662# nmos$3
Xnmos$3_225 a_n79644_n6666# VSS VSS a_n79497_n6586# nmos$3
Xnmos$2_1412 a_n70456_n6586# VSS SL_7 a_n70142_n6597# nmos$2
Xnmos$2_1401 a_n68957_n6586# VSS SL_8 a_n68643_n6597# nmos$2
Xnmos$3_236 a_n76630_n5358# VSS VSS a_n76483_n5278# nmos$3
Xnmos$2_2179 WL_12 VSS a_n61425_11726# SL_13 nmos$2
Xnmos$2_2168 a_n64585_9329# VSS a_n64124_9099# SL_11N nmos$2
Xnmos$2_1445 a_n55096_n13137# VSS ML_31 m1_n54999_n12929# nmos$2
Xnmos$2_1423 a_n57062_n13206# VSS a_n56601_n13137# SL_16N nmos$2
Xnmos$2_1434 WL_30 VSS SL_17N a_n55557_n11898# nmos$2
Xnmos$3_269 a_n72108_n4050# VSS VSS a_n71961_n3970# nmos$3
Xnmos$2_1456 a_n59602_n13137# VSS ML_31 m1_n59505_n12929# nmos$2
Xnmos$2_1467 a_n59916_n11818# VSS SL_14 a_n59602_n11829# nmos$2
Xnmos$2_1478 a_n58097_n11829# VSS ML_30 m1_n58000_n11621# nmos$2
Xnmos$2_1489 a_n60063_n9282# VSS a_n59602_n9213# SL_14N nmos$2
Xpmos_2019 a_n42003_14561# VDD a_n41856_14342# VDD pmos
Xpmos_2008 a_n45017_14561# VDD a_n44870_14342# VDD pmos
Xpmos_1307 a_n69104_18485# VDD a_n68957_18266# VDD pmos
Xpmos_1329 a_n73617_23717# VDD a_n73470_23498# VDD pmos
Xpmos_1318 a_n71961_18266# VDD VDD a_n72108_18485# pmos
Xnmos_1227 a_n26495_26984# VSS VSS COMP3 nmos
Xnmos_1216 a_n35829_27422# VSS a_n35976_27641# VSS nmos
Xnmos_1205 a_n37338_23498# VSS a_n37485_23717# VSS nmos
Xnmos_1249 a_n27274_29860# VSS a_n27618_29860# VSS nmos
Xnmos_1238 ML_2 VSS VSS a_n28485_28520# nmos
Xnmos_790 a_n65943_19574# VSS a_n66090_19793# VSS nmos
Xnmos$2_4071 a_n45017_8021# VSS a_n44556_7791# m2_n44135_352# nmos$2
Xnmos$2_4082 WL_17 VSS SL_26N a_n42003_5405# nmos$2
Xnmos$2_4060 a_n46055_5175# VSS ML_17 m1_n45958_5383# nmos$2
Xnmos$2_3370 a_n55557_17177# VSS a_n55096_16947# SL_17N nmos$2
Xnmos$2_3381 a_n57062_17177# VSS a_n56601_16947# SL_16N nmos$2
Xnmos$2_4093 a_n43512_5405# VSS a_n43051_5175# SL_25N nmos$2
Xnmos$2_3392 a_n55557_19793# VSS a_n55096_19563# SL_17N nmos$2
Xnmos$3_770 a_n37485_4097# VSS VSS a_n37338_3878# nmos$3
Xnmos$5_17 VEVAL VSS m1_n39940_n11621# VSS nmos$5
Xnmos$5_28 VEVAL VSS m1_n45958_n6389# VSS nmos$5
Xnmos$2_2691 WL_12 VSS SL_3N a_n76630_11945# nmos$2
Xnmos$3_792 a_n38990_10637# VSS VSS a_n38843_10418# nmos$3
Xnmos$2_2680 a_n76169_10407# VSS ML_13 m1_n76072_10615# nmos$2
Xnmos$3_781 a_n34471_5405# VSS VSS a_n34324_5186# nmos$3
Xnmos$5_39 VEVAL VSS m1_n42954_n11621# VSS nmos$5
Xnmos$2_280 a_n47874_n9202# VSS SL_22 a_n47560_n9213# nmos$2
Xnmos$2_1990 a_n59602_7791# VSS ML_15 m1_n59505_7999# nmos$2
Xnmos$2_291 WL_27 VSS a_n47874_n7894# SL_22 nmos$2
Xpmos_1830 a_n43512_6713# VDD a_n43365_6494# VDD pmos
Xpmos_1852 a_n40498_8021# VDD a_n40351_7802# VDD pmos
Xpmos_1841 a_n40498_6713# VDD a_n40351_6494# VDD pmos
Xpmos_1863 a_n47874_3878# VDD VDD a_n48021_4097# pmos
Xpmos_1885 a_n52543_6713# VDD a_n52396_6494# VDD pmos
Xpmos_1896 a_n49530_5405# VDD a_n49383_5186# VDD pmos
Xpmos_1874 a_n53901_2570# VDD VDD a_n54048_2789# pmos
Xnmos$5_0 VEVAL VSS m1_n36927_n28774# VSS nmos$5
Xnmos$2_1220 WL_21 VSS a_n74975_n46# SL_4 nmos$2
Xnmos$2_1231 WL_23 VSS SL_2N a_n78135_n2742# nmos$2
Xnmos$2_1242 WL_23 VSS a_n79497_n2662# SL_1 nmos$2
Xnmos$2_1253 WL_25 VSS a_n70456_n5278# SL_7 nmos$2
Xnmos$2_1275 a_n71961_n5278# VSS SL_6 a_n71647_n5289# nmos$2
Xnmos$2_1286 WL_24 VSS SL_4N a_n75122_n4050# nmos$2
Xnmos$2_1264 a_n69104_n4050# VSS a_n68643_n3981# SL_8N nmos$2
Xnmos$2_1297 a_n71961_n1354# VSS SL_6 a_n71647_n1365# nmos$2
Xpmos_1104 a_n73617_8021# VDD a_n73470_7802# VDD pmos
Xpmos_1115 a_n70603_5405# VDD a_n70456_5186# VDD pmos
Xpmos_1159 a_n81002_5186# VDD VDD a_n81149_5405# pmos
Xpmos_1137 a_n76483_3878# VDD VDD a_n76630_4097# pmos
Xpmos_1148 a_n78135_4097# VDD a_n77988_3878# VDD pmos
Xpmos_1126 a_n75122_1481# VDD a_n74975_1262# VDD pmos
Xpmos_319 a_n38990_n5358# VDD a_n38843_n5278# VDD pmos
Xpmos_308 a_n35829_n5278# VDD VDD a_n35976_n5358# pmos
Xnmos_1002 a_n50888_2570# VSS a_n51035_2789# VSS nmos
Xnmos_1024 a_n47874_14342# VSS a_n48021_14561# VSS nmos
Xnmos_1035 a_n41856_10418# VSS a_n42003_10637# VSS nmos
Xnmos_1013 a_n53901_9110# VSS a_n54048_9329# VSS nmos
Xnmos_1068 a_n46369_16958# VSS a_n46516_17177# VSS nmos
Xnmos_1057 a_n43365_15650# VSS a_n43512_15869# VSS nmos
Xnmos_1046 a_n44870_11726# VSS a_n45017_11945# VSS nmos
Xnmos_1079 a_n43365_22190# VSS a_n43512_22409# VSS nmos
Xnmos$3_1006 a_n38990_23717# VSS VSS a_n38843_23498# nmos$3
Xnmos$3_1017 a_n37485_25025# VSS VSS a_n37338_24806# nmos$3
Xnmos$3_1028 a_n45017_1481# VSS VSS a_n44870_1262# nmos$3
Xnmos$3_1039 a_n57062_1481# VSS VSS a_n56915_1262# nmos$3
Xpmos_2361 a_n40351_22190# VDD VDD a_n40498_22409# pmos
Xpmos_2350 a_n40351_9110# VDD VDD a_n40498_9329# pmos
Xpmos_1660 OUTP VDD VDD a_n28089_7796# pmos
Xpmos_1671 a_n34471_2789# VDD a_n34324_2570# VDD pmos
Xpmos_820 a_n60063_173# VDD a_n59916_n46# VDD pmos
Xpmos_1693 a_n35976_5405# VDD a_n35829_5186# VDD pmos
Xpmos_1682 a_n38990_1481# VDD a_n38843_1262# VDD pmos
Xpmos_853 a_n55410_1262# VDD VDD a_n55557_1481# pmos
Xpmos_831 a_n55557_n1434# VDD a_n55410_n1354# VDD pmos
Xpmos_842 a_n61425_n13126# VDD VDD a_n61572_n13206# pmos
Xnmos$2_4807 WL_0 VSS a_n49383_27422# SL_21 nmos$2
Xpmos_886 a_n59916_7802# VDD VDD a_n60063_8021# pmos
Xpmos_897 a_n55557_6713# VDD a_n55410_6494# VDD pmos
Xpmos_875 a_n58558_4097# VDD a_n58411_3878# VDD pmos
Xpmos_864 a_n57062_1481# VDD a_n56915_1262# VDD pmos
Xnmos$2_4818 WL_1 VSS SL_21N a_n49530_26333# nmos$2
Xnmos$2_4829 WL_2 VSS a_n50888_24806# SL_20 nmos$2
Xnmos$5_309 VEVAL VSS m1_n65532_n9005# VSS nmos$5
Xnmos$5_821 VEVAL VSS m1_n39940_7999# VSS nmos$5
Xnmos$5_810 VEVAL VSS m1_n44459_5383# VSS nmos$5
Xnmos$5_854 VEVAL VSS m1_n48972_10615# VSS nmos$5
Xnmos$5_843 VEVAL VSS m1_n51985_6691# VSS nmos$5
Xnmos$5_832 VEVAL VSS m1_n48972_4075# VSS nmos$5
Xnmos$5_865 VEVAL VSS m1_n50477_14539# VSS nmos$5
Xnmos$5_887 VEVAL VSS m1_n44459_11923# VSS nmos$5
Xnmos$5_876 VEVAL VSS m1_n39940_10615# VSS nmos$5
Xnmos$5_898 VEVAL VSS m1_n41445_15847# VSS nmos$5
Xnmos$2_1061 WL_30 VSS SL_0N a_n81149_n11898# nmos$2
Xnmos$2_1050 a_n77988_n13126# VSS SL_2 a_n77674_n13137# nmos$2
Xnmos$2_1072 a_n79497_n11818# VSS SL_1 a_n79183_n11829# nmos$2
Xnmos$2_1083 WL_29 VSS a_n79497_n10510# SL_1 nmos$2
Xnmos$2_1094 WL_28 VSS SL_0N a_n81149_n9282# nmos$2
Xnmos$2_18 WL VSS a_n38843_n28971# PSL_28 nmos$2
Xnmos$2_29 a_n42003_n29051# VSS a_n41542_n28982# PSL_26N nmos$2
Xpmos_116 a_n50888_n13126# VDD VDD a_n51035_n13206# pmos
Xpmos_105 a_n49383_n9202# VDD VDD a_n49530_n9282# pmos
Xpmos_149 a_n52543_n2742# VDD a_n52396_n2662# VDD pmos
Xpmos_138 a_n52543_n6666# VDD a_n52396_n6586# VDD pmos
Xpmos_127 a_n49530_n4050# VDD a_n49383_n3970# VDD pmos
Xpmos_2180 a_n44870_26114# VDD VDD a_n45017_26333# pmos
Xpmos_2191 a_n27274_19794# VDD VDD a_n27618_19794# pmos
Xpmos_1490 a_n58558_17177# VDD a_n58411_16958# VDD pmos
Xpmos_650 a_n69104_n2742# VDD a_n68957_n2662# VDD pmos
Xpmos_661 a_n58411_n13126# VDD VDD a_n58558_n13206# pmos
Xnmos$2_4615 WL_3 VSS a_n43365_23498# SL_25 nmos$2
Xnmos$2_4604 WL_4 VSS a_n44870_22190# SL_24 nmos$2
Xpmos_683 a_n58558_n10590# VDD a_n58411_n10510# VDD pmos
Xpmos_672 a_n57062_n9282# VDD a_n56915_n9202# VDD pmos
Xpmos_694 a_n55557_n7974# VDD a_n55410_n7894# VDD pmos
Xnmos$2_4648 WL_3 VSS a_n40351_23498# SL_27 nmos$2
Xnmos$2_4637 WL_4 VSS a_n41856_22190# SL_26 nmos$2
Xnmos$2_4626 a_n40037_20871# VSS ML_5 m1_n39940_21079# nmos$2
Xnmos$2_3903 a_n34471_11945# VSS a_n34010_11715# SL_31N nmos$2
Xnmos$5_106 VEVAL VSS m1_n42954_n3773# VSS nmos$5
Xnmos$2_4659 WL_7 VSS a_n46369_18266# SL_23 nmos$2
Xnmos$2_3936 a_n37024_14331# VSS ML_10 m1_n36927_14539# nmos$2
Xnmos$2_3925 a_n38990_11945# VSS a_n38529_11715# SL_28N nmos$2
Xnmos$2_3914 a_n38529_9099# VSS ML_14 m1_n38432_9307# nmos$2
Xnmos$5_117 VEVAL VSS m1_n33913_n11621# VSS nmos$5
Xnmos$5_128 VEVAL VSS m1_n36927_n6389# VSS nmos$5
Xnmos$5_139 VEVAL VSS m1_n33913_n3773# VSS nmos$5
Xnmos$2_3958 WL_9 VSS SL_28N a_n38990_15869# nmos$2
Xnmos$2_3969 WL_10 VSS SL_31N a_n34471_14561# nmos$2
Xnmos$2_3947 WL_10 VSS SL_28N a_n38990_14561# nmos$2
Xnmos$2_813 a_n55557_n29051# VSS a_n55096_n28982# PSL_17N nmos$2
Xnmos$2_802 a_n38529_n6597# VSS ML_26 m1_n38432_n6389# nmos$2
Xnmos$2_835 WL VSS PSL_11N a_n64585_n29051# nmos$2
Xnmos$2_846 a_n62930_n28971# VSS PSL_12 a_n62616_n28982# nmos$2
Xnmos$2_824 a_n56915_n28971# VSS PSL_16 a_n56601_n28982# nmos$2
Xnmos$2_879 WL VSS PSL_3N a_n76630_n29051# nmos$2
Xnmos$2_857 a_n72108_n29051# VSS a_n71647_n28982# PSL_6N nmos$2
Xnmos$2_868 a_n70142_n28982# VSS a_n32313_n28669# m1_n70045_n28774# nmos$2
Xnmos$5_662 VEVAL VSS m1_n68546_26311# VSS nmos$5
Xnmos$5_640 VEVAL VSS m1_n76072_23695# VSS nmos$5
Xnmos$5_651 VEVAL VSS m1_n79086_25003# VSS nmos$5
Xnmos$5_684 VEVAL VSS m1_n59505_21079# VSS nmos$5
Xnmos$5_673 VEVAL VSS m1_n56504_19771# VSS nmos$5
Xnmos$5_695 VEVAL VSS m1_n62519_17155# VSS nmos$5
Xnmos_619 a_n77988_10418# VSS a_n78135_10637# VSS nmos
Xnmos_608 a_n81002_6494# VSS a_n81149_6713# VSS nmos
Xnmos$2_2509 WL_17 VSS SL_5N a_n73617_5405# nmos$2
Xnmos$2_1819 WL_21 VSS a_n56915_n46# SL_16 nmos$2
Xnmos$2_1808 a_n58097_n1365# VSS ML_22 m1_n58000_n1157# nmos$2
Xnmos$2_109 a_n46055_n13137# VSS ML_31 m1_n45958_n12929# nmos$2
Xnmos$3_50 a_n51035_n10590# VSS VSS a_n50888_n10510# nmos$3
Xnmos$3_83 a_n49530_173# VSS VSS a_n49383_n46# nmos$3
Xnmos$3_61 a_n49530_n6666# VSS VSS a_n49383_n6586# nmos$3
Xnmos$3_72 a_n48021_n5358# VSS VSS a_n47874_n5278# nmos$3
Xnmos$3_94 a_n42003_n4050# VSS VSS a_n41856_n3970# nmos$3
Xnmos$2_5102 a_n37485_27641# VSS a_n37024_27411# SL_29N nmos$2
Xnmos$2_5113 WL_1 VSS SL_28N a_n38990_26333# nmos$2
Xnmos$2_5124 a_n38990_1481# VSS a_n38529_1251# SL_28N nmos$2
Xnmos$2_5135 a_n46369_1262# VSS SL_23 a_n46055_1251# nmos$2
Xpmos_480 a_n67599_n10590# VDD a_n67452_n10510# VDD pmos
Xnmos$2_4423 WL_13 VSS SL_23N a_n46516_10637# nmos$2
Xnmos$2_4401 a_n42003_9329# VSS a_n41542_9099# SL_26N nmos$2
Xnmos$2_4412 a_n43051_9099# VSS ML_14 m1_n42954_9307# nmos$2
Xnmos$2_5168 WL_20 VSS a_n43365_1262# SL_25 nmos$2
Xnmos$2_5157 WL_20 VSS SL_2N a_n78135_1481# nmos$2
Xnmos$2_5146 a_n81002_1262# VSS SL_0 a_n80688_1251# nmos$2
Xpmos_491 a_n69104_n10590# VDD a_n68957_n10510# VDD pmos
Xnmos$2_3700 a_n67599_26333# VSS a_n67138_26103# SL_9N nmos$2
Xnmos$2_3711 WL_2 VSS a_n53901_24806# SL_18 nmos$2
Xnmos$2_4445 WL_10 VSS a_n43365_14342# SL_25 nmos$2
Xnmos$2_4456 a_n46055_13023# VSS ML_11 m1_n45958_13231# nmos$2
Xnmos$2_4434 a_n44556_11715# VSS ML_12 m1_n44459_11923# nmos$2
Xnmos$2_5179 WL_20 VSS SL_18N a_n54048_1481# nmos$2
Xnmos$2_3722 WL_0 VSS a_n55410_27422# SL_17 nmos$2
Xnmos$2_3755 a_n59916_27422# VSS SL_14 a_n59602_27411# nmos$2
Xnmos$2_3733 WL_1 VSS a_n55410_26114# SL_17 nmos$2
Xnmos$2_3744 a_n58558_25025# VSS a_n58097_24795# SL_15N nmos$2
Xnmos$2_4489 WL_10 VSS a_n41856_14342# SL_26 nmos$2
Xnmos$2_4478 WL_11 VSS SL_26N a_n42003_13253# nmos$2
Xnmos$2_4467 a_n44556_13023# VSS ML_11 m1_n44459_13231# nmos$2
Xnmos$2_3766 a_n58558_26333# VSS a_n58097_26103# SL_15N nmos$2
Xnmos$2_3777 a_n56915_24806# VSS SL_16 a_n56601_24795# nmos$2
Xnmos$2_3788 a_n35976_4097# VSS a_n35515_3867# SL_30N nmos$2
Xnmos$2_610 WL_31 VSS a_n37338_n13126# SL_29 nmos$2
Xnmos$2_621 a_n38990_n11898# VSS a_n38529_n11829# SL_28N nmos$2
Xnmos$1_120 OUTP VSS m1_n27919_28434# a_n27274_28422# nmos$1
Xnmos$2_3799 a_n37485_2789# VSS a_n37024_2559# SL_29N nmos$2
Xnmos$2_632 a_n37338_n10510# VSS SL_29 a_n37024_n10521# nmos$2
Xnmos$2_643 a_n38529_n9213# VSS ML_28 m1_n38432_n9005# nmos$2
Xnmos$2_654 WL_27 VSS a_n37338_n7894# SL_29 nmos$2
Xnmos$2_676 WL_30 VSS a_n35829_n11818# SL_30 nmos$2
Xnmos$2_665 a_n35515_n9213# VSS ML_28 m1_n35418_n9005# nmos$2
Xnmos$2_687 WL_25 VSS SL_30N a_n35976_n5358# nmos$2
Xnmos$2_698 a_n34010_n3981# VSS ML_24 m1_n33913_n3773# nmos$2
Xnmos$2_4990 WL_6 VSS a_n37338_19574# SL_29 nmos$2
Xnmos$5_470 VEVAL VSS m1_n59505_14539# VSS nmos$5
Xnmos$5_492 VEVAL VSS m1_n71550_5383# VSS nmos$5
Xnmos$5_481 VEVAL VSS m1_n68546_1459# VSS nmos$5
Xpmos$1_13 OUTP VDD m1_n26796_n7516# a_n26151_n7528# pmos$1
Xpmos$1_46 a_n28089_2044# VDD m1_n27919_2550# a_n27274_2538# pmos$1
Xpmos$1_35 a_n27990_220# VDD m1_n27919_n326# a_n27274_n338# pmos$1
Xpmos$1_24 a_n28089_n3708# VDD m1_n27919_n3202# a_n27274_n3214# pmos$1
Xpmos$1_68 a_n28089_13548# VDD m1_n27919_14054# a_n27274_14042# pmos$1
Xpmos$1_79 a_n28089_12110# VDD a_n26151_12604# a_n27618_12604# pmos$1
Xpmos$1_57 a_n28089_6358# VDD a_n26151_6852# a_n27618_6852# pmos$1
Xnmos_405 a_n61425_n11818# VSS a_n61572_n11898# VSS nmos
Xnmos_416 a_n67452_n7894# VSS a_n67599_n7974# VSS nmos
Xnmos_438 a_n65943_n1354# VSS a_n66090_n1434# VSS nmos
Xnmos_449 a_n64438_n2662# VSS a_n64585_n2742# VSS nmos
Xnmos_427 a_n62930_n7894# VSS a_n63077_n7974# VSS nmos
Xnmos$2_3007 a_n71647_19563# VSS ML_6 m1_n71550_19771# nmos$2
Xnmos$2_3018 a_n71647_22179# VSS ML_4 m1_n71550_22387# nmos$2
Xnmos$2_3029 a_n73156_20871# VSS ML_5 m1_n73059_21079# nmos$2
Xnmos$2_2306 a_n55410_10418# VSS SL_17 a_n55096_10407# nmos$2
Xnmos$2_2317 a_n55557_11945# VSS a_n55096_11715# SL_17N nmos$2
Xnmos$2_2328 a_n58097_10407# VSS ML_13 m1_n58000_10615# nmos$2
Xnmos$2_2339 WL_13 VSS a_n59916_10418# SL_14 nmos$2
Xnmos$3_429 a_n61572_10637# VSS VSS a_n61425_10418# nmos$3
Xnmos$3_407 a_n55557_8021# VSS VSS a_n55410_7802# nmos$3
Xnmos$3_418 a_n64585_6713# VSS VSS a_n64438_6494# nmos$3
Xnmos$2_1605 a_n67599_n9282# VSS a_n67138_n9213# SL_9N nmos$2
Xnmos$2_1627 WL_28 VSS a_n62930_n9202# SL_12 nmos$2
Xnmos$2_1616 a_n66090_n7974# VSS a_n65629_n7905# SL_10N nmos$2
Xnmos$2_1638 a_n61425_n7894# VSS SL_13 a_n61111_n7905# nmos$2
Xnmos$2_1649 a_n62930_n5278# VSS SL_12 a_n62616_n5289# nmos$2
Xnmos_950 a_n27618_14042# VSS m1_n27919_14054# VSS nmos
Xnmos$2_4231 WL_13 VSS a_n46369_10418# SL_23 nmos$2
Xnmos$2_4220 WL_15 VSS a_n49383_7802# SL_21 nmos$2
Xnmos_961 a_n43365_2570# VSS a_n43512_2789# VSS nmos
Xnmos$2_3530 a_n62616_19563# VSS ML_6 m1_n62519_19771# nmos$2
Xnmos$2_4253 a_n49383_11726# VSS SL_21 a_n49069_11715# nmos$2
Xnmos$2_4242 WL_13 VSS SL_21N a_n49530_10637# nmos$2
Xnmos$2_4264 a_n50574_10407# VSS ML_13 m1_n50477_10615# nmos$2
Xnmos_972 a_n46369_7802# VSS a_n46516_8021# VSS nmos
Xnmos_994 a_n47874_6494# VSS a_n48021_6713# VSS nmos
Xnmos_983 a_n47874_3878# VSS a_n48021_4097# VSS nmos
Xnmos$2_3563 WL_6 VSS a_n65943_19574# SL_10 nmos$2
Xnmos$2_3541 a_n64124_16947# VSS ML_8 m1_n64027_17155# nmos$2
Xnmos$2_3552 a_n67138_16947# VSS ML_8 m1_n67041_17155# nmos$2
Xnmos$2_4286 WL_12 VSS a_n52396_11726# SL_19 nmos$2
Xnmos$2_4297 a_n52543_10637# VSS a_n52082_10407# SL_19N nmos$2
Xnmos$2_4275 a_n52082_9099# VSS ML_14 m1_n51985_9307# nmos$2
Xnmos$3_930 a_n40498_23717# VSS VSS a_n40351_23498# nmos$3
Xnmos$2_3596 WL_3 VSS a_n65943_23498# SL_10 nmos$2
Xnmos$3_952 a_n46516_22409# VSS VSS a_n46369_22190# nmos$3
Xnmos$2_3574 WL_4 VSS a_n64438_22190# SL_11 nmos$2
Xnmos$2_3585 a_n65943_20882# VSS SL_10 a_n65629_20871# nmos$2
Xnmos$3_941 a_n51035_18485# VSS VSS a_n50888_18266# nmos$3
Xnmos$2_2840 a_n71961_10418# VSS SL_6 a_n71647_10407# nmos$2
Xnmos$2_2851 WL_14 VSS SL_4N a_n75122_9329# nmos$2
Xnmos$3_974 a_n52543_27641# VSS VSS a_n52396_27422# nmos$3
Xnmos$3_985 a_n45017_26333# VSS VSS a_n44870_26114# nmos$3
Xnmos$3_963 a_n49530_26333# VSS VSS a_n49383_26114# nmos$3
Xnmos$3_996 a_n38990_17177# VSS VSS a_n38843_16958# nmos$3
Xnmos$2_2895 a_n73617_15869# VSS a_n73156_15639# SL_5N nmos$2
Xnmos$2_2873 WL_10 VSS SL_6N a_n72108_14561# nmos$2
Xnmos$2_2884 a_n73470_13034# VSS SL_5 a_n73156_13023# nmos$2
Xnmos$2_2862 a_n73470_11726# VSS SL_5 a_n73156_11715# nmos$2
Xnmos$2_462 a_n45017_n1434# VSS a_n44556_n1365# m2_n44135_352# nmos$2
Xnmos$2_440 WL_25 VSS m2_n44135_352# a_n45017_n5358# nmos$2
Xnmos$2_451 WL_24 VSS m2_n44135_352# a_n45017_n4050# nmos$2
Xnmos$2_495 WL_21 VSS a_n41856_n46# SL_26 nmos$2
Xnmos$2_473 WL_21 VSS a_n43365_n46# SL_25 nmos$2
Xnmos$2_484 WL_22 VSS SL_27N a_n40498_n1434# nmos$2
Xnmos_224 a_n26151_n1776# VSS a_n26495_n1776# VSS nmos
Xnmos_202 a_n26151_n6090# VSS a_n26495_n6090# VSS nmos
Xnmos_213 a_n27274_n3214# VSS a_n27618_n3214# VSS nmos
Xnmos_235 a_n27618_n338# VSS m1_n27919_n326# VSS nmos
Xnmos_257 a_n59916_n28971# VSS a_n60063_n29051# VSS nmos
Xnmos_246 a_n40351_n11818# VSS a_n40498_n11898# VSS nmos
Xnmos_268 a_n74975_n28971# VSS a_n75122_n29051# VSS nmos
Xnmos_279 a_n68957_n10510# VSS a_n69104_n10590# VSS nmos
Xnmos$2_2103 a_n65943_7802# VSS SL_10 a_n65629_7791# nmos$2
Xnmos$2_2114 a_n61111_5175# VSS ML_17 m1_n61014_5383# nmos$2
Xnmos$3_215 a_n79644_n10590# VSS VSS a_n79497_n10510# nmos$3
Xnmos$3_204 a_n69104_n6666# VSS VSS a_n68957_n6586# nmos$3
Xnmos$2_2136 a_n64585_8021# VSS a_n64124_7791# SL_11N nmos$2
Xnmos$2_2147 WL_16 VSS SL_12N a_n63077_6713# nmos$2
Xnmos$2_2125 a_n62616_6483# VSS ML_16 m1_n62519_6691# nmos$2
Xnmos$3_248 a_n81149_173# VSS VSS a_n81002_n46# nmos$3
Xnmos$3_226 a_n79644_n7974# VSS VSS a_n79497_n7894# nmos$3
Xnmos$2_1402 WL_26 VSS SL_4N a_n75122_n6666# nmos$2
Xnmos$3_237 a_n76630_n4050# VSS VSS a_n76483_n3970# nmos$3
Xnmos$2_2158 a_n61572_10637# VSS a_n61111_10407# SL_13N nmos$2
Xnmos$2_2169 a_n62930_9110# VSS SL_12 a_n62616_9099# nmos$2
Xnmos$3_259 a_n76630_n2742# VSS VSS a_n76483_n2662# nmos$3
Xnmos$2_1435 a_n55557_n11898# VSS a_n55096_n11829# SL_17N nmos$2
Xnmos$2_1424 a_n57062_n10590# VSS a_n56601_n10521# SL_16N nmos$2
Xnmos$2_1413 WL_26 VSS SL_7N a_n70603_n6666# nmos$2
Xnmos$2_1457 a_n60063_n13206# VSS a_n59602_n13137# SL_14N nmos$2
Xnmos$2_1468 a_n58411_n11818# VSS SL_15 a_n58097_n11829# nmos$2
Xnmos$2_1479 WL_29 VSS SL_15N a_n58558_n10590# nmos$2
Xnmos$2_1446 a_n55096_n10521# VSS ML_29 m1_n54999_n10313# nmos$2
Xpmos_2009 a_n40498_13253# VDD a_n40351_13034# VDD pmos
Xpmos_1308 a_n69104_17177# VDD a_n68957_16958# VDD pmos
Xpmos_1319 a_n72108_19793# VDD a_n71961_19574# VDD pmos
Xnmos_1217 a_n34324_27422# VSS a_n34471_27641# VSS nmos
Xnmos_1206 a_n34324_20882# VSS a_n34471_21101# VSS nmos
Xnmos_1228 a_n27274_26984# VSS a_n27618_26984# VSS nmos
Xnmos_1239 ML_0 VSS VSS a_n28485_31396# nmos
Xnmos_780 a_n64438_18266# VSS a_n64585_18485# VSS nmos
Xnmos_791 a_n65943_22190# VSS a_n66090_22409# VSS nmos
Xnmos$2_4072 a_n43051_7791# VSS ML_15 m1_n42954_7999# nmos$2
Xnmos$2_4050 WL_16 VSS m2_n44135_352# a_n45017_6713# nmos$2
Xnmos$2_4061 a_n44870_6494# VSS SL_24 a_n44556_6483# nmos$2
Xnmos$2_4083 WL_17 VSS a_n40351_5186# SL_27 nmos$2
Xnmos$2_3360 a_n72108_26333# VSS a_n71647_26103# SL_6N nmos$2
Xnmos$2_3371 WL_8 VSS SL_17N a_n55557_17177# nmos$2
Xnmos$2_4094 a_n41542_6483# VSS ML_16 m1_n41445_6691# nmos$2
Xnmos$3_760 a_n57062_27641# VSS VSS a_n56915_27422# nmos$3
Xnmos$2_3393 a_n53901_19574# VSS SL_18 a_n53587_19563# nmos$2
Xnmos$2_3382 a_n55410_16958# VSS SL_17 a_n55096_16947# nmos$2
Xnmos$2_2670 WL_14 VSS a_n74975_9110# SL_4 nmos$2
Xnmos$3_771 a_n35976_4097# VSS VSS a_n35829_3878# nmos$3
Xnmos$5_18 VEVAL VSS m1_n39940_n10313# VSS nmos$5
Xnmos$5_29 VEVAL VSS m1_n44459_n7697# VSS nmos$5
Xnmos$3_793 a_n38990_11945# VSS VSS a_n38843_11726# nmos$3
Xnmos$2_2692 WL_12 VSS a_n74975_11726# SL_4 nmos$2
Xnmos$2_2681 WL_13 VSS SL_2N a_n78135_10637# nmos$2
Xnmos$3_782 a_n34471_6713# VSS VSS a_n34324_6494# nmos$3
Xnmos$2_281 a_n49069_n9213# VSS ML_28 m1_n48972_n9005# nmos$2
Xnmos$2_270 a_n50574_n7905# VSS ML_27 m1_n50477_n7697# nmos$2
Xnmos$2_1991 a_n58411_7802# VSS SL_15 a_n58097_7791# nmos$2
Xnmos$2_1980 WL_16 VSS a_n59916_6494# SL_14 nmos$2
Xnmos$2_292 a_n48021_n7974# VSS a_n47560_n7905# SL_22N nmos$2
Xpmos_1820 a_n43512_1481# VDD a_n43365_1262# VDD pmos
Xpmos_1842 a_n41856_6494# VDD VDD a_n42003_6713# pmos
Xpmos_1831 a_n44870_6494# VDD VDD a_n45017_6713# pmos
Xpmos_1853 a_n46516_2789# VDD a_n46369_2570# VDD pmos
Xpmos_1897 a_n49530_6713# VDD a_n49383_6494# VDD pmos
Xpmos_1886 a_n53901_5186# VDD VDD a_n54048_5405# pmos
Xpmos_1864 a_n46516_4097# VDD a_n46369_3878# VDD pmos
Xpmos_1875 a_n53901_1262# VDD VDD a_n54048_1481# pmos
Xnmos$5_1 VEVAL VSS m1_n33913_n28774# VSS nmos$5
Xnmos$2_1210 a_n78135_n1434# VSS a_n77674_n1365# SL_2N nmos$2
Xnmos$2_1221 a_n74661_n57# VSS ML_21 m1_n74564_151# nmos$2
Xnmos$2_1243 a_n74975_n2662# VSS SL_4 a_n74661_n2673# nmos$2
Xnmos$2_1232 a_n76169_n2673# VSS ML_23 m1_n76072_n2465# nmos$2
Xnmos$2_1254 WL_25 VSS SL_7N a_n70603_n5358# nmos$2
Xnmos$2_1276 a_n75122_n5358# VSS a_n74661_n5289# SL_4N nmos$2
Xnmos$2_1287 a_n75122_n4050# VSS a_n74661_n3981# SL_4N nmos$2
Xnmos$2_1265 a_n68643_n3981# VSS ML_24 m1_n68546_n3773# nmos$2
Xnmos$2_1298 WL_22 VSS a_n71961_n1354# SL_6 nmos$2
Xpmos_1105 a_n74975_7802# VDD VDD a_n75122_8021# pmos
Xpmos_1116 a_n70456_6494# VDD VDD a_n70603_6713# pmos
Xpmos_1149 a_n79497_3878# VDD VDD a_n79644_4097# pmos
Xpmos_1127 a_n76483_2570# VDD VDD a_n76630_2789# pmos
Xpmos_1138 a_n79497_1262# VDD VDD a_n79644_1481# pmos
Xpmos_309 a_n34471_n5358# VDD a_n34324_n5278# VDD pmos
Xnmos_1025 a_n49383_13034# VSS a_n49530_13253# VSS nmos
Xnmos_1014 a_n53901_10418# VSS a_n54048_10637# VSS nmos
Xnmos_1003 a_n50888_3878# VSS a_n51035_4097# VSS nmos
Xnmos_1069 a_n46369_19574# VSS a_n46516_19793# VSS nmos
Xnmos_1058 a_n41856_15650# VSS a_n42003_15869# VSS nmos
Xnmos_1047 a_n44870_14342# VSS a_n45017_14561# VSS nmos
Xnmos_1036 a_n41856_9110# VSS a_n42003_9329# VSS nmos
Xnmos$3_1018 a_n35976_25025# VSS VSS a_n35829_24806# nmos$3
Xnmos$3_1007 a_n35976_23717# VSS VSS a_n35829_23498# nmos$3
Xnmos$3_1029 a_n49530_1481# VSS VSS a_n49383_1262# nmos$3
Xnmos$2_3190 WL_3 VSS a_n79497_23498# SL_1 nmos$2
Xnmos$3_590 a_n69104_14561# VSS VSS a_n68957_14342# nmos$3
Xpmos_2340 a_n26495_24108# VDD VDD m1_n26796_24120# pmos
Xpmos_2362 a_n40351_20882# VDD VDD a_n40498_21101# pmos
Xpmos_2351 a_n40351_7802# VDD VDD a_n40498_8021# pmos
Xpmos_1661 OUTP VDD VDD a_n28089_6358# pmos
Xpmos_1650 a_n26495_5414# VDD COMP18 VDD pmos
Xpmos_1672 a_n35829_1262# VDD VDD a_n35976_1481# pmos
Xpmos_810 a_n58558_n6666# VDD a_n58411_n6586# VDD pmos
Xpmos_1694 a_n37338_6494# VDD VDD a_n37485_6713# pmos
Xpmos_854 a_n55557_2789# VDD a_n55410_2570# VDD pmos
Xpmos_1683 a_n38843_1262# VDD VDD a_n38990_1481# pmos
Xpmos_821 a_n59916_n46# VDD VDD a_n60063_173# pmos
Xpmos_832 a_n55557_n2742# VDD a_n55410_n2662# VDD pmos
Xpmos_843 a_n61425_n7894# VDD VDD a_n61572_n7974# pmos
Xpmos_887 a_n57062_8021# VDD a_n56915_7802# VDD pmos
Xpmos_865 a_n58411_2570# VDD VDD a_n58558_2789# pmos
Xpmos_876 a_n58558_2789# VDD a_n58411_2570# VDD pmos
Xnmos$2_4808 a_n49069_27411# VSS ML_0 m1_n48972_27619# nmos$2
Xnmos$2_4819 a_n49383_26114# VSS SL_21 a_n49069_26103# nmos$2
Xpmos_898 a_n55557_5405# VDD a_n55410_5186# VDD pmos
Xnmos$5_811 VEVAL VSS m1_n44459_6691# VSS nmos$5
Xnmos$5_800 VEVAL VSS m1_n41445_2767# VSS nmos$5
Xnmos$5_844 VEVAL VSS m1_n51985_7999# VSS nmos$5
Xnmos$5_833 VEVAL VSS m1_n47463_4075# VSS nmos$5
Xnmos$5_822 VEVAL VSS m1_n42954_1459# VSS nmos$5
Xnmos$5_888 VEVAL VSS m1_n44459_14539# VSS nmos$5
Xnmos$5_866 VEVAL VSS m1_n51985_13231# VSS nmos$5
Xnmos$5_877 VEVAL VSS m1_n39940_9307# VSS nmos$5
Xnmos$5_855 VEVAL VSS m1_n48972_9307# VSS nmos$5
Xnmos$5_899 VEVAL VSS m1_n39940_15847# VSS nmos$5
Xnmos$2_1040 a_n76630_n11898# VSS a_n76169_n11829# SL_3N nmos$2
Xnmos$2_1051 WL_31 VSS a_n77988_n13126# SL_2 nmos$2
Xnmos$2_1062 a_n81002_n10510# VSS SL_0 a_n80688_n10521# nmos$2
Xnmos$2_1073 a_n79183_n11829# VSS ML_30 m1_n79086_n11621# nmos$2
Xnmos$2_1084 WL_30 VSS a_n79497_n11818# SL_1 nmos$2
Xnmos$2_1095 WL_28 VSS a_n81002_n9202# SL_0 nmos$2
Xnmos$2_19 a_n37024_n28982# VSS a_n32313_n28669# m1_n36927_n28774# nmos$2
Xpmos_106 a_n49530_n7974# VDD a_n49383_n7894# VDD pmos
Xpmos_117 a_n50888_n10510# VDD VDD a_n51035_n10590# pmos
Xpmos_139 a_n53901_n5278# VDD VDD a_n54048_n5358# pmos
Xpmos_128 a_n47874_n3970# VDD VDD a_n48021_n4050# pmos
Xpmos_2181 a_n43512_27641# VDD a_n43365_27422# VDD pmos
Xpmos_2170 a_n40498_26333# VDD a_n40351_26114# VDD pmos
Xpmos_2192 a_n27618_19794# VDD VDD m1_n27919_19806# pmos
Xpmos_1480 a_n60063_17177# VDD a_n59916_16958# VDD pmos
Xpmos_1491 a_n58558_18485# VDD a_n58411_18266# VDD pmos
Xpmos_651 a_n69104_n1434# VDD a_n68957_n1354# VDD pmos
Xpmos_640 a_n68957_n2662# VDD VDD a_n69104_n2742# pmos
Xpmos_662 a_n60063_n13206# VDD a_n59916_n13126# VDD pmos
Xnmos$2_4605 WL_5 VSS a_n44870_20882# SL_24 nmos$2
Xpmos_684 a_n58558_n9282# VDD a_n58411_n9202# VDD pmos
Xpmos_673 a_n58411_n9202# VDD VDD a_n58558_n9282# pmos
Xpmos_695 a_n55410_n7894# VDD VDD a_n55557_n7974# pmos
Xnmos$2_4649 a_n40351_23498# VSS SL_27 a_n40037_23487# nmos$2
Xnmos$2_4616 a_n44556_23487# VSS ML_3 m1_n44459_23695# nmos$2
Xnmos$2_4627 a_n40498_21101# VSS a_n40037_20871# SL_27N nmos$2
Xnmos$2_4638 a_n43512_21101# VSS a_n43051_20871# SL_25N nmos$2
Xnmos$2_3904 a_n37485_10637# VSS a_n37024_10407# SL_29N nmos$2
Xnmos$5_107 VEVAL VSS m1_n42954_n5081# VSS nmos$5
Xnmos$2_3937 a_n37338_14342# VSS SL_29 a_n37024_14331# nmos$2
Xnmos$2_3926 WL_12 VSS SL_28N a_n38990_11945# nmos$2
Xnmos$2_3915 WL_13 VSS a_n38843_10418# SL_28 nmos$2
Xnmos$5_118 VEVAL VSS m1_n36927_n12929# VSS nmos$5
Xnmos$5_129 VEVAL VSS m1_n36927_n7697# VSS nmos$5
Xnmos$2_3959 a_n37024_15639# VSS ML_9 m1_n36927_15847# nmos$2
Xnmos$2_3948 a_n38529_13023# VSS ML_11 m1_n38432_13231# nmos$2
Xnmos$2_803 a_n37485_n6666# VSS a_n37024_n6597# SL_29N nmos$2
Xnmos$2_836 a_n64585_n29051# VSS a_n64124_n28982# PSL_11N nmos$2
Xnmos$2_814 WL VSS a_n58411_n28971# PSL_15 nmos$2
Xnmos$2_825 WL VSS PSL_15N a_n58558_n29051# nmos$2
Xnmos$2_869 a_n73617_n29051# VSS a_n73156_n28982# PSL_5N nmos$2
Xnmos$2_858 a_n69104_n29051# VSS a_n68643_n28982# PSL_8N nmos$2
Xnmos$2_847 WL VSS PSL_13N a_n61572_n29051# nmos$2
Xnmos$5_663 VEVAL VSS m1_n71550_25003# VSS nmos$5
Xnmos$5_641 VEVAL VSS m1_n74564_23695# VSS nmos$5
Xnmos$5_652 VEVAL VSS m1_n80591_25003# VSS nmos$5
Xnmos$5_630 VEVAL VSS m1_n80591_22387# VSS nmos$5
Xnmos$5_685 VEVAL VSS m1_n59505_23695# VSS nmos$5
Xnmos$5_674 VEVAL VSS m1_n54999_19771# VSS nmos$5
Xnmos$5_696 VEVAL VSS m1_n62519_18463# VSS nmos$5
Xnmos_609 a_n81002_7802# VSS a_n81149_8021# VSS nmos
Xnmos$2_1809 a_n59916_n1354# VSS SL_14 a_n59602_n1365# nmos$2
Xnmos$3_40 a_n49530_n11898# VSS VSS a_n49383_n11818# nmos$3
Xnmos$3_51 a_n51035_n11898# VSS VSS a_n50888_n11818# nmos$3
Xnmos$3_62 a_n46516_n6666# VSS VSS a_n46369_n6586# nmos$3
Xnmos$3_73 a_n51035_n5358# VSS VSS a_n50888_n5278# nmos$3
Xnmos$3_84 a_n46516_173# VSS VSS a_n46369_n46# nmos$3
Xnmos$3_95 a_n40498_n4050# VSS VSS a_n40351_n3970# nmos$3
Xnmos$2_5103 WL_0 VSS SL_29N a_n37485_27641# nmos$2
Xnmos$2_5114 WL_2 VSS a_n35829_24806# SL_30 nmos$2
Xnmos$2_5125 WL_20 VSS SL_28N a_n38990_1481# nmos$2
Xpmos_470 a_n74975_n9202# VDD VDD a_n75122_n9282# pmos
Xnmos$2_4402 a_n42003_11945# VSS a_n41542_11715# SL_26N nmos$2
Xnmos$2_4413 a_n43365_9110# VSS SL_25 a_n43051_9099# nmos$2
Xnmos$2_5136 WL_20 VSS a_n34324_1262# SL_31 nmos$2
Xnmos$2_5158 WL_20 VSS a_n76483_1262# SL_3 nmos$2
Xnmos$2_5147 WL_20 VSS a_n81002_1262# SL_0 nmos$2
Xpmos_481 a_n68957_n10510# VDD VDD a_n69104_n10590# pmos
Xpmos_492 a_n69104_n9282# VDD a_n68957_n9202# VDD pmos
Xnmos$2_3701 WL_1 VSS SL_9N a_n67599_26333# nmos$2
Xnmos$2_3712 a_n53587_24795# VSS ML_2 m1_n53490_25003# nmos$2
Xnmos$2_4457 WL_9 VSS SL_23N a_n46516_15869# nmos$2
Xnmos$2_4446 WL_10 VSS m2_n44135_352# a_n45017_14561# nmos$2
Xnmos$2_4424 a_n44870_11726# VSS SL_24 a_n44556_11715# nmos$2
Xnmos$2_4435 a_n44556_10407# VSS ML_13 m1_n44459_10615# nmos$2
Xnmos$2_5169 WL_20 VSS a_n50888_1262# SL_20 nmos$2
Xnmos$2_3723 a_n57062_27641# VSS a_n56601_27411# SL_16N nmos$2
Xnmos$2_3734 WL_1 VSS a_n53901_26114# SL_18 nmos$2
Xnmos$2_3745 WL_2 VSS SL_15N a_n58558_25025# nmos$2
Xnmos$2_4479 a_n40037_14331# VSS ML_10 m1_n39940_14539# nmos$2
Xnmos$2_4468 a_n44556_14331# VSS ML_10 m1_n44459_14539# nmos$2
Xnmos$2_3756 a_n60063_27641# VSS a_n59602_27411# SL_14N nmos$2
Xnmos$2_3778 a_n56915_26114# VSS SL_16 a_n56601_26103# nmos$2
Xnmos$2_3767 WL_1 VSS SL_15N a_n58558_26333# nmos$2
Xnmos$2_611 a_n37024_n13137# VSS ML_31 m1_n36927_n12929# nmos$2
Xnmos$2_600 WL_29 VSS SL_30N a_n35976_n10590# nmos$2
Xnmos$1_121 OUTP VSS a_n26151_28422# a_n27618_28422# nmos$1
Xnmos$1_110 a_n28089_25052# VSS a_n27274_25546# m1_n28364_25469# nmos$1
Xnmos$2_3789 WL_18 VSS SL_30N a_n35976_4097# nmos$2
Xnmos$2_622 a_n38529_n11829# VSS ML_30 m1_n38432_n11621# nmos$2
Xnmos$2_633 a_n37485_n11898# VSS a_n37024_n11829# SL_29N nmos$2
Xnmos$2_644 WL_28 VSS SL_28N a_n38990_n9282# nmos$2
Xnmos$2_655 a_n37024_n7905# VSS ML_27 m1_n36927_n7697# nmos$2
Xnmos$2_677 a_n35829_n11818# VSS SL_30 a_n35515_n11829# nmos$2
Xnmos$2_666 a_n34324_n7894# VSS SL_31 a_n34010_n7905# nmos$2
Xnmos$2_688 a_n35515_n5289# VSS ML_25 m1_n35418_n5081# nmos$2
Xnmos$2_699 a_n34471_n4050# VSS a_n34010_n3981# SL_31N nmos$2
Xnmos$2_4991 a_n37485_19793# VSS a_n37024_19563# SL_29N nmos$2
Xnmos$2_4980 a_n38990_17177# VSS a_n38529_16947# SL_28N nmos$2
Xnmos$5_471 VEVAL VSS m1_n59505_13231# VSS nmos$5
Xnmos$5_460 VEVAL VSS m1_n56504_11923# VSS nmos$5
Xnmos$5_493 VEVAL VSS m1_n71550_6691# VSS nmos$5
Xnmos$5_482 VEVAL VSS m1_n70045_1459# VSS nmos$5
Xpmos$1_36 OUTP VDD a_n27274_n338# m1_n28364_n415# pmos$1
Xpmos$1_14 a_n28089_n9460# VDD m1_n27919_n8954# a_n27274_n8966# pmos$1
Xpmos$1_25 OUTP VDD m1_n26796_n3202# a_n26151_n3214# pmos$1
Xpmos$1_69 OUTP VDD m1_n26796_15492# a_n26151_15480# pmos$1
Xpmos$1_58 a_n28089_6358# VDD m1_n27919_6864# a_n27274_6852# pmos$1
Xpmos$1_47 OUTP VDD a_n27274_2538# m1_n28364_2461# pmos$1
Xnmos_406 a_n61425_n10510# VSS a_n61572_n10590# VSS nmos
Xnmos_439 a_n67452_n1354# VSS a_n67599_n1434# VSS nmos
Xnmos_417 a_n65943_n6586# VSS a_n66090_n6666# VSS nmos
Xnmos_428 a_n62930_n5278# VSS a_n63077_n5358# VSS nmos
Xnmos$2_3008 WL_6 VSS SL_6N a_n72108_19793# nmos$2
Xnmos$2_3019 WL_4 VSS SL_6N a_n72108_22409# nmos$2
Xnmos$2_2329 WL_13 VSS SL_15N a_n58558_10637# nmos$2
Xnmos$2_2318 a_n55096_9099# VSS ML_14 m1_n54999_9307# nmos$2
Xnmos$2_2307 WL_14 VSS SL_16N a_n57062_9329# nmos$2
Xnmos$3_408 a_n54048_8021# VSS VSS a_n53901_7802# nmos$3
Xnmos$3_419 a_n66090_5405# VSS VSS a_n65943_5186# nmos$3
Xnmos$2_1606 WL_28 VSS a_n65943_n9202# SL_10 nmos$2
Xnmos$2_1628 a_n64585_n9282# VSS a_n64124_n9213# SL_11N nmos$2
Xnmos$2_1617 a_n64438_n7894# VSS SL_11 a_n64124_n7905# nmos$2
Xnmos$2_1639 WL_27 VSS SL_13N a_n61572_n7974# nmos$2
Xnmos_951 a_n26495_14042# VSS m1_n26796_14054# VSS nmos
Xnmos_940 ML_14 VSS VSS a_n28485_11264# nmos
Xnmos$2_4232 WL_14 VSS SL_22N a_n48021_9329# nmos$2
Xnmos$2_4221 a_n49069_7791# VSS ML_15 m1_n48972_7999# nmos$2
Xnmos$2_4210 a_n49530_6713# VSS a_n49069_6483# SL_21N nmos$2
Xnmos_962 a_n43365_3878# VSS a_n43512_4097# VSS nmos
Xnmos$2_3520 a_n62930_16958# VSS SL_12 a_n62616_16947# nmos$2
Xnmos$2_4254 WL_12 VSS a_n49383_11726# SL_21 nmos$2
Xnmos$2_4243 a_n49530_10637# VSS a_n49069_10407# SL_21N nmos$2
Xnmos$2_4265 a_n51035_9329# VSS a_n50574_9099# SL_20N nmos$2
Xnmos_973 a_n44870_7802# VSS a_n45017_8021# VSS nmos
Xnmos_995 a_n47874_5186# VSS a_n48021_5405# VSS nmos
Xnmos_984 a_n52396_2570# VSS a_n52543_2789# VSS nmos
Xnmos$3_920 a_n43512_22409# VSS VSS a_n43365_22190# nmos$3
Xnmos$2_3531 a_n64585_19793# VSS a_n64124_19563# SL_11N nmos$2
Xnmos$2_3542 a_n64438_18266# VSS SL_11 a_n64124_18255# nmos$2
Xnmos$2_3553 a_n67138_18255# VSS ML_7 m1_n67041_18463# nmos$2
Xnmos$2_4287 a_n52082_11715# VSS ML_12 m1_n51985_11923# nmos$2
Xnmos$2_4298 WL_13 VSS SL_19N a_n52543_10637# nmos$2
Xnmos$2_4276 WL_13 VSS a_n52396_10418# SL_19 nmos$2
Xnmos$2_3597 WL_3 VSS SL_9N a_n67599_23717# nmos$2
Xnmos$3_953 a_n46516_21101# VSS VSS a_n46369_20882# nmos$3
Xnmos$2_3575 a_n64438_20882# VSS SL_11 a_n64124_20871# nmos$2
Xnmos$2_3564 a_n65943_19574# VSS SL_10 a_n65629_19563# nmos$2
Xnmos$2_3586 WL_5 VSS a_n65943_20882# SL_10 nmos$2
Xnmos$3_942 a_n52543_18485# VSS VSS a_n52396_18266# nmos$3
Xnmos$3_931 a_n46516_17177# VSS VSS a_n46369_16958# nmos$3
Xnmos$2_2830 a_n67452_11726# VSS SL_9 a_n67138_11715# nmos$2
Xnmos$2_2841 a_n72108_10637# VSS a_n71647_10407# SL_6N nmos$2
Xnmos$2_2852 WL_13 VSS a_n73470_10418# SL_5 nmos$2
Xnmos$3_986 a_n45017_27641# VSS VSS a_n44870_27422# nmos$3
Xnmos$3_975 a_n51035_27641# VSS VSS a_n50888_27422# nmos$3
Xnmos$3_964 a_n49530_25025# VSS VSS a_n49383_24806# nmos$3
Xnmos$2_2874 a_n72108_14561# VSS a_n71647_14331# SL_6N nmos$2
Xnmos$2_2885 a_n73156_13023# VSS ML_11 m1_n73059_13231# nmos$2
Xnmos$2_2863 a_n72108_11945# VSS a_n71647_11715# SL_6N nmos$2
Xnmos$2_463 a_n44870_n1354# VSS SL_24 a_n44556_n1365# nmos$2
Xnmos$2_441 WL_25 VSS a_n44870_n5278# SL_24 nmos$2
Xnmos$2_452 a_n45017_n4050# VSS a_n44556_n3981# m2_n44135_352# nmos$2
Xnmos$2_430 a_n40037_n3981# VSS ML_24 m1_n39940_n3773# nmos$2
Xnmos$3_997 a_n38990_19793# VSS VSS a_n38843_19574# nmos$3
Xnmos$2_2896 a_n73156_15639# VSS ML_9 m1_n73059_15847# nmos$2
Xnmos$2_496 a_n40351_n46# VSS SL_27 a_n40037_n57# nmos$2
Xnmos$2_474 a_n43365_n46# VSS SL_25 a_n43051_n57# nmos$2
Xnmos$2_485 a_n40498_n1434# VSS a_n40037_n1365# SL_27N nmos$2
Xnmos$5_290 VEVAL VSS m1_n58000_n6389# VSS nmos$5
Xnmos_214 OUTP VSS a_n28089_n3708# VSS nmos
Xnmos_203 a_n26495_n6090# VSS m1_n26796_n6078# VSS nmos
Xnmos_236 a_n27274_n338# VSS a_n27618_n338# VSS nmos
Xnmos_225 OUTP VSS a_n28089_n2270# VSS nmos
Xnmos_258 a_n55410_n28971# VSS a_n55557_n29051# VSS nmos
Xnmos_247 a_n40351_n10510# VSS a_n40498_n10590# VSS nmos
Xnmos_269 a_n71961_n28971# VSS a_n72108_n29051# VSS nmos
Xnmos$2_2104 WL_15 VSS SL_9N a_n67599_8021# nmos$2
Xnmos$3_205 a_n75122_n13206# VSS VSS a_n74975_n13126# nmos$3
Xnmos$2_2148 WL_15 VSS SL_12N a_n63077_8021# nmos$2
Xnmos$2_2137 a_n62616_7791# VSS ML_15 m1_n62519_7999# nmos$2
Xnmos$2_2115 WL_16 VSS a_n61425_6494# SL_13 nmos$2
Xnmos$2_2126 WL_16 VSS SL_11N a_n64585_6713# nmos$2
Xnmos$3_216 a_n79644_n11898# VSS VSS a_n79497_n11818# nmos$3
Xnmos$3_227 a_n78135_n6666# VSS VSS a_n77988_n6586# nmos$3
Xnmos$2_1403 a_n73156_n6597# VSS ML_26 m1_n73059_n6389# nmos$2
Xnmos$3_238 a_n75122_n4050# VSS VSS a_n74975_n3970# nmos$3
Xnmos$2_2159 WL_13 VSS a_n61425_10418# SL_13 nmos$2
Xnmos$3_249 a_n79644_173# VSS VSS a_n79497_n46# nmos$3
Xnmos$2_1414 WL_31 VSS a_n53901_n13126# SL_18 nmos$2
Xnmos$2_1425 a_n55410_n11818# VSS SL_17 a_n55096_n11829# nmos$2
Xnmos$2_1436 WL_29 VSS a_n53901_n10510# SL_18 nmos$2
Xnmos$2_1447 a_n58097_n13137# VSS ML_31 m1_n58000_n12929# nmos$2
Xnmos$2_1458 a_n59602_n11829# VSS ML_30 m1_n59505_n11621# nmos$2
Xnmos$2_1469 WL_30 VSS SL_15N a_n58558_n11898# nmos$2
Xpmos_1309 a_n71961_16958# VDD VDD a_n72108_17177# pmos
Xnmos_1218 a_n37338_26114# VSS a_n37485_26333# VSS nmos
Xnmos_1207 a_n34324_22190# VSS a_n34471_22409# VSS nmos
Xnmos_1229 a_n27274_25546# VSS a_n27618_25546# VSS nmos
Xnmos_770 a_n55410_22190# VSS a_n55557_22409# VSS nmos
Xnmos$2_4040 WL_18 VSS a_n43365_3878# SL_25 nmos$2
Xnmos_792 a_n65943_20882# VSS a_n66090_21101# VSS nmos
Xnmos_781 a_n64438_16958# VSS a_n64585_17177# VSS nmos
Xnmos$2_4073 WL_15 VSS a_n43365_7802# SL_25 nmos$2
Xnmos$2_4051 a_n45017_6713# VSS a_n44556_6483# m2_n44135_352# nmos$2
Xnmos$2_4062 a_n44870_5186# VSS SL_24 a_n44556_5175# nmos$2
Xnmos$2_3350 WL_0 VSS SL_6N a_n72108_27641# nmos$2
Xnmos$2_3361 WL_1 VSS SL_6N a_n72108_26333# nmos$2
Xnmos$2_3372 WL_7 VSS SL_17N a_n55557_18485# nmos$2
Xnmos$2_4084 WL_16 VSS a_n40351_6494# SL_27 nmos$2
Xnmos$2_4095 WL_16 VSS SL_25N a_n43512_6713# nmos$2
Xnmos$3_761 a_n58558_27641# VSS VSS a_n58411_27422# nmos$3
Xnmos$3_750 a_n54048_26333# VSS VSS a_n53901_26114# nmos$3
Xnmos$2_3394 WL_6 VSS SL_17N a_n55557_19793# nmos$2
Xnmos$2_3383 a_n56601_16947# VSS ML_8 m1_n56504_17155# nmos$2
Xnmos$2_2660 a_n76630_8021# VSS a_n76169_7791# SL_3N nmos$2
Xnmos$5_19 VEVAL VSS m1_n44459_n12929# VSS nmos$5
Xnmos$3_794 a_n35976_11945# VSS VSS a_n35829_11726# nmos$3
Xnmos$2_2693 a_n74975_11726# VSS SL_4 a_n74661_11715# nmos$2
Xnmos$2_2682 a_n78135_10637# VSS a_n77674_10407# SL_2N nmos$2
Xnmos$2_2671 a_n77674_9099# VSS ML_14 m1_n77577_9307# nmos$2
Xnmos$3_783 a_n34471_8021# VSS VSS a_n34324_7802# nmos$3
Xnmos$3_772 a_n35976_5405# VSS VSS a_n35829_5186# nmos$3
Xnmos$2_260 WL_28 VSS SL_18N a_n54048_n9282# nmos$2
Xnmos$2_271 a_n52543_n7974# VSS a_n52082_n7905# SL_19N nmos$2
Xnmos$2_1992 WL_15 VSS a_n58411_7802# SL_15 nmos$2
Xnmos$2_1970 WL_16 VSS a_n56915_6494# SL_16 nmos$2
Xnmos$2_1981 a_n60063_5405# VSS a_n59602_5175# SL_14N nmos$2
Xnmos$2_282 WL_28 VSS SL_21N a_n49530_n9282# nmos$2
Xnmos$2_293 WL_27 VSS a_n46369_n7894# SL_23 nmos$2
Xpmos_1810 a_n42003_1481# VDD a_n41856_1262# VDD pmos
Xpmos_1821 a_n46369_1262# VDD VDD a_n46516_1481# pmos
Xpmos_1843 a_n40498_5405# VDD a_n40351_5186# VDD pmos
Xpmos_1832 a_n43512_5405# VDD a_n43365_5186# VDD pmos
Xpmos_1854 a_n47874_2570# VDD VDD a_n48021_2789# pmos
Xpmos_1887 a_n52543_5405# VDD a_n52396_5186# VDD pmos
Xpmos_1876 a_n53901_3878# VDD VDD a_n54048_4097# pmos
Xpmos_1865 a_n48021_2789# VDD a_n47874_2570# VDD pmos
Xpmos_1898 a_n49383_5186# VDD VDD a_n49530_5405# pmos
Xnmos$5_2 VEVAL VSS m1_n38432_n28774# VSS nmos$5
Xnmos$2_1200 WL_21 VSS a_n79497_n46# SL_1 nmos$2
Xnmos$2_1211 WL_22 VSS SL_2N a_n78135_n1434# nmos$2
Xnmos$2_1222 a_n76630_173# VSS a_n76169_n57# SL_3N nmos$2
Xnmos$2_1244 WL_23 VSS a_n74975_n2662# SL_4 nmos$2
Xnmos$2_1233 a_n76483_n2662# VSS SL_3 a_n76169_n2673# nmos$2
Xnmos$2_1277 WL_25 VSS SL_4N a_n75122_n5358# nmos$2
Xnmos$2_1255 a_n70142_n5289# VSS ML_25 m1_n70045_n5081# nmos$2
Xnmos$2_1266 WL_24 VSS SL_8N a_n69104_n4050# nmos$2
Xnmos$2_1299 a_n71647_n1365# VSS ML_22 m1_n71550_n1157# nmos$2
Xnmos$2_1288 WL_24 VSS a_n71961_n3970# SL_6 nmos$2
Xpmos_1106 a_n71961_7802# VDD VDD a_n72108_8021# pmos
Xpmos_1117 a_n70603_6713# VDD a_n70456_6494# VDD pmos
Xpmos_1128 a_n75122_2789# VDD a_n74975_2570# VDD pmos
Xpmos_1139 a_n78135_2789# VDD a_n77988_2570# VDD pmos
Xnmos_1026 a_n49383_14342# VSS a_n49530_14561# VSS nmos
Xnmos_1015 a_n53901_11726# VSS a_n54048_11945# VSS nmos
Xnmos_1004 a_n50888_5186# VSS a_n51035_5405# VSS nmos
Xnmos_1059 a_n41856_18266# VSS a_n42003_18485# VSS nmos
Xnmos_1048 a_n44870_13034# VSS a_n45017_13253# VSS nmos
Xnmos_1037 a_n43365_10418# VSS a_n43512_10637# VSS nmos
Xnmos$3_1019 a_n38990_26333# VSS VSS a_n38843_26114# nmos$3
Xnmos$3_1008 a_n37485_23717# VSS VSS a_n37338_23498# nmos$3
Xnmos$2_3180 a_n80688_23487# VSS ML_3 m1_n80591_23695# nmos$2
Xnmos$2_3191 WL_5 VSS a_n79497_20882# SL_1 nmos$2
Xnmos$3_591 a_n69104_15869# VSS VSS a_n68957_15650# nmos$3
Xnmos$3_580 a_n73617_13253# VSS VSS a_n73470_13034# nmos$3
Xnmos$2_2490 a_n73470_5186# VSS SL_5 a_n73156_5175# nmos$2
Xpmos_2330 a_n26495_29860# VDD COMP1 VDD pmos
Xpmos_2341 a_n28485_24206# VDD m1_n28364_24031# VDD pmos
Xpmos_2352 a_n40351_6494# VDD VDD a_n40498_6713# pmos
Xpmos_2363 a_n26495_1100# VDD COMP21 VDD pmos
Xpmos_1662 a_n27274_6852# VDD VDD a_n27618_6852# pmos
Xpmos_1651 a_n28485_5512# VDD m1_n28364_5337# VDD pmos
Xpmos_1640 a_n26495_2538# VDD COMP20 VDD pmos
Xpmos_811 a_n58558_n5358# VDD a_n58411_n5278# VDD pmos
Xpmos_800 a_n58411_n5278# VDD VDD a_n58558_n5358# pmos
Xpmos_1695 a_n37338_5186# VDD VDD a_n37485_5405# pmos
Xpmos_1673 a_n35829_2570# VDD VDD a_n35976_2789# pmos
Xpmos_1684 a_n38843_2570# VDD VDD a_n38990_2789# pmos
Xpmos_822 a_n58411_n46# VDD VDD a_n58558_173# pmos
Xpmos_833 a_n56915_n2662# VDD VDD a_n57062_n2742# pmos
Xpmos_844 a_n61425_n6586# VDD VDD a_n61572_n6666# pmos
Xpmos_888 a_n58411_7802# VDD VDD a_n58558_8021# pmos
Xpmos_877 a_n57062_6713# VDD a_n56915_6494# VDD pmos
Xpmos_855 a_n55557_1481# VDD a_n55410_1262# VDD pmos
Xpmos_866 a_n60063_1481# VDD a_n59916_1262# VDD pmos
Xnmos$2_4809 WL_0 VSS SL_22N a_n48021_27641# nmos$2
Xpmos_899 a_n56915_5186# VDD VDD a_n57062_5405# pmos
Xnmos$5_812 VEVAL VSS m1_n45958_5383# VSS nmos$5
Xnmos$5_801 VEVAL VSS m1_n41445_1459# VSS nmos$5
Xnmos$5_845 VEVAL VSS m1_n50477_7999# VSS nmos$5
Xnmos$5_823 VEVAL VSS m1_n42954_2767# VSS nmos$5
Xnmos$5_834 VEVAL VSS m1_n50477_2767# VSS nmos$5
Xnmos$5_867 VEVAL VSS m1_n51985_14539# VSS nmos$5
Xnmos$5_856 VEVAL VSS m1_n48972_11923# VSS nmos$5
Xnmos$5_878 VEVAL VSS m1_n41445_9307# VSS nmos$5
Xnmos$5_889 VEVAL VSS m1_n44459_13231# VSS nmos$5
Xnmos$2_1030 a_n78135_n11898# VSS a_n77674_n11829# SL_2N nmos$2
Xnmos$2_1052 a_n79183_n13137# VSS ML_31 m1_n79086_n12929# nmos$2
Xnmos$2_1041 a_n74661_n10521# VSS ML_29 m1_n74564_n10313# nmos$2
Xnmos$2_1085 WL_31 VSS a_n79497_n13126# SL_1 nmos$2
Xnmos$2_1063 WL_29 VSS a_n81002_n10510# SL_0 nmos$2
Xnmos$2_1074 a_n79497_n10510# VSS SL_1 a_n79183_n10521# nmos$2
Xnmos$2_1096 a_n80688_n9213# VSS ML_28 m1_n80591_n9005# nmos$2
Xpmos_107 a_n49383_n7894# VDD VDD a_n49530_n7974# pmos
Xpmos_118 a_n46516_n6666# VDD a_n46369_n6586# VDD pmos
Xpmos_129 a_n46516_n4050# VDD a_n46369_n3970# VDD pmos
Xpmos_2182 a_n44870_27422# VDD VDD a_n45017_27641# pmos
Xpmos_2160 a_n40498_25025# VDD a_n40351_24806# VDD pmos
Xpmos_2171 a_n43512_25025# VDD a_n43365_24806# VDD pmos
Xpmos_2193 OUTP VDD VDD a_n28089_19300# pmos
Xpmos_1470 a_n55557_19793# VDD a_n55410_19574# VDD pmos
Xpmos_1492 a_n57062_21101# VDD a_n56915_20882# VDD pmos
Xpmos_1481 a_n59916_18266# VDD VDD a_n60063_18485# pmos
Xpmos_630 a_n74975_n46# VDD VDD a_n75122_173# pmos
Xpmos_641 a_n70603_n1434# VDD a_n70456_n1354# VDD pmos
Xpmos_652 a_n54048_n13206# VDD a_n53901_n13126# VDD pmos
Xnmos$2_4606 a_n44870_23498# VSS SL_24 a_n44556_23487# nmos$2
Xpmos_663 a_n59916_n13126# VDD VDD a_n60063_n13206# pmos
Xpmos_674 a_n59916_n10510# VDD VDD a_n60063_n10590# pmos
Xpmos_685 a_n54048_n9282# VDD a_n53901_n9202# VDD pmos
Xpmos_696 a_n54048_n7974# VDD a_n53901_n7894# VDD pmos
Xnmos$2_4628 WL_5 VSS SL_26N a_n42003_21101# nmos$2
Xnmos$2_4639 WL_4 VSS SL_25N a_n43512_22409# nmos$2
Xnmos$2_4617 a_n44556_22179# VSS ML_4 m1_n44459_22387# nmos$2
Xnmos$2_3927 a_n38529_11715# VSS ML_12 m1_n38432_11923# nmos$2
Xnmos$2_3905 WL_13 VSS SL_29N a_n37485_10637# nmos$2
Xnmos$2_3916 a_n38990_9329# VSS a_n38529_9099# SL_28N nmos$2
Xnmos$5_108 VEVAL VSS m1_n42954_151# VSS nmos$5
Xnmos$5_119 VEVAL VSS m1_n38432_n12929# VSS nmos$5
Xnmos$2_3938 a_n37024_13023# VSS ML_11 m1_n36927_13231# nmos$2
Xnmos$2_3949 WL_11 VSS a_n38843_13034# SL_28 nmos$2
Xnmos$2_804 a_n55410_n28971# VSS PSL_17 a_n55096_n28982# nmos$2
Xnmos$2_837 a_n64124_n28982# VSS a_n32313_n28669# m1_n64027_n28774# nmos$2
Xnmos$2_815 a_n59916_n28971# VSS PSL_14 a_n59602_n28982# nmos$2
Xnmos$2_826 a_n57062_n29051# VSS a_n56601_n28982# PSL_16N nmos$2
Xnmos$2_859 a_n67452_n28971# VSS PSL_9 a_n67138_n28982# nmos$2
Xnmos$2_848 a_n65943_n28971# VSS PSL_10 a_n65629_n28982# nmos$2
Xnmos$5_620 VEVAL VSS m1_n74564_19771# VSS nmos$5
Xnmos$5_653 VEVAL VSS m1_n80591_27619# VSS nmos$5
Xnmos$5_642 VEVAL VSS m1_n74564_25003# VSS nmos$5
Xnmos$5_631 VEVAL VSS m1_n80591_23695# VSS nmos$5
Xnmos$5_686 VEVAL VSS m1_n58000_23695# VSS nmos$5
Xnmos$5_664 VEVAL VSS m1_n73059_25003# VSS nmos$5
Xnmos$5_675 VEVAL VSS m1_n58000_18463# VSS nmos$5
Xnmos$5_697 VEVAL VSS m1_n62519_19771# VSS nmos$5
Xnmos$3_41 a_n46516_n11898# VSS VSS a_n46369_n11818# nmos$3
Xnmos$3_30 a_n43512_n7974# VSS VSS a_n43365_n7894# nmos$3
Xnmos$3_52 a_n51035_n9282# VSS VSS a_n50888_n9202# nmos$3
Xnmos$3_63 a_n46516_n7974# VSS VSS a_n46369_n7894# nmos$3
Xnmos$3_74 a_n52543_n5358# VSS VSS a_n52396_n5278# nmos$3
Xnmos$3_85 a_n48021_173# VSS VSS a_n47874_n46# nmos$3
Xnmos$3_96 a_n43512_n5358# VSS VSS a_n43365_n5278# nmos$3
Xnmos$2_5104 a_n37338_26114# VSS SL_29 a_n37024_26103# nmos$2
Xnmos$2_5115 a_n35829_24806# VSS SL_30 a_n35515_24795# nmos$2
Xpmos_460 a_n71961_n11818# VDD VDD a_n72108_n11898# pmos
Xpmos_471 a_n74975_n7894# VDD VDD a_n75122_n7974# pmos
Xnmos$2_4403 a_n42003_10637# VSS a_n41542_10407# SL_26N nmos$2
Xnmos$2_4414 a_n46516_9329# VSS a_n46055_9099# SL_23N nmos$2
Xnmos$2_5137 a_n34324_1262# VSS SL_31 a_n34010_1251# nmos$2
Xnmos$2_5126 a_n38529_1251# VSS ML_20 m1_n38432_1459# nmos$2
Xnmos$2_5159 a_n76169_1251# VSS ML_20 m1_n76072_1459# nmos$2
Xnmos$2_5148 a_n81149_1481# VSS a_n80688_1251# SL_0N nmos$2
Xpmos_493 a_n75122_n13206# VDD a_n74975_n13126# VDD pmos
Xpmos_482 a_n70456_n9202# VDD VDD a_n70603_n9282# pmos
Xnmos$2_3702 a_n65943_26114# VSS SL_10 a_n65629_26103# nmos$2
Xnmos$2_4447 a_n46516_13253# VSS a_n46055_13023# SL_23N nmos$2
Xnmos$2_4425 a_n46055_11715# VSS ML_12 m1_n45958_11923# nmos$2
Xnmos$2_4436 a_n44556_9099# VSS ML_14 m1_n44459_9307# nmos$2
Xnmos$2_3724 a_n56601_27411# VSS ML_0 m1_n56504_27619# nmos$2
Xnmos$2_3735 a_n53587_26103# VSS ML_1 m1_n53490_26311# nmos$2
Xnmos$2_3713 a_n53901_24806# VSS SL_18 a_n53587_24795# nmos$2
Xnmos$2_3746 WL_2 VSS a_n56915_24806# SL_16 nmos$2
Xnmos$2_4469 a_n44556_15639# VSS ML_9 m1_n44459_15847# nmos$2
Xnmos$2_4458 a_n46055_15639# VSS ML_9 m1_n45958_15847# nmos$2
Xnmos$2_3779 a_n56915_27422# VSS SL_16 a_n56601_27411# nmos$2
Xnmos$2_3757 WL_0 VSS SL_14N a_n60063_27641# nmos$2
Xnmos$2_3768 WL_1 VSS a_n56915_26114# SL_16 nmos$2
Xnmos$2_612 WL_31 VSS SL_29N a_n37485_n13206# nmos$2
Xnmos$2_601 WL_30 VSS a_n34324_n11818# SL_31 nmos$2
Xnmos$1_122 a_n28089_27928# VSS m1_n26796_28434# a_n26151_28422# nmos$1
Xnmos$1_111 OUTP VSS a_n26151_26984# a_n27618_26984# nmos$1
Xnmos$1_100 OUTP VSS m1_n27919_21244# a_n27274_21232# nmos$1
Xnmos$2_623 WL_29 VSS a_n38843_n10510# SL_28 nmos$2
Xnmos$2_634 WL_29 VSS SL_29N a_n37485_n10590# nmos$2
Xnmos$2_645 a_n38990_n9282# VSS a_n38529_n9213# SL_28N nmos$2
Xnmos$2_678 WL_31 VSS a_n35829_n13126# SL_30 nmos$2
Xnmos$2_656 WL_27 VSS SL_29N a_n37485_n7974# nmos$2
Xnmos$2_667 a_n35976_n7974# VSS a_n35515_n7905# SL_30N nmos$2
Xnmos$2_689 a_n34324_n5278# VSS SL_31 a_n34010_n5289# nmos$2
Xnmos$2_4970 WL_8 VSS SL_29N a_n37485_17177# nmos$2
Xnmos$2_4992 a_n37024_19563# VSS ML_6 m1_n36927_19771# nmos$2
Xnmos$2_4981 a_n38529_18255# VSS ML_7 m1_n38432_18463# nmos$2
Xnmos$5_450 VEVAL VSS m1_n64027_14539# VSS nmos$5
Xnmos$5_461 VEVAL VSS m1_n54999_11923# VSS nmos$5
Xnmos$5_472 VEVAL VSS m1_n59505_15847# VSS nmos$5
Xnmos$5_494 VEVAL VSS m1_n73059_6691# VSS nmos$5
Xnmos$5_483 VEVAL VSS m1_n70045_2767# VSS nmos$5
Xpmos$1_37 OUTP VDD m1_n26796_n326# a_n26151_n338# pmos$1
Xpmos$1_15 a_n28089_n8022# VDD m1_n27919_n7516# a_n27274_n7528# pmos$1
Xpmos$1_26 a_n28089_n3708# VDD a_n26151_n3214# a_n27618_n3214# pmos$1
Xpmos$1_48 OUTP VDD m1_n26796_5426# a_n26151_5414# pmos$1
Xpmos$1_59 a_n28089_4920# VDD a_n26151_5414# a_n27618_5414# pmos$1
Xnmos_407 a_n65943_n13126# VSS a_n66090_n13206# VSS nmos
Xnmos_418 a_n65943_n7894# VSS a_n66090_n7974# VSS nmos
Xnmos_429 a_n61425_n5278# VSS a_n61572_n5358# VSS nmos
Xnmos$2_3009 a_n72108_19793# VSS a_n71647_19563# SL_6N nmos$2
Xnmos$2_2308 a_n55410_11726# VSS SL_17 a_n55096_11715# nmos$2
Xnmos$2_2319 a_n55096_10407# VSS ML_13 m1_n54999_10615# nmos$2
Xnmos$3_409 a_n61572_2789# VSS VSS a_n61425_2570# nmos$3
Xnmos$2_1607 a_n65943_n9202# VSS SL_10 a_n65629_n9213# nmos$2
Xnmos$2_1618 a_n65629_n9213# VSS ML_28 m1_n65532_n9005# nmos$2
Xnmos$2_1629 a_n62930_n9202# VSS SL_12 a_n62616_n9213# nmos$2
Xnmos_952 a_n27618_15480# VSS m1_n27919_15492# VSS nmos
Xnmos_930 a_n27274_11166# VSS a_n27618_11166# VSS nmos
Xnmos_941 ML_15 VSS VSS a_n28485_9826# nmos
Xnmos$2_4222 a_n49383_7802# VSS SL_21 a_n49069_7791# nmos$2
Xnmos$2_4200 a_n47874_6494# VSS SL_22 a_n47560_6483# nmos$2
Xnmos$2_4211 a_n49383_6494# VSS SL_21 a_n49069_6483# nmos$2
Xpmos_290 a_n38843_n7894# VDD VDD a_n38990_n7974# pmos
Xnmos$2_3510 a_n61111_16947# VSS ML_8 m1_n61014_17155# nmos$2
Xnmos$2_3521 WL_8 VSS a_n62930_16958# SL_12 nmos$2
Xnmos$2_4255 WL_12 VSS SL_21N a_n49530_11945# nmos$2
Xnmos$2_4244 a_n49383_10418# VSS SL_21 a_n49069_10407# nmos$2
Xnmos$2_4233 a_n48021_9329# VSS a_n47560_9099# SL_22N nmos$2
Xnmos_974 a_n41856_6494# VSS a_n42003_6713# VSS nmos
Xnmos_996 a_n49383_6494# VSS a_n49530_6713# VSS nmos
Xnmos_963 a_n41856_3878# VSS a_n42003_4097# VSS nmos
Xnmos_985 a_n53901_2570# VSS a_n54048_2789# VSS nmos
Xnmos$2_3532 WL_6 VSS SL_13N a_n61572_19793# nmos$2
Xnmos$2_3543 WL_7 VSS a_n64438_18266# SL_11 nmos$2
Xnmos$3_910 a_n42003_17177# VSS VSS a_n41856_16958# nmos$3
Xnmos$2_3554 a_n67599_17177# VSS a_n67138_16947# SL_9N nmos$2
Xnmos$2_4299 WL_11 VSS SL_20N a_n51035_13253# nmos$2
Xnmos$2_4288 a_n51035_11945# VSS a_n50574_11715# SL_20N nmos$2
Xnmos$2_4266 a_n51035_10637# VSS a_n50574_10407# SL_20N nmos$2
Xnmos$2_4277 a_n54048_10637# VSS a_n53587_10407# SL_18N nmos$2
Xnmos$3_921 a_n45017_22409# VSS VSS a_n44870_22190# nmos$3
Xnmos$2_3587 a_n67138_22179# VSS ML_4 m1_n67041_22387# nmos$2
Xnmos$2_3565 a_n64124_19563# VSS ML_6 m1_n64027_19771# nmos$2
Xnmos$2_3576 WL_5 VSS a_n64438_20882# SL_11 nmos$2
Xnmos$3_932 a_n46516_18485# VSS VSS a_n46369_18266# nmos$3
Xnmos$3_943 a_n52543_17177# VSS VSS a_n52396_16958# nmos$3
Xnmos$2_2831 a_n69104_11945# VSS a_n68643_11715# SL_8N nmos$2
Xnmos$2_2820 WL_13 VSS a_n70456_10418# SL_7 nmos$2
Xnmos$2_2842 WL_13 VSS SL_6N a_n72108_10637# nmos$2
Xnmos$2_420 WL_25 VSS a_n41856_n5278# SL_26 nmos$2
Xnmos$3_987 a_n43512_27641# VSS VSS a_n43365_27422# nmos$3
Xnmos$3_965 a_n49530_27641# VSS VSS a_n49383_27422# nmos$3
Xnmos$3_976 a_n40498_25025# VSS VSS a_n40351_24806# nmos$3
Xnmos$2_3598 a_n64438_23498# VSS SL_11 a_n64124_23487# nmos$2
Xnmos$3_954 a_n49530_22409# VSS VSS a_n49383_22190# nmos$3
Xnmos$2_2875 a_n71647_14331# VSS ML_10 m1_n71550_14539# nmos$2
Xnmos$2_2886 WL_11 VSS SL_4N a_n75122_13253# nmos$2
Xnmos$2_2864 a_n71647_11715# VSS ML_12 m1_n71550_11923# nmos$2
Xnmos$2_2853 a_n73470_10418# VSS SL_5 a_n73156_10407# nmos$2
Xnmos$2_442 a_n46516_n5358# VSS a_n46055_n5289# SL_23N nmos$2
Xnmos$2_453 WL_24 VSS a_n43365_n3970# SL_25 nmos$2
Xnmos$2_431 a_n40498_n4050# VSS a_n40037_n3981# SL_27N nmos$2
Xnmos$3_998 a_n35976_19793# VSS VSS a_n35829_19574# nmos$3
Xnmos$2_2897 WL_9 VSS SL_4N a_n75122_15869# nmos$2
Xnmos$2_497 a_n40498_173# VSS a_n40037_n57# SL_27N nmos$2
Xnmos$2_475 a_n45017_173# VSS a_n44556_n57# m2_n44135_352# nmos$2
Xnmos$2_486 WL_22 VSS SL_25N a_n43512_n1434# nmos$2
Xnmos$2_464 WL_22 VSS SL_23N a_n46516_n1434# nmos$2
Xnmos$5_280 VEVAL VSS m1_n59505_n12929# VSS nmos$5
Xnmos$5_291 VEVAL VSS m1_n54999_n9005# VSS nmos$5
Xnmos_204 a_n26495_n6090# VSS VSS COMP26 nmos
Xnmos_215 a_n26151_n3214# VSS a_n26495_n3214# VSS nmos
Xnmos_237 a_n26151_1100# VSS a_n26495_1100# VSS nmos
Xnmos_226 a_n26495_n1776# VSS m1_n26796_n1764# VSS nmos
Xnmos_248 a_n40351_n9202# VSS a_n40498_n9282# VSS nmos
Xnmos_259 a_n56915_n28971# VSS a_n57062_n29051# VSS nmos
Xnmos$2_2105 a_n67138_7791# VSS ML_15 m1_n67041_7999# nmos$2
Xnmos$3_206 a_n76630_n13206# VSS VSS a_n76483_n13126# nmos$3
Xnmos$2_2138 WL_15 VSS SL_11N a_n64585_8021# nmos$2
Xnmos$2_2116 a_n61425_6494# VSS SL_13 a_n61111_6483# nmos$2
Xnmos$2_2127 a_n64585_6713# VSS a_n64124_6483# SL_11N nmos$2
Xnmos$3_217 a_n81149_n10590# VSS VSS a_n81002_n10510# nmos$3
Xnmos$3_228 a_n78135_n7974# VSS VSS a_n77988_n7894# nmos$3
Xnmos$3_239 a_n78135_n5358# VSS VSS a_n77988_n5278# nmos$3
Xnmos$2_2149 WL_17 VSS SL_12N a_n63077_5405# nmos$2
Xnmos$2_1415 a_n53587_n13137# VSS ML_31 m1_n53490_n12929# nmos$2
Xnmos$2_1426 a_n55410_n10510# VSS SL_17 a_n55096_n10521# nmos$2
Xnmos$2_1404 a_n72108_n6666# VSS a_n71647_n6597# SL_6N nmos$2
Xnmos$2_1448 WL_31 VSS a_n56915_n13126# SL_16 nmos$2
Xnmos$2_1459 WL_30 VSS a_n59916_n11818# SL_14 nmos$2
Xnmos$2_1437 a_n53587_n10521# VSS ML_29 m1_n53490_n10313# nmos$2
Xnmos_1208 a_n35829_20882# VSS a_n35976_21101# VSS nmos
Xnmos_1219 a_n37338_24806# VSS a_n37485_25025# VSS nmos
Xnmos_771 a_n55410_20882# VSS a_n55557_21101# VSS nmos
Xnmos_760 a_n59916_18266# VSS a_n60063_18485# VSS nmos
Xnmos$2_4030 a_n46055_2559# VSS ML_19 m1_n45958_2767# nmos$2
Xnmos_793 a_n67452_20882# VSS a_n67599_21101# VSS nmos
Xnmos_782 a_n64438_19574# VSS a_n64585_19793# VSS nmos
Xnmos$2_4074 a_n43365_7802# VSS SL_25 a_n43051_7791# nmos$2
Xnmos$2_4063 WL_16 VSS SL_23N a_n46516_6713# nmos$2
Xnmos$2_4052 a_n45017_5405# VSS a_n44556_5175# m2_n44135_352# nmos$2
Xnmos$2_4041 a_n43365_3878# VSS SL_25 a_n43051_3867# nmos$2
Xnmos$2_3351 a_n71961_27422# VSS SL_6 a_n71647_27411# nmos$2
Xnmos$2_3362 a_n71961_26114# VSS SL_6 a_n71647_26103# nmos$2
Xnmos$2_3340 WL_2 VSS a_n73470_24806# SL_5 nmos$2
Xnmos$2_4085 a_n40351_6494# VSS SL_27 a_n40037_6483# nmos$2
Xnmos$2_4096 a_n41542_5175# VSS ML_17 m1_n41445_5383# nmos$2
Xnmos$3_751 a_n55557_26333# VSS VSS a_n55410_26114# nmos$3
Xnmos$3_762 a_n58558_26333# VSS VSS a_n58411_26114# nmos$3
Xnmos$3_740 a_n63077_26333# VSS VSS a_n62930_26114# nmos$3
Xnmos$2_3395 a_n53587_19563# VSS ML_6 m1_n53490_19771# nmos$2
Xnmos$2_3373 a_n53901_16958# VSS SL_18 a_n53587_16947# nmos$2
Xnmos$2_3384 WL_8 VSS SL_16N a_n57062_17177# nmos$2
Xnmos$2_2661 WL_13 VSS a_n74975_10418# SL_4 nmos$2
Xnmos$2_2650 WL_15 VSS a_n76483_7802# SL_3 nmos$2
Xnmos$5_1050 VEVAL VSS m1_n53490_n11621# VSS nmos$5
Xnmos$3_795 a_n37485_11945# VSS VSS a_n37338_11726# nmos$3
Xnmos$2_2683 WL_12 VSS SL_2N a_n78135_11945# nmos$2
Xnmos$3_784 a_n34471_9329# VSS VSS a_n34324_9110# nmos$3
Xnmos$2_2672 WL_14 VSS a_n76483_9110# SL_3 nmos$2
Xnmos$2_2694 WL_14 VSS a_n77988_9110# SL_2 nmos$2
Xnmos$3_773 a_n37485_6713# VSS VSS a_n37338_6494# nmos$3
Xnmos$2_250 a_n52543_n10590# VSS a_n52082_n10521# SL_19N nmos$2
Xnmos$2_261 WL_27 VSS a_n52396_n7894# SL_19 nmos$2
Xnmos$2_1971 a_n58411_6494# VSS SL_15 a_n58097_6483# nmos$2
Xnmos$2_1982 WL_17 VSS SL_14N a_n60063_5405# nmos$2
Xnmos$2_1960 WL_18 VSS a_n58411_3878# SL_15 nmos$2
Xnmos$2_283 a_n49383_n9202# VSS SL_21 a_n49069_n9213# nmos$2
Xnmos$2_272 WL_27 VSS SL_19N a_n52543_n7974# nmos$2
Xnmos$2_294 WL_27 VSS SL_22N a_n48021_n7974# nmos$2
Xnmos$2_1993 a_n58558_8021# VSS a_n58097_7791# SL_15N nmos$2
Xpmos_1800 a_n26495_12604# VDD COMP13 VDD pmos
Xpmos_1811 a_n42003_2789# VDD a_n41856_2570# VDD pmos
Xpmos_1833 a_n46369_6494# VDD VDD a_n46516_6713# pmos
Xpmos_1844 a_n41856_5186# VDD VDD a_n42003_5405# pmos
Xpmos_1822 a_n45017_1481# VDD a_n44870_1262# VDD pmos
Xpmos_1888 a_n52543_8021# VDD a_n52396_7802# VDD pmos
Xpmos_1866 a_n48021_4097# VDD a_n47874_3878# VDD pmos
Xpmos_1877 a_n52543_4097# VDD a_n52396_3878# VDD pmos
Xpmos_1855 a_n46516_1481# VDD a_n46369_1262# VDD pmos
Xpmos_1899 a_n49383_6494# VDD VDD a_n49530_6713# pmos
Xnmos$5_3 VEVAL VSS m1_n35418_n28774# VSS nmos$5
Xnmos$2_1201 WL_22 VSS a_n79497_n1354# SL_1 nmos$2
Xnmos$2_1223 WL_21 VSS SL_3N a_n76630_173# nmos$2
Xnmos$2_1212 a_n77674_n1365# VSS ML_22 m1_n77577_n1157# nmos$2
Xnmos$2_1245 a_n74661_n2673# VSS ML_23 m1_n74564_n2465# nmos$2
Xnmos$2_1234 WL_23 VSS SL_1N a_n79644_n2742# nmos$2
Xnmos$2_1278 WL_25 VSS a_n73470_n5278# SL_5 nmos$2
Xnmos$2_1256 a_n70603_n5358# VSS a_n70142_n5289# SL_7N nmos$2
Xnmos$2_1267 a_n67452_n3970# VSS SL_9 a_n67138_n3981# nmos$2
Xnmos$2_1289 a_n71961_n3970# VSS SL_6 a_n71647_n3981# nmos$2
Xpmos_1107 a_n72108_8021# VDD a_n71961_7802# VDD pmos
Xpmos_1118 a_n70456_5186# VDD VDD a_n70603_5405# pmos
Xpmos_1129 a_n76483_1262# VDD VDD a_n76630_1481# pmos
Xnmos_1016 a_n52396_11726# VSS a_n52543_11945# VSS nmos
Xnmos_1005 a_n47874_9110# VSS a_n48021_9329# VSS nmos
Xnmos_1027 a_n49383_15650# VSS a_n49530_15869# VSS nmos
Xnmos_1049 a_n46369_14342# VSS a_n46516_14561# VSS nmos
Xnmos_1038 a_n43365_9110# VSS a_n43512_9329# VSS nmos
Xnmos_590 a_n73470_6494# VSS a_n73617_6713# VSS nmos
Xnmos$3_1009 a_n34471_22409# VSS VSS a_n34324_22190# nmos$3
Xnmos$2_3170 a_n81002_22190# VSS SL_0 a_n80688_22179# nmos$2
Xnmos$2_3181 WL_3 VSS a_n81002_23498# SL_0 nmos$2
Xnmos$2_3192 WL_5 VSS SL_3N a_n76630_21101# nmos$2
Xnmos$3_570 a_n69104_10637# VSS VSS a_n68957_10418# nmos$3
Xnmos$3_581 a_n73617_14561# VSS VSS a_n73470_14342# nmos$3
Xnmos$3_592 a_n69104_13253# VSS VSS a_n68957_13034# nmos$3
Xnmos$2_2491 a_n73156_6483# VSS ML_16 m1_n73059_6691# nmos$2
Xnmos$2_2480 a_n71647_5175# VSS ML_17 m1_n71550_5383# nmos$2
Xnmos$2_1790 a_n59602_n5289# VSS ML_25 m1_n59505_n5081# nmos$2
Xpmos_2331 a_n26495_31298# VDD VDD m1_n26796_31310# pmos
Xpmos_2320 a_n26151_28422# VDD VDD a_n26495_28422# pmos
Xpmos_2353 a_n40351_5186# VDD VDD a_n40498_5405# pmos
Xpmos_2364 a_n27618_1100# VDD VDD m1_n27919_1112# pmos
Xpmos_2342 a_n40351_1262# VDD VDD a_n40498_1481# pmos
Xpmos_1663 a_n26495_6852# VDD VDD m1_n26796_6864# pmos
Xpmos_1652 a_n27618_5414# VDD VDD m1_n27919_5426# pmos
Xpmos_1630 a_n26495_2538# VDD VDD m1_n26796_2550# pmos
Xpmos_1641 ML_20 VDD a_n28485_2636# VDD pmos
Xpmos_801 a_n60063_n6666# VDD a_n59916_n6586# VDD pmos
Xpmos_1696 a_n38843_5186# VDD VDD a_n38990_5405# pmos
Xpmos_1674 a_n35829_3878# VDD VDD a_n35976_4097# pmos
Xpmos_1685 a_n38843_3878# VDD VDD a_n38990_4097# pmos
Xpmos_823 a_n57062_173# VDD a_n56915_n46# VDD pmos
Xpmos_834 a_n56915_n1354# VDD VDD a_n57062_n1434# pmos
Xpmos_812 a_n58411_n1354# VDD VDD a_n58558_n1434# pmos
Xpmos_845 a_n61425_n2662# VDD VDD a_n61572_n2742# pmos
Xpmos_878 a_n58411_5186# VDD VDD a_n58558_5405# pmos
Xpmos_867 a_n59916_2570# VDD VDD a_n60063_2789# pmos
Xpmos_856 a_n56915_1262# VDD VDD a_n57062_1481# pmos
Xpmos_889 a_n58558_6713# VDD a_n58411_6494# VDD pmos
Xnmos$3_0 a_n34471_n29051# VSS VSS a_n34324_n28971# nmos$3
Xnmos$5_802 VEVAL VSS m1_n41445_4075# VSS nmos$5
Xnmos$5_813 VEVAL VSS m1_n45958_6691# VSS nmos$5
Xnmos$5_824 VEVAL VSS m1_n42954_4075# VSS nmos$5
Xnmos$5_835 VEVAL VSS m1_n50477_1459# VSS nmos$5
Xnmos$5_868 VEVAL VSS m1_n51985_15847# VSS nmos$5
Xnmos$5_857 VEVAL VSS m1_n47463_11923# VSS nmos$5
Xnmos$5_879 VEVAL VSS m1_n41445_10615# VSS nmos$5
Xnmos$5_846 VEVAL VSS m1_n47463_5383# VSS nmos$5
Xnmos$2_1020 WL_31 VSS SL_3N a_n76630_n13206# nmos$2
Xnmos$2_1031 WL_30 VSS a_n76483_n11818# SL_3 nmos$2
Xnmos$2_1053 a_n79644_n13206# VSS a_n79183_n13137# SL_1N nmos$2
Xnmos$2_1042 a_n76630_n10590# VSS a_n76169_n10521# SL_3N nmos$2
Xnmos$2_1064 a_n80688_n10521# VSS ML_29 m1_n80591_n10313# nmos$2
Xnmos$2_1075 a_n79183_n10521# VSS ML_29 m1_n79086_n10313# nmos$2
Xnmos$2_1086 a_n79644_n9282# VSS a_n79183_n9213# SL_1N nmos$2
Xnmos$2_1097 a_n81149_n7974# VSS a_n80688_n7905# SL_0N nmos$2
Xpmos_108 a_n46516_n7974# VDD a_n46369_n7894# VDD pmos
Xpmos_119 a_n47874_n5278# VDD VDD a_n48021_n5358# pmos
Xpmos_2150 a_n52543_27641# VDD a_n52396_27422# VDD pmos
Xpmos_2161 a_n43365_24806# VDD VDD a_n43512_25025# pmos
Xpmos_2172 a_n44870_24806# VDD VDD a_n45017_25025# pmos
Xpmos_1460 a_n71961_26114# VDD VDD a_n72108_26333# pmos
Xpmos_2194 a_n26495_19794# VDD VDD m1_n26796_19806# pmos
Xpmos_1471 a_n56915_18266# VDD VDD a_n57062_18485# pmos
Xpmos_2183 a_n26495_16918# VDD VDD m1_n26796_16930# pmos
Xpmos_620 a_n73470_n3970# VDD VDD a_n73617_n4050# pmos
Xpmos_1493 a_n58411_20882# VDD VDD a_n58558_21101# pmos
Xpmos_1482 a_n60063_18485# VDD a_n59916_18266# VDD pmos
Xpmos_631 a_n73617_173# VDD a_n73470_n46# VDD pmos
Xpmos_642 a_n70456_n2662# VDD VDD a_n70603_n2742# pmos
Xpmos_653 a_n55410_n13126# VDD VDD a_n55557_n13206# pmos
Xpmos_664 a_n59916_n11818# VDD VDD a_n60063_n11898# pmos
Xpmos_675 a_n60063_n10590# VDD a_n59916_n10510# VDD pmos
Xpmos_686 a_n55410_n9202# VDD VDD a_n55557_n9282# pmos
Xnmos$2_4607 a_n46055_23487# VSS ML_3 m1_n45958_23695# nmos$2
Xnmos$2_4629 a_n40351_20882# VSS SL_27 a_n40037_20871# nmos$2
Xnmos$2_4618 a_n44556_20871# VSS ML_5 m1_n44459_21079# nmos$2
Xpmos_697 a_n61572_n13206# VDD a_n61425_n13126# VDD pmos
Xnmos$2_3928 WL_12 VSS a_n38843_11726# SL_28 nmos$2
Xnmos$2_3906 WL_13 VSS a_n37338_10418# SL_29 nmos$2
Xnmos$2_3917 WL_14 VSS SL_28N a_n38990_9329# nmos$2
Xnmos$5_109 VEVAL VSS m1_n42954_n1157# VSS nmos$5
Xnmos$2_3939 WL_11 VSS a_n37338_13034# SL_29 nmos$2
Xnmos$2_827 a_n62616_n28982# VSS a_n32313_n28669# m1_n62519_n28774# nmos$2
Xnmos$2_816 WL VSS a_n55410_n28971# PSL_17 nmos$2
Xnmos$2_805 WL VSS PSL_17N a_n55557_n29051# nmos$2
Xnmos$2_838 a_n67599_n29051# VSS a_n67138_n28982# PSL_9N nmos$2
Xnmos$2_849 WL VSS a_n65943_n28971# PSL_10 nmos$2
Xnmos$5_610 VEVAL VSS m1_n70045_23695# VSS nmos$5
Xnmos$5_654 VEVAL VSS m1_n79086_27619# VSS nmos$5
Xnmos$5_643 VEVAL VSS m1_n76072_25003# VSS nmos$5
Xnmos$5_632 VEVAL VSS m1_n79086_23695# VSS nmos$5
Xnmos$5_621 VEVAL VSS m1_n79086_17155# VSS nmos$5
Xnmos$5_665 VEVAL VSS m1_n73059_27619# VSS nmos$5
Xnmos$5_687 VEVAL VSS m1_n54999_21079# VSS nmos$5
Xnmos$5_676 VEVAL VSS m1_n58000_17155# VSS nmos$5
Xnmos$5_698 VEVAL VSS m1_n61014_19771# VSS nmos$5
Xnmos$3_20 a_n45017_n13206# VSS VSS a_n44870_n13126# nmos$3
Xnmos$3_31 a_n40498_n9282# VSS VSS a_n40351_n9202# nmos$3
Xnmos$3_42 a_n46516_n10590# VSS VSS a_n46369_n10510# nmos$3
Xnmos$3_53 a_n52543_n9282# VSS VSS a_n52396_n9202# nmos$3
Xnmos$3_64 a_n48021_n6666# VSS VSS a_n47874_n6586# nmos$3
Xnmos$3_86 a_n48021_n1434# VSS VSS a_n47874_n1354# nmos$3
Xnmos$3_97 a_n45017_n5358# VSS VSS a_n44870_n5278# nmos$3
Xnmos$3_75 a_n52543_n4050# VSS VSS a_n52396_n3970# nmos$3
Xnmos$2_5116 WL_0 VSS a_n35829_27422# SL_30 nmos$2
Xnmos$2_5105 a_n37024_26103# VSS ML_1 m1_n36927_26311# nmos$2
Xpmos_1290 a_n70603_14561# VDD a_n70456_14342# VDD pmos
Xpmos_450 a_n67599_n11898# VDD a_n67452_n11818# VDD pmos
Xpmos_461 a_n73470_n13126# VDD VDD a_n73617_n13206# pmos
Xnmos$2_4404 a_n43051_10407# VSS ML_13 m1_n42954_10615# nmos$2
Xnmos$2_5138 a_n35976_1481# VSS a_n35515_1251# SL_30N nmos$2
Xnmos$2_5127 WL_20 VSS a_n38843_1262# SL_28 nmos$2
Xnmos$2_5149 a_n77988_1262# VSS SL_2 a_n77674_1251# nmos$2
Xpmos_494 a_n76483_n13126# VDD VDD a_n76630_n13206# pmos
Xpmos_483 a_n70603_n9282# VDD a_n70456_n9202# VDD pmos
Xpmos_472 a_n73617_n7974# VDD a_n73470_n7894# VDD pmos
Xnmos$2_3703 WL_1 VSS a_n65943_26114# SL_10 nmos$2
Xnmos$2_4437 a_n43051_14331# VSS ML_10 m1_n42954_14539# nmos$2
Xnmos$2_4448 WL_10 VSS a_n44870_14342# SL_24 nmos$2
Xnmos$2_4426 a_n46516_11945# VSS a_n46055_11715# SL_23N nmos$2
Xnmos$2_4415 WL_14 VSS SL_23N a_n46516_9329# nmos$2
Xnmos$2_3725 WL_0 VSS SL_16N a_n57062_27641# nmos$2
Xnmos$2_3736 a_n55410_26114# VSS SL_17 a_n55096_26103# nmos$2
Xnmos$2_3714 a_n55557_25025# VSS a_n55096_24795# SL_17N nmos$2
Xnmos$2_4459 WL_9 VSS a_n44870_15650# SL_24 nmos$2
Xnmos$2_3758 a_n59602_27411# VSS ML_0 m1_n59505_27619# nmos$2
Xnmos$2_3769 a_n58097_26103# VSS ML_1 m1_n58000_26311# nmos$2
Xnmos$2_3747 a_n58097_24795# VSS ML_2 m1_n58000_25003# nmos$2
Xnmos$2_602 WL_30 VSS SL_31N a_n34471_n11898# nmos$2
Xnmos$1_112 a_n28089_29366# VSS a_n27274_29860# m1_n28364_29783# nmos$1
Xnmos$1_101 OUTP VSS a_n26151_21232# a_n27618_21232# nmos$1
Xnmos$2_613 a_n38843_n13126# VSS SL_28 a_n38529_n13137# nmos$2
Xnmos$2_624 a_n38843_n10510# VSS SL_28 a_n38529_n10521# nmos$2
Xnmos$2_635 a_n37024_n10521# VSS ML_29 m1_n36927_n10313# nmos$2
Xnmos$2_646 a_n38843_n9202# VSS SL_28 a_n38529_n9213# nmos$2
Xnmos$1_123 a_n28089_27928# VSS a_n27274_28422# m1_n28364_28345# nmos$1
Xnmos$2_679 a_n35829_n13126# VSS SL_30 a_n35515_n13137# nmos$2
Xnmos$2_657 a_n37485_n7974# VSS a_n37024_n7905# SL_29N nmos$2
Xnmos$2_668 a_n35515_n7905# VSS ML_27 m1_n35418_n7697# nmos$2
Xnmos$2_4960 WL_6 VSS SL_30N a_n35976_19793# nmos$2
Xnmos$2_4993 a_n37338_19574# VSS SL_29 a_n37024_19563# nmos$2
Xnmos$2_4971 a_n37485_17177# VSS a_n37024_16947# SL_29N nmos$2
Xnmos$2_4982 WL_8 VSS SL_28N a_n38990_17177# nmos$2
Xnmos$5_440 VEVAL VSS m1_n67041_13231# VSS nmos$5
Xnmos$5_462 VEVAL VSS m1_n58000_10615# VSS nmos$5
Xnmos$5_451 VEVAL VSS m1_n64027_9307# VSS nmos$5
Xnmos$5_473 VEVAL VSS m1_n58000_15847# VSS nmos$5
Xnmos$5_495 VEVAL VSS m1_n73059_5383# VSS nmos$5
Xnmos$5_484 VEVAL VSS m1_n70045_4075# VSS nmos$5
Xpmos$1_16 a_n27990_n9846# VDD m1_n27919_n10392# a_n27274_n10404# pmos$1
Xpmos$1_27 OUTP VDD a_n27274_n4652# m1_n28364_n4729# pmos$1
Xpmos$1_49 OUTP VDD a_n27274_5414# m1_n28364_5337# pmos$1
Xpmos$1_38 a_n27990_220# VDD a_n26151_n338# a_n27618_n338# pmos$1
Xnmos_408 a_n67452_n13126# VSS a_n67599_n13206# VSS nmos
Xnmos_419 a_n61425_n9202# VSS a_n61572_n9282# VSS nmos
Xnmos$2_2309 WL_12 VSS SL_16N a_n57062_11945# nmos$2
Xnmos$2_1608 a_n65943_n7894# VSS SL_10 a_n65629_n7905# nmos$2
Xnmos$2_1619 a_n65629_n7905# VSS ML_27 m1_n65532_n7697# nmos$2
Xnmos_920 a_n26495_9728# VSS m1_n26796_9740# VSS nmos
Xnmos_953 a_n28485_15578# VSS VSS m1_n28364_15403# nmos
Xnmos_931 a_n26495_12604# VSS VSS COMP13 nmos
Xnmos_942 ML_12 VSS VSS a_n28485_14140# nmos
Xnmos$2_4223 WL_15 VSS SL_21N a_n49530_8021# nmos$2
Xnmos$2_4201 a_n47874_5186# VSS SL_22 a_n47560_5175# nmos$2
Xnmos$2_4212 a_n49069_5175# VSS ML_17 m1_n48972_5383# nmos$2
Xpmos_280 a_n37485_n13206# VDD a_n37338_n13126# VDD pmos
Xpmos_291 a_n37338_n7894# VDD VDD a_n37485_n7974# pmos
Xnmos$2_3500 a_n56915_22190# VSS SL_16 a_n56601_22179# nmos$2
Xnmos$2_3511 a_n61572_18485# VSS a_n61111_18255# SL_13N nmos$2
Xnmos$2_4256 a_n49530_11945# VSS a_n49069_11715# SL_21N nmos$2
Xnmos$2_4245 WL_13 VSS a_n49383_10418# SL_21 nmos$2
Xnmos$2_4234 WL_14 VSS a_n46369_9110# SL_23 nmos$2
Xnmos_975 a_n41856_5186# VSS a_n42003_5405# VSS nmos
Xnmos_986 a_n53901_3878# VSS a_n54048_4097# VSS nmos
Xnmos_964 a_n44870_2570# VSS a_n45017_2789# VSS nmos
Xnmos$3_911 a_n42003_19793# VSS VSS a_n41856_19574# nmos$3
Xnmos$2_3533 a_n61425_19574# VSS SL_13 a_n61111_19563# nmos$2
Xnmos$2_3522 a_n62616_16947# VSS ML_8 m1_n62519_17155# nmos$2
Xnmos$2_3544 a_n66090_17177# VSS a_n65629_16947# SL_10N nmos$2
Xnmos$3_900 a_n43512_15869# VSS VSS a_n43365_15650# nmos$3
Xnmos$2_4289 a_n50574_11715# VSS ML_12 m1_n50477_11923# nmos$2
Xnmos$2_4278 a_n52396_10418# VSS SL_19 a_n52082_10407# nmos$2
Xnmos$2_4267 WL_14 VSS a_n50888_9110# SL_20 nmos$2
Xnmos$2_2810 a_n68957_9110# VSS SL_8 a_n68643_9099# nmos$2
Xnmos_997 a_n49383_5186# VSS a_n49530_5405# VSS nmos
Xnmos$3_922 a_n45017_21101# VSS VSS a_n44870_20882# nmos$3
Xnmos$2_3577 WL_4 VSS SL_10N a_n66090_22409# nmos$2
Xnmos$2_3588 a_n67599_22409# VSS a_n67138_22179# SL_9N nmos$2
Xnmos$3_944 a_n52543_19793# VSS VSS a_n52396_19574# nmos$3
Xnmos$2_3566 WL_6 VSS a_n64438_19574# SL_11 nmos$2
Xnmos$3_933 a_n49530_18485# VSS VSS a_n49383_18266# nmos$3
Xnmos$2_3555 a_n67599_18485# VSS a_n67138_18255# SL_9N nmos$2
Xnmos$2_2832 WL_12 VSS a_n68957_11726# SL_8 nmos$2
Xnmos$2_2821 a_n70603_11945# VSS a_n70142_11715# SL_7N nmos$2
Xnmos$2_2843 a_n72108_9329# VSS a_n71647_9099# SL_6N nmos$2
Xnmos$2_410 WL_23 VSS SL_22N a_n48021_n2742# nmos$2
Xnmos$3_966 a_n46516_27641# VSS VSS a_n46369_27422# nmos$3
Xnmos$3_977 a_n40498_26333# VSS VSS a_n40351_26114# nmos$3
Xnmos$2_3599 WL_3 VSS SL_10N a_n66090_23717# nmos$2
Xnmos$3_955 a_n49530_21101# VSS VSS a_n49383_20882# nmos$3
Xnmos$2_2876 a_n71961_14342# VSS SL_6 a_n71647_14331# nmos$2
Xnmos$2_2865 WL_12 VSS SL_6N a_n72108_11945# nmos$2
Xnmos$2_2854 a_n75122_10637# VSS a_n74661_10407# SL_4N nmos$2
Xnmos$2_443 a_n44870_n5278# VSS SL_24 a_n44556_n5289# nmos$2
Xnmos$2_421 a_n41542_n5289# VSS ML_25 m1_n41445_n5081# nmos$2
Xnmos$2_454 a_n43365_n3970# VSS SL_25 a_n43051_n3981# nmos$2
Xnmos$2_432 WL_24 VSS SL_27N a_n40498_n4050# nmos$2
Xnmos$3_999 a_n37485_19793# VSS VSS a_n37338_19574# nmos$3
Xnmos$3_988 a_n34471_18485# VSS VSS a_n34324_18266# nmos$3
Xnmos$2_2898 a_n75122_15869# VSS a_n74661_15639# SL_4N nmos$2
Xnmos$2_2887 a_n75122_13253# VSS a_n74661_13023# SL_4N nmos$2
Xnmos$2_476 WL_21 VSS m2_n44135_352# a_n45017_173# nmos$2
Xnmos$2_487 a_n41856_n1354# VSS SL_26 a_n41542_n1365# nmos$2
Xnmos$2_465 WL_22 VSS a_n44870_n1354# SL_24 nmos$2
Xnmos$2_498 WL_21 VSS a_n40351_n46# SL_27 nmos$2
Xnmos$2_4790 WL_3 VSS a_n46369_23498# SL_23 nmos$2
Xnmos$5_270 VEVAL VSS m1_n68546_n2465# VSS nmos$5
Xnmos$5_281 VEVAL VSS m1_n59505_n11621# VSS nmos$5
Xnmos$5_292 VEVAL VSS m1_n56504_n9005# VSS nmos$5
Xnmos_205 a_n27618_n6090# VSS m1_n27919_n6078# VSS nmos
Xnmos_238 OUTP VSS a_n27990_220# VSS nmos
Xnmos_227 a_n26495_n1776# VSS VSS COMP23 nmos
Xnmos_249 a_n40351_n7894# VSS a_n40498_n7974# VSS nmos
Xnmos_216 a_n26495_n3214# VSS m1_n26796_n3202# VSS nmos
Xnmos$2_2139 a_n62930_7802# VSS SL_12 a_n62616_7791# nmos$2
Xnmos$2_2106 WL_15 VSS a_n64438_7802# SL_11 nmos$2
Xnmos$2_2117 a_n61572_6713# VSS a_n61111_6483# SL_13N nmos$2
Xnmos$2_2128 WL_17 VSS a_n62930_5186# SL_12 nmos$2
Xnmos$3_207 a_n76630_n11898# VSS VSS a_n76483_n11818# nmos$3
Xnmos$3_218 a_n78135_n10590# VSS VSS a_n77988_n10510# nmos$3
Xnmos$3_229 a_n75122_n9282# VSS VSS a_n74975_n9202# nmos$3
Xnmos$2_1416 a_n55557_n13206# VSS a_n55096_n13137# SL_17N nmos$2
Xnmos$2_1427 WL_30 VSS a_n55410_n11818# SL_17 nmos$2
Xnmos$2_1405 a_n71647_n6597# VSS ML_26 m1_n71550_n6389# nmos$2
Xnmos$2_1449 WL_31 VSS SL_15N a_n58558_n13206# nmos$2
Xnmos$2_1438 WL_30 VSS a_n53901_n11818# SL_18 nmos$2
Xnmos_1209 a_n35829_22190# VSS a_n35976_22409# VSS nmos
Xnmos_750 a_n73470_26114# VSS a_n73617_26333# VSS nmos
Xnmos_761 a_n59916_16958# VSS a_n60063_17177# VSS nmos
Xnmos$2_4020 a_n40498_4097# VSS a_n40037_3867# SL_27N nmos$2
Xnmos$2_4031 a_n44870_2570# VSS SL_24 a_n44556_2559# nmos$2
Xnmos_772 a_n56915_22190# VSS a_n57062_22409# VSS nmos
Xnmos_794 a_n67452_22190# VSS a_n67599_22409# VSS nmos
Xnmos_783 a_n61425_19574# VSS a_n61572_19793# VSS nmos
Xnmos$2_4064 a_n46055_6483# VSS ML_16 m1_n45958_6691# nmos$2
Xnmos$2_4053 a_n43051_5175# VSS ML_17 m1_n42954_5383# nmos$2
Xnmos$2_4042 a_n45017_4097# VSS a_n44556_3867# m2_n44135_352# nmos$2
Xnmos$2_3341 a_n73617_27641# VSS a_n73156_27411# SL_5N nmos$2
Xnmos$2_3363 WL_1 VSS a_n71961_26114# SL_6 nmos$2
Xnmos$2_3352 a_n73617_26333# VSS a_n73156_26103# SL_5N nmos$2
Xnmos$2_3330 a_n71961_24806# VSS SL_6 a_n71647_24795# nmos$2
Xnmos$2_4075 WL_15 VSS m2_n44135_352# a_n45017_8021# nmos$2
Xnmos$2_4086 WL_16 VSS SL_27N a_n40498_6713# nmos$2
Xnmos$2_4097 WL_17 VSS a_n41856_5186# SL_26 nmos$2
Xnmos$3_741 a_n63077_27641# VSS VSS a_n62930_27422# nmos$3
Xnmos$3_752 a_n55557_25025# VSS VSS a_n55410_24806# nmos$3
Xnmos$3_730 a_n64585_23717# VSS VSS a_n64438_23498# nmos$3
Xnmos$2_3396 a_n55096_19563# VSS ML_6 m1_n54999_19771# nmos$2
Xnmos$2_3374 a_n55557_18485# VSS a_n55096_18255# SL_17N nmos$2
Xnmos$2_3385 a_n57062_18485# VSS a_n56601_18255# SL_16N nmos$2
Xnmos$2_2651 a_n76483_7802# VSS SL_3 a_n76169_7791# nmos$2
Xnmos$2_2640 a_n77674_5175# VSS ML_17 m1_n77577_5383# nmos$2
Xnmos$5_1051 VEVAL VSS m1_n53490_n12929# VSS nmos$5
Xnmos$5_1040 VEVAL VSS m1_n53490_n3773# VSS nmos$5
Xnmos$3_763 a_n58558_25025# VSS VSS a_n58411_24806# nmos$3
Xnmos$2_2684 WL_12 VSS a_n76483_11726# SL_3 nmos$2
Xnmos$3_785 a_n34471_10637# VSS VSS a_n34324_10418# nmos$3
Xnmos$2_2662 a_n76630_9329# VSS a_n76169_9099# SL_3N nmos$2
Xnmos$2_2673 a_n76483_9110# VSS SL_3 a_n76169_9099# nmos$2
Xnmos$3_774 a_n37485_5405# VSS VSS a_n37338_5186# nmos$3
Xnmos$2_240 a_n50574_n11829# VSS ML_30 m1_n50477_n11621# nmos$2
Xnmos$2_251 a_n51035_n9282# VSS a_n50574_n9213# SL_20N nmos$2
Xnmos$2_262 a_n52082_n7905# VSS ML_27 m1_n51985_n7697# nmos$2
Xnmos$3_796 a_n37485_14561# VSS VSS a_n37338_14342# nmos$3
Xnmos$2_2695 a_n77988_9110# VSS SL_2 a_n77674_9099# nmos$2
Xnmos$2_1972 a_n58097_5175# VSS ML_17 m1_n58000_5383# nmos$2
Xnmos$2_1983 a_n59602_5175# VSS ML_17 m1_n59505_5383# nmos$2
Xnmos$2_1961 a_n58097_3867# VSS ML_18 m1_n58000_4075# nmos$2
Xnmos$2_1950 a_n59916_2570# VSS SL_14 a_n59602_2559# nmos$2
Xnmos$2_273 WL_28 VSS SL_19N a_n52543_n9282# nmos$2
Xnmos$2_284 WL_28 VSS a_n49383_n9202# SL_21 nmos$2
Xnmos$2_295 a_n47560_n7905# VSS ML_27 m1_n47463_n7697# nmos$2
Xnmos$2_1994 WL_15 VSS SL_15N a_n58558_8021# nmos$2
Xpmos_1801 a_n26151_12604# VDD VDD a_n26495_12604# pmos
Xpmos_1812 a_n43365_2570# VDD VDD a_n43512_2789# pmos
Xpmos_1845 a_n43365_5186# VDD VDD a_n43512_5405# pmos
Xpmos_1834 a_n46369_5186# VDD VDD a_n46516_5405# pmos
Xpmos_1823 a_n45017_2789# VDD a_n44870_2570# VDD pmos
Xpmos_1878 a_n52396_3878# VDD VDD a_n52543_4097# pmos
Xpmos_1856 a_n47874_1262# VDD VDD a_n48021_1481# pmos
Xpmos_1867 a_n48021_1481# VDD a_n47874_1262# VDD pmos
Xpmos_1889 a_n53901_7802# VDD VDD a_n54048_8021# pmos
Xnmos$5_4 VEVAL VSS m1_n39940_n28774# VSS nmos$5
Xnmos$2_1202 WL_22 VSS a_n74975_n1354# SL_4 nmos$2
Xnmos$2_1213 a_n78135_173# VSS a_n77674_n57# SL_2N nmos$2
Xnmos$2_1224 a_n79183_n2673# VSS ML_23 m1_n79086_n2465# nmos$2
Xnmos$2_1235 a_n79497_n2662# VSS SL_1 a_n79183_n2673# nmos$2
Xnmos$2_1246 a_n76630_n2742# VSS a_n76169_n2673# SL_3N nmos$2
Xnmos$2_1257 a_n70456_n5278# VSS SL_7 a_n70142_n5289# nmos$2
Xnmos$2_1268 a_n68957_n3970# VSS SL_8 a_n68643_n3981# nmos$2
Xnmos$2_1279 a_n73470_n5278# VSS SL_5 a_n73156_n5289# nmos$2
Xpmos_1119 a_n70456_7802# VDD VDD a_n70603_8021# pmos
Xpmos_1108 a_n73470_7802# VDD VDD a_n73617_8021# pmos
Xnmos_1017 a_n52396_14342# VSS a_n52543_14561# VSS nmos
Xnmos_1006 a_n47874_10418# VSS a_n48021_10637# VSS nmos
Xnmos_1028 a_n47874_15650# VSS a_n48021_15869# VSS nmos
Xnmos_1039 a_n43365_11726# VSS a_n43512_11945# VSS nmos
Xnmos_591 a_n68957_6494# VSS a_n69104_6713# VSS nmos
Xnmos_580 a_n73470_3878# VSS a_n73617_4097# VSS nmos
Xnmos$2_3160 a_n79644_22409# VSS a_n79183_22179# SL_1N nmos$2
Xnmos$2_3171 WL_4 VSS SL_0N a_n81149_22409# nmos$2
Xnmos$2_3182 a_n81002_23498# VSS SL_0 a_n80688_23487# nmos$2
Xnmos$2_3193 a_n76630_21101# VSS a_n76169_20871# SL_3N nmos$2
Xnmos$3_560 a_n76630_14561# VSS VSS a_n76483_14342# nmos$3
Xnmos$3_593 a_n67599_18485# VSS VSS a_n67452_18266# nmos$3
Xnmos$3_582 a_n73617_15869# VSS VSS a_n73470_15650# nmos$3
Xnmos$3_571 a_n69104_9329# VSS VSS a_n68957_9110# nmos$3
Xnmos$2_2481 a_n71647_6483# VSS ML_16 m1_n71550_6691# nmos$2
Xnmos$2_2492 WL_16 VSS SL_4N a_n75122_6713# nmos$2
Xnmos$2_2470 a_n71647_3867# VSS ML_18 m1_n71550_4075# nmos$2
Xnmos$2_1791 a_n59916_n5278# VSS SL_14 a_n59602_n5289# nmos$2
Xnmos$2_1780 a_n55096_n3981# VSS ML_24 m1_n54999_n3773# nmos$2
Xpmos_2321 a_n27618_31298# VDD VDD m1_n27919_31310# pmos
Xpmos_2310 a_n26151_25546# VDD VDD a_n26495_25546# pmos
Xpmos_2332 a_n26495_28422# VDD COMP2 VDD pmos
Xpmos_1620 a_n61425_18266# VDD VDD a_n61572_18485# pmos
Xpmos_2354 a_n40351_3878# VDD VDD a_n40498_4097# pmos
Xpmos_2343 a_n40351_2570# VDD VDD a_n40498_2789# pmos
Xpmos_2365 a_n27274_1100# VDD VDD a_n27618_1100# pmos
Xpmos_1653 a_n27274_5414# VDD VDD a_n27618_5414# pmos
Xpmos_1631 a_n27274_3976# VDD VDD a_n27618_3976# pmos
Xpmos_1642 ML_19 VDD a_n28485_4074# VDD pmos
Xpmos_802 a_n60063_n5358# VDD a_n59916_n5278# VDD pmos
Xpmos_1664 a_n28485_6950# VDD m1_n28364_6775# VDD pmos
Xpmos_1675 a_n34471_4097# VDD a_n34324_3878# VDD pmos
Xpmos_1686 a_n38990_4097# VDD a_n38843_3878# VDD pmos
Xpmos_835 a_n56915_n46# VDD VDD a_n57062_173# pmos
Xpmos_813 a_n57062_n1434# VDD a_n56915_n1354# VDD pmos
Xpmos_824 a_n58558_n2742# VDD a_n58411_n2662# VDD pmos
Xpmos_1697 a_n38843_6494# VDD VDD a_n38990_6713# pmos
Xpmos_857 a_n56915_2570# VDD VDD a_n57062_2789# pmos
Xpmos_868 a_n59916_1262# VDD VDD a_n60063_1481# pmos
Xpmos_846 a_n61425_n46# VDD VDD a_n61572_173# pmos
Xpmos_879 a_n57062_5405# VDD a_n56915_5186# VDD pmos
Xnmos$3_1 a_n38990_n29051# VSS VSS a_n38843_n28971# nmos$3
Xnmos$5_803 VEVAL VSS m1_n39940_4075# VSS nmos$5
Xnmos$5_825 VEVAL VSS m1_n42954_7999# VSS nmos$5
Xnmos$5_814 VEVAL VSS m1_n45958_7999# VSS nmos$5
Xnmos$5_836 VEVAL VSS m1_n51985_1459# VSS nmos$5
Xnmos$5_869 VEVAL VSS m1_n50477_15847# VSS nmos$5
Xnmos$5_858 VEVAL VSS m1_n50477_10615# VSS nmos$5
Xnmos$5_847 VEVAL VSS m1_n47463_6691# VSS nmos$5
Xnmos$2_1010 WL_27 VSS a_n67452_n7894# SL_9 nmos$2
Xnmos$2_1021 a_n76630_n13206# VSS a_n76169_n13137# SL_3N nmos$2
Xnmos$2_1032 WL_29 VSS a_n76483_n10510# SL_3 nmos$2
Xnmos$2_1043 WL_29 VSS a_n74975_n10510# SL_4 nmos$2
Xnmos$2_1076 WL_30 VSS a_n77988_n11818# SL_2 nmos$2
Xnmos$2_1065 a_n80688_n11829# VSS ML_30 m1_n80591_n11621# nmos$2
Xnmos$2_1054 a_n79497_n13126# VSS SL_1 a_n79183_n13137# nmos$2
Xnmos$2_1087 a_n77988_n9202# VSS SL_2 a_n77674_n9213# nmos$2
Xnmos$2_1098 a_n81002_n7894# VSS SL_0 a_n80688_n7905# nmos$2
Xpmos_109 a_n47874_n7894# VDD VDD a_n48021_n7974# pmos
Xnmos$3_390 a_n60063_4097# VSS VSS a_n59916_3878# nmos$3
Xpmos_2140 a_n47874_26114# VDD VDD a_n48021_26333# pmos
Xpmos_2151 a_n53901_26114# VDD VDD a_n54048_26333# pmos
Xpmos_2162 a_n42003_25025# VDD a_n41856_24806# VDD pmos
Xpmos_2173 a_n46369_24806# VDD VDD a_n46516_25025# pmos
Xpmos_1461 a_n72108_26333# VDD a_n71961_26114# VDD pmos
Xpmos_1450 a_n72108_25025# VDD a_n71961_24806# VDD pmos
Xpmos_2195 a_n26495_19794# VDD COMP8 VDD pmos
Xpmos_2184 OUTP VDD VDD a_n28089_16424# pmos
Xpmos_610 a_n71961_n6586# VDD VDD a_n72108_n6666# pmos
Xpmos_1494 a_n60063_21101# VDD a_n59916_20882# VDD pmos
Xpmos_1483 a_n59916_19574# VDD VDD a_n60063_19793# pmos
Xpmos_1472 a_n55557_18485# VDD a_n55410_18266# VDD pmos
Xpmos_632 a_n71961_n46# VDD VDD a_n72108_173# pmos
Xpmos_643 a_n70603_n2742# VDD a_n70456_n2662# VDD pmos
Xpmos_621 a_n73470_n6586# VDD VDD a_n73617_n6666# pmos
Xpmos_654 a_n55557_n13206# VDD a_n55410_n13126# VDD pmos
Xpmos_665 a_n60063_n11898# VDD a_n59916_n11818# VDD pmos
Xpmos_687 a_n54048_n10590# VDD a_n53901_n10510# VDD pmos
Xpmos_676 a_n60063_n9282# VDD a_n59916_n9202# VDD pmos
Xnmos$2_4608 a_n46516_23717# VSS a_n46055_23487# SL_23N nmos$2
Xnmos$2_4619 WL_4 VSS SL_27N a_n40498_22409# nmos$2
Xpmos_698 a_n64438_n13126# VDD VDD a_n64585_n13206# pmos
Xnmos$2_3907 a_n37338_10418# VSS SL_29 a_n37024_10407# nmos$2
Xnmos$2_3918 a_n38843_9110# VSS SL_28 a_n38529_9099# nmos$2
Xnmos$2_3929 a_n37338_11726# VSS SL_29 a_n37024_11715# nmos$2
Xnmos$2_828 WL VSS PSL_10N a_n66090_n29051# nmos$2
Xnmos$2_817 a_n59602_n28982# VSS a_n32313_n28669# m1_n59505_n28774# nmos$2
Xnmos$2_806 WL VSS a_n53901_n28971# PSL_18 nmos$2
Xnmos$2_839 a_n61572_n29051# VSS a_n61111_n28982# PSL_13N nmos$2
Xnmos$5_611 VEVAL VSS m1_n68546_23695# VSS nmos$5
Xnmos$5_600 VEVAL VSS m1_n71550_21079# VSS nmos$5
Xnmos$5_644 VEVAL VSS m1_n77577_25003# VSS nmos$5
Xnmos$5_633 VEVAL VSS m1_n76072_21079# VSS nmos$5
Xnmos$5_622 VEVAL VSS m1_n79086_18463# VSS nmos$5
Xnmos$5_666 VEVAL VSS m1_n71550_27619# VSS nmos$5
Xnmos$5_655 VEVAL VSS m1_n80591_26311# VSS nmos$5
Xnmos$5_677 VEVAL VSS m1_n59505_18463# VSS nmos$5
Xnmos$5_688 VEVAL VSS m1_n54999_22387# VSS nmos$5
Xnmos$5_699 VEVAL VSS m1_n65532_17155# VSS nmos$5
Xnmos$3_10 a_n51035_n29051# VSS VSS a_n50888_n28971# nmos$3
Xnmos$3_21 a_n45017_n11898# VSS VSS a_n44870_n11818# nmos$3
Xnmos$3_32 a_n42003_n9282# VSS VSS a_n41856_n9202# nmos$3
Xnmos$3_43 a_n48021_n11898# VSS VSS a_n47874_n11818# nmos$3
Xnmos$3_65 a_n48021_n7974# VSS VSS a_n47874_n7894# nmos$3
Xnmos$3_54 a_n52543_n6666# VSS VSS a_n52396_n6586# nmos$3
Xnmos$3_87 a_n52543_n2742# VSS VSS a_n52396_n2662# nmos$3
Xnmos$3_76 a_n51035_n4050# VSS VSS a_n50888_n3970# nmos$3
Xnmos$3_98 a_n45017_n4050# VSS VSS a_n44870_n3970# nmos$3
Xpmos_1280 a_n67599_13253# VDD a_n67452_13034# VDD pmos
Xnmos$2_5106 WL_1 VSS a_n37338_26114# SL_29 nmos$2
Xpmos_1291 a_n68957_14342# VDD VDD a_n69104_14561# pmos
Xpmos_462 a_n73470_n11818# VDD VDD a_n73617_n11898# pmos
Xpmos_451 a_n69104_n13206# VDD a_n68957_n13126# VDD pmos
Xpmos_440 a_n81149_n29051# VDD a_n81002_n28971# VDD pmos
Xnmos$2_5117 a_n35829_27422# VSS SL_30 a_n35515_27411# nmos$2
Xnmos$2_4405 WL_14 VSS a_n43365_9110# SL_25 nmos$2
Xnmos$2_5139 WL_20 VSS SL_30N a_n35976_1481# nmos$2
Xnmos$2_5128 WL_20 VSS a_n37338_1262# SL_29 nmos$2
Xpmos_495 a_n77988_n13126# VDD VDD a_n78135_n13206# pmos
Xpmos_484 a_n70456_n10510# VDD VDD a_n70603_n10590# pmos
Xpmos_473 a_n72108_n7974# VDD a_n71961_n7894# VDD pmos
Xnmos$2_4438 a_n45017_14561# VSS a_n44556_14331# m2_n44135_352# nmos$2
Xnmos$2_4427 WL_12 VSS a_n44870_11726# SL_24 nmos$2
Xnmos$2_4416 a_n46516_10637# VSS a_n46055_10407# SL_23N nmos$2
Xnmos$2_3726 WL_0 VSS a_n53901_27422# SL_18 nmos$2
Xnmos$2_3737 a_n56601_26103# VSS ML_1 m1_n56504_26311# nmos$2
Xnmos$2_3704 a_n65629_26103# VSS ML_1 m1_n65532_26311# nmos$2
Xnmos$2_3715 WL_2 VSS SL_17N a_n55557_25025# nmos$2
Xnmos$2_4449 WL_11 VSS SL_23N a_n46516_13253# nmos$2
Xnmos$2_3759 WL_0 VSS a_n59916_27422# SL_14 nmos$2
Xnmos$2_3748 WL_2 VSS a_n58411_24806# SL_15 nmos$2
Xnmos$2_603 a_n34471_n11898# VSS a_n34010_n11829# SL_31N nmos$2
Xnmos$1_113 OUTP VSS m1_n27919_31310# a_n27274_31298# nmos$1
Xnmos$1_102 a_n28089_20738# VSS m1_n26796_21244# a_n26151_21232# nmos$1
Xnmos$2_614 WL_31 VSS a_n38843_n13126# SL_28 nmos$2
Xnmos$2_625 WL_29 VSS SL_28N a_n38990_n10590# nmos$2
Xnmos$2_636 WL_29 VSS a_n37338_n10510# SL_29 nmos$2
Xnmos$1_124 OUTP VSS m1_n27919_16930# a_n27274_16918# nmos$1
Xnmos$2_647 WL_28 VSS a_n38843_n9202# SL_28 nmos$2
Xnmos$2_658 a_n34471_n9282# VSS a_n34010_n9213# SL_31N nmos$2
Xnmos$2_669 WL_27 VSS SL_30N a_n35976_n7974# nmos$2
Xnmos$2_4961 WL_6 VSS SL_31N a_n34471_19793# nmos$2
Xnmos$2_4950 WL_7 VSS SL_30N a_n35976_18485# nmos$2
Xnmos$2_4994 a_n37024_20871# VSS ML_5 m1_n36927_21079# nmos$2
Xnmos$2_4972 a_n37338_16958# VSS SL_29 a_n37024_16947# nmos$2
Xnmos$2_4983 WL_8 VSS a_n38843_16958# SL_28 nmos$2
Xnmos$5_441 VEVAL VSS m1_n67041_14539# VSS nmos$5
Xnmos$5_430 VEVAL VSS m1_n62519_11923# VSS nmos$5
Xnmos$5_452 VEVAL VSS m1_n64027_10615# VSS nmos$5
Xnmos$5_474 VEVAL VSS m1_n54999_13231# VSS nmos$5
Xnmos$5_463 VEVAL VSS m1_n58000_9307# VSS nmos$5
Xnmos$5_496 VEVAL VSS m1_n73059_7999# VSS nmos$5
Xnmos$5_485 VEVAL VSS m1_n68546_4075# VSS nmos$5
Xpmos$1_17 OUTP VDD a_n27274_n10404# m1_n28364_n10481# pmos$1
Xpmos$1_28 OUTP VDD m1_n26796_n4640# a_n26151_n4652# pmos$1
Xpmos$1_39 a_n28089_n2270# VDD a_n26151_n1776# a_n27618_n1776# pmos$1
Xnmos_409 a_n67452_n11818# VSS a_n67599_n11898# VSS nmos
Xnmos$2_1609 WL_27 VSS a_n65943_n7894# SL_10 nmos$2
Xnmos_910 a_n38843_15650# VSS a_n38990_15869# VSS nmos
Xpmos_270 a_n34324_n11818# VDD VDD a_n34471_n11898# pmos
Xnmos_943 ML_11 VSS VSS a_n28485_15578# nmos
Xnmos_932 OUTP VSS a_n28089_12110# VSS nmos
Xnmos_921 a_n26151_9728# VSS a_n26495_9728# VSS nmos
Xnmos$2_4202 WL_17 VSS SL_22N a_n48021_5405# nmos$2
Xnmos$2_4213 WL_17 VSS a_n49383_5186# SL_21 nmos$2
Xpmos_281 a_n35976_n10590# VDD a_n35829_n10510# VDD pmos
Xpmos_292 a_n35976_n7974# VDD a_n35829_n7894# VDD pmos
Xnmos$2_3501 a_n56915_23498# VSS SL_16 a_n56601_23487# nmos$2
Xnmos$2_3512 WL_7 VSS SL_13N a_n61572_18485# nmos$2
Xnmos_954 a_n26495_15480# VSS m1_n26796_15492# VSS nmos
Xnmos$2_4246 a_n49069_10407# VSS ML_13 m1_n48972_10615# nmos$2
Xnmos$2_4235 WL_14 VSS a_n47874_9110# SL_22 nmos$2
Xnmos$2_4224 a_n47874_7802# VSS SL_22 a_n47560_7791# nmos$2
Xnmos_976 a_n43365_5186# VSS a_n43512_5405# VSS nmos
Xnmos_987 a_n52396_3878# VSS a_n52543_4097# VSS nmos
Xnmos_965 a_n46369_2570# VSS a_n46516_2789# VSS nmos
Xnmos$2_3534 a_n61572_19793# VSS a_n61111_19563# SL_13N nmos$2
Xnmos$2_3523 a_n63077_17177# VSS a_n62616_16947# SL_12N nmos$2
Xnmos$2_3545 WL_8 VSS SL_10N a_n66090_17177# nmos$2
Xnmos$3_901 a_n40498_14561# VSS VSS a_n40351_14342# nmos$3
Xnmos$2_4257 WL_12 VSS SL_22N a_n48021_11945# nmos$2
Xnmos$2_4268 a_n50888_9110# VSS SL_20 a_n50574_9099# nmos$2
Xnmos$2_4279 a_n54048_9329# VSS a_n53587_9099# SL_18N nmos$2
Xnmos$2_2800 WL_14 VSS SL_8N a_n69104_9329# nmos$2
Xnmos_998 a_n49383_7802# VSS a_n49530_8021# VSS nmos
Xnmos$3_923 a_n45017_23717# VSS VSS a_n44870_23498# nmos$3
Xnmos$2_3578 a_n66090_21101# VSS a_n65629_20871# SL_10N nmos$2
Xnmos$3_912 a_n40498_19793# VSS VSS a_n40351_19574# nmos$3
Xnmos$2_3567 a_n64438_19574# VSS SL_11 a_n64124_19563# nmos$2
Xnmos$3_934 a_n49530_17177# VSS VSS a_n49383_16958# nmos$3
Xnmos$2_3556 WL_8 VSS a_n65943_16958# SL_10 nmos$2
Xnmos$2_2822 WL_12 VSS SL_7N a_n70603_11945# nmos$2
Xnmos$2_2833 WL_13 VSS a_n68957_10418# SL_8 nmos$2
Xnmos$2_2811 a_n70456_10418# VSS SL_7 a_n70142_10407# nmos$2
Xnmos$2_411 a_n52082_n2673# VSS ML_23 m1_n51985_n2465# nmos$2
Xnmos$2_400 a_n54048_n2742# VSS a_n53587_n2673# SL_18N nmos$2
Xnmos$3_978 a_n42003_26333# VSS VSS a_n41856_26114# nmos$3
Xnmos$3_967 a_n48021_25025# VSS VSS a_n47874_24806# nmos$3
Xnmos$3_956 a_n49530_23717# VSS VSS a_n49383_23498# nmos$3
Xnmos$2_3589 WL_4 VSS SL_9N a_n67599_22409# nmos$2
Xnmos$3_945 a_n51035_19793# VSS VSS a_n50888_19574# nmos$3
Xnmos$2_2877 WL_11 VSS a_n71961_13034# SL_6 nmos$2
Xnmos$2_2866 WL_12 VSS a_n71961_11726# SL_6 nmos$2
Xnmos$2_2855 WL_13 VSS SL_4N a_n75122_10637# nmos$2
Xnmos$2_2844 WL_14 VSS SL_6N a_n72108_9329# nmos$2
Xnmos$2_444 a_n46055_n5289# VSS ML_25 m1_n45958_n5081# nmos$2
Xnmos$2_422 WL_25 VSS SL_25N a_n43512_n5358# nmos$2
Xnmos$2_433 a_n40351_n3970# VSS SL_27 a_n40037_n3981# nmos$2
Xnmos$3_989 a_n34471_17177# VSS VSS a_n34324_16958# nmos$3
Xnmos$2_2899 WL_9 VSS a_n71961_15650# SL_6 nmos$2
Xnmos$2_2888 a_n73617_14561# VSS a_n73156_14331# SL_5N nmos$2
Xnmos$2_477 a_n43051_n57# VSS ML_21 m1_n42954_151# nmos$2
Xnmos$2_488 a_n41542_n1365# VSS ML_22 m1_n41445_n1157# nmos$2
Xnmos$2_466 a_n46516_n1434# VSS a_n46055_n1365# SL_23N nmos$2
Xnmos$2_455 a_n43051_n3981# VSS ML_24 m1_n42954_n3773# nmos$2
Xnmos$2_499 WL_21 VSS SL_27N a_n40498_173# nmos$2
Xnmos_0 a_n38843_n28971# VSS a_n38990_n29051# VSS nmos
Xnmos$2_4791 WL_3 VSS a_n47874_23498# SL_22 nmos$2
Xnmos$2_4780 WL_5 VSS SL_21N a_n49530_21101# nmos$2
Xnmos$5_271 VEVAL VSS m1_n70045_n2465# VSS nmos$5
Xnmos$5_260 VEVAL VSS m1_n71550_n3773# VSS nmos$5
Xnmos$5_282 VEVAL VSS m1_n59505_n10313# VSS nmos$5
Xnmos$5_293 VEVAL VSS m1_n56504_n7697# VSS nmos$5
Xnmos_206 a_n27274_n6090# VSS a_n27618_n6090# VSS nmos
Xnmos_239 a_n26495_n338# VSS VSS COMP22 nmos
Xnmos_228 a_n27274_n1776# VSS a_n27618_n1776# VSS nmos
Xnmos_217 a_n26495_n3214# VSS VSS COMP24 nmos
Xpmos_90 a_n52543_n9282# VDD a_n52396_n9202# VDD pmos
Xnmos$2_2107 WL_15 VSS SL_10N a_n66090_8021# nmos$2
Xnmos$2_2118 a_n61111_6483# VSS ML_16 m1_n61014_6691# nmos$2
Xnmos$2_2129 WL_16 VSS a_n62930_6494# SL_12 nmos$2
Xnmos$3_219 a_n78135_n11898# VSS VSS a_n77988_n11818# nmos$3
Xnmos$3_208 a_n76630_n10590# VSS VSS a_n76483_n10510# nmos$3
Xnmos$2_1417 WL_31 VSS SL_17N a_n55557_n13206# nmos$2
Xnmos$2_1406 WL_26 VSS SL_6N a_n72108_n6666# nmos$2
Xnmos$2_1439 a_n53901_n11818# VSS SL_18 a_n53587_n11829# nmos$2
Xnmos$2_1428 a_n56601_n10521# VSS ML_29 m1_n56504_n10313# nmos$2
Xnmos_740 a_n70456_24806# VSS a_n70603_25025# VSS nmos
Xnmos_751 a_n73470_24806# VSS a_n73617_25025# VSS nmos
Xnmos_762 a_n59916_19574# VSS a_n60063_19793# VSS nmos
Xnmos$2_4021 a_n40351_3878# VSS SL_27 a_n40037_3867# nmos$2
Xnmos$2_4010 a_n43512_2789# VSS a_n43051_2559# SL_25N nmos$2
Xnmos$2_3320 a_n70603_26333# VSS a_n70142_26103# SL_7N nmos$2
Xnmos_795 a_n67452_23498# VSS a_n67599_23717# VSS nmos
Xnmos_773 a_n56915_20882# VSS a_n57062_21101# VSS nmos
Xnmos_784 a_n62930_19574# VSS a_n63077_19793# VSS nmos
Xnmos$2_4065 a_n46516_6713# VSS a_n46055_6483# SL_23N nmos$2
Xnmos$2_4054 WL_17 VSS a_n43365_5186# SL_25 nmos$2
Xnmos$2_4043 a_n43051_3867# VSS ML_18 m1_n42954_4075# nmos$2
Xnmos$2_4032 a_n46516_2789# VSS a_n46055_2559# SL_23N nmos$2
Xnmos$2_3342 a_n75122_27641# VSS a_n74661_27411# SL_4N nmos$2
Xnmos$2_3353 a_n75122_26333# VSS a_n74661_26103# SL_4N nmos$2
Xnmos$2_3331 WL_2 VSS a_n71961_24806# SL_6 nmos$2
Xnmos$2_4087 a_n40498_6713# VSS a_n40037_6483# SL_27N nmos$2
Xnmos$2_4098 a_n43512_6713# VSS a_n43051_6483# SL_25N nmos$2
Xnmos$2_4076 a_n44556_6483# VSS ML_16 m1_n44459_6691# nmos$2
Xnmos$3_753 a_n55557_27641# VSS VSS a_n55410_27422# nmos$3
Xnmos$3_742 a_n61572_27641# VSS VSS a_n61425_27422# nmos$3
Xnmos$5_1041 VEVAL VSS m1_n53490_26311# VSS nmos$5
Xnmos$2_3364 a_n71647_26103# VSS ML_1 m1_n71550_26311# nmos$2
Xnmos$5_1052 VEVAL VSS m1_n53490_22387# VSS nmos$5
Xnmos$3_731 a_n61572_22409# VSS VSS a_n61425_22190# nmos$3
Xnmos$2_3386 a_n56601_19563# VSS ML_6 m1_n56504_19771# nmos$2
Xnmos$2_3375 a_n53587_18255# VSS ML_7 m1_n53490_18463# nmos$2
Xnmos$3_720 a_n64585_18485# VSS VSS a_n64438_18266# nmos$3
Xnmos$2_2652 a_n76169_7791# VSS ML_15 m1_n76072_7999# nmos$2
Xnmos$2_2630 a_n74975_6494# VSS SL_4 a_n74661_6483# nmos$2
Xnmos$2_2641 WL_17 VSS a_n76483_5186# SL_3 nmos$2
Xnmos$5_1030 VEVAL VSS m1_n53490_n9005# VSS nmos$5
Xnmos$2_3397 a_n55096_18255# VSS ML_7 m1_n54999_18463# nmos$2
Xnmos$3_786 a_n34471_11945# VSS VSS a_n34324_11726# nmos$3
Xnmos$2_2685 a_n76169_11715# VSS ML_12 m1_n76072_11923# nmos$2
Xnmos$2_2663 a_n74975_10418# VSS SL_4 a_n74661_10407# nmos$2
Xnmos$2_2674 a_n76169_9099# VSS ML_14 m1_n76072_9307# nmos$2
Xnmos$3_775 a_n35976_6713# VSS VSS a_n35829_6494# nmos$3
Xnmos$3_764 a_n34471_2789# VSS VSS a_n34324_2570# nmos$3
Xnmos$2_1940 a_n55096_2559# VSS ML_19 m1_n54999_2767# nmos$2
Xnmos$2_230 a_n54048_n11898# VSS a_n53587_n11829# SL_18N nmos$2
Xnmos$2_241 WL_30 VSS SL_20N a_n51035_n11898# nmos$2
Xnmos$2_252 a_n50888_n9202# VSS SL_20 a_n50574_n9213# nmos$2
Xnmos$3_797 a_n35976_13253# VSS VSS a_n35829_13034# nmos$3
Xnmos$2_2696 WL_13 VSS SL_1N a_n79644_10637# nmos$2
Xnmos$2_1973 WL_16 VSS SL_15N a_n58558_6713# nmos$2
Xnmos$2_1962 a_n58411_3878# VSS SL_15 a_n58097_3867# nmos$2
Xnmos$2_1951 WL_19 VSS a_n59916_2570# SL_14 nmos$2
Xnmos$2_274 a_n52543_n9282# VSS a_n52082_n9213# SL_19N nmos$2
Xnmos$2_285 a_n49530_n9282# VSS a_n49069_n9213# SL_21N nmos$2
Xnmos$2_263 a_n52396_n7894# VSS SL_19 a_n52082_n7905# nmos$2
Xnmos$2_296 a_n47874_n7894# VSS SL_22 a_n47560_n7905# nmos$2
Xnmos$2_1995 a_n58097_7791# VSS ML_15 m1_n58000_7999# nmos$2
Xnmos$2_1984 WL_16 VSS SL_14N a_n60063_6713# nmos$2
Xpmos_1802 a_n26495_12604# VDD VDD m1_n26796_12616# pmos
Xpmos_1835 a_n45017_5405# VDD a_n44870_5186# VDD pmos
Xpmos_1813 a_n43365_3878# VDD VDD a_n43512_4097# pmos
Xpmos_1824 a_n46369_2570# VDD VDD a_n46516_2789# pmos
Xpmos_1846 a_n43365_6494# VDD VDD a_n43512_6713# pmos
Xpmos_1879 a_n51035_4097# VDD a_n50888_3878# VDD pmos
Xpmos_1868 a_n51035_2789# VDD a_n50888_2570# VDD pmos
Xpmos_1857 a_n49383_1262# VDD VDD a_n49530_1481# pmos
Xnmos$5_5 VEVAL VSS m1_n44459_n28774# VSS nmos$5
Xnmos$2_1214 WL_21 VSS SL_2N a_n78135_173# nmos$2
Xnmos$2_1203 a_n74661_n1365# VSS ML_22 m1_n74564_n1157# nmos$2
Xnmos$2_1225 WL_23 VSS a_n77988_n2662# SL_2 nmos$2
Xnmos$2_1236 a_n80688_n2673# VSS ML_23 m1_n80591_n2465# nmos$2
Xnmos$2_1269 WL_25 VSS a_n68957_n5278# SL_8 nmos$2
Xnmos$2_1247 WL_25 VSS SL_8N a_n69104_n5358# nmos$2
Xnmos$2_1258 a_n70603_n4050# VSS a_n70142_n3981# SL_7N nmos$2
Xpmos_1109 a_n73470_6494# VDD VDD a_n73617_6713# pmos
Xnmos_1007 a_n49383_9110# VSS a_n49530_9329# VSS nmos
Xnmos_1029 a_n50888_15650# VSS a_n51035_15869# VSS nmos
Xnmos_1018 a_n52396_13034# VSS a_n52543_13253# VSS nmos
Xnmos_570 a_n56915_15650# VSS a_n57062_15869# VSS nmos
Xnmos_592 a_n68957_5186# VSS a_n69104_5405# VSS nmos
Xnmos_581 a_n73470_2570# VSS a_n73617_2789# VSS nmos
Xnmos$2_3161 a_n77988_20882# VSS SL_2 a_n77674_20871# nmos$2
Xnmos$2_3150 a_n79497_19574# VSS SL_1 a_n79183_19563# nmos$2
Xnmos$2_3183 a_n77988_23498# VSS SL_2 a_n77674_23487# nmos$2
Xnmos$2_3194 WL_4 VSS SL_3N a_n76630_22409# nmos$2
Xnmos$2_3172 a_n81149_22409# VSS a_n80688_22179# SL_0N nmos$2
Xnmos$3_561 a_n76630_15869# VSS VSS a_n76483_15650# nmos$3
Xnmos$3_550 a_n79644_13253# VSS VSS a_n79497_13034# nmos$3
Xnmos$2_2460 a_n73156_2559# VSS ML_19 m1_n73059_2767# nmos$2
Xnmos$3_594 a_n67599_17177# VSS VSS a_n67452_16958# nmos$3
Xnmos$3_583 a_n72108_15869# VSS VSS a_n71961_15650# nmos$3
Xnmos$3_572 a_n72108_9329# VSS VSS a_n71961_9110# nmos$3
Xnmos$2_2482 WL_16 VSS SL_6N a_n72108_6713# nmos$2
Xnmos$2_2493 a_n73617_6713# VSS a_n73156_6483# SL_5N nmos$2
Xnmos$2_2471 WL_18 VSS SL_6N a_n72108_4097# nmos$2
Xnmos$2_1781 a_n58558_n5358# VSS a_n58097_n5289# SL_15N nmos$2
Xnmos$2_1770 a_n55410_n3970# VSS SL_17 a_n55096_n3981# nmos$2
Xnmos$2_1792 a_n59602_n3981# VSS ML_24 m1_n59505_n3773# nmos$2
Xpmos_2322 a_n27274_29860# VDD VDD a_n27618_29860# pmos
Xpmos_2300 a_n26495_26984# VDD VDD m1_n26796_26996# pmos
Xpmos_2311 ML_1 VDD a_n28485_29958# VDD pmos
Xpmos_2333 a_n26495_28422# VDD VDD m1_n26796_28434# pmos
Xpmos_1610 a_n59916_26114# VDD VDD a_n60063_26333# pmos
Xpmos_2344 a_n40351_18266# VDD VDD a_n40498_18485# pmos
Xpmos_2355 a_n40351_13034# VDD VDD a_n40498_13253# pmos
Xpmos_1621 a_n61425_20882# VDD VDD a_n61572_21101# pmos
Xpmos_1654 a_n28485_8388# VDD m1_n28364_8213# VDD pmos
Xpmos_1632 a_n28485_4074# VDD m1_n28364_3899# VDD pmos
Xpmos_2366 OUTP VDD VDD a_n28089_606# pmos
Xpmos_1643 ML_21 VDD a_n28485_1198# VDD pmos
Xpmos_1665 a_n27618_6852# VDD VDD m1_n27919_6864# pmos
Xpmos_1676 a_n34324_3878# VDD VDD a_n34471_4097# pmos
Xpmos_1687 a_n35976_4097# VDD a_n35829_3878# VDD pmos
Xpmos_836 a_n55557_173# VDD a_n55410_n46# VDD pmos
Xpmos_825 a_n58558_n1434# VDD a_n58411_n1354# VDD pmos
Xpmos_814 a_n57062_n2742# VDD a_n56915_n2662# VDD pmos
Xpmos_803 a_n59916_n5278# VDD VDD a_n60063_n5358# pmos
Xpmos_1698 a_n38990_6713# VDD a_n38843_6494# VDD pmos
Xpmos_858 a_n55557_4097# VDD a_n55410_3878# VDD pmos
Xpmos_869 a_n60063_2789# VDD a_n59916_2570# VDD pmos
Xpmos_847 a_n61425_n1354# VDD VDD a_n61572_n1434# pmos
Xnmos$3_2 a_n35976_n29051# VSS VSS a_n35829_n28971# nmos$3
Xnmos$5_815 VEVAL VSS m1_n44459_7999# VSS nmos$5
Xnmos$5_826 VEVAL VSS m1_n42954_6691# VSS nmos$5
Xnmos$5_804 VEVAL VSS m1_n44459_1459# VSS nmos$5
Xnmos$5_859 VEVAL VSS m1_n50477_9307# VSS nmos$5
Xnmos$5_848 VEVAL VSS m1_n48972_5383# VSS nmos$5
Xnmos$5_837 VEVAL VSS m1_n51985_2767# VSS nmos$5
Xnmos$2_1000 a_n70603_n9282# VSS a_n70142_n9213# SL_7N nmos$2
Xnmos$2_1011 a_n69104_n7974# VSS a_n68643_n7905# SL_8N nmos$2
Xnmos$2_1044 WL_30 VSS a_n74975_n11818# SL_4 nmos$2
Xnmos$2_1033 a_n76483_n11818# VSS SL_3 a_n76169_n11829# nmos$2
Xnmos$2_1022 a_n76169_n13137# VSS ML_31 m1_n76072_n12929# nmos$2
Xnmos$2_1066 a_n81002_n11818# VSS SL_0 a_n80688_n11829# nmos$2
Xnmos$2_1055 WL_31 VSS SL_1N a_n79644_n13206# nmos$2
Xnmos$2_1077 WL_29 VSS SL_1N a_n79644_n10590# nmos$2
Xnmos$2_1088 WL_28 VSS SL_1N a_n79644_n9282# nmos$2
Xnmos$2_1099 WL_27 VSS a_n81002_n7894# SL_0 nmos$2
Xnmos$2_2290 WL_13 VSS a_n53901_10418# SL_18 nmos$2
Xnmos$3_391 a_n57062_4097# VSS VSS a_n56915_3878# nmos$3
Xnmos$3_380 a_n54048_n2742# VSS VSS a_n53901_n2662# nmos$3
Xpmos_2130 a_n46516_25025# VDD a_n46369_24806# VDD pmos
Xpmos_2163 a_n43365_27422# VDD VDD a_n43512_27641# pmos
Xpmos_2152 a_n51035_27641# VDD a_n50888_27422# VDD pmos
Xpmos_2141 a_n48021_25025# VDD a_n47874_24806# VDD pmos
Xpmos_1462 a_n73470_27422# VDD VDD a_n73617_27641# pmos
Xpmos_1440 a_n70603_26333# VDD a_n70456_26114# VDD pmos
Xpmos_2174 a_n45017_25025# VDD a_n44870_24806# VDD pmos
Xpmos_1451 a_n71961_24806# VDD VDD a_n72108_25025# pmos
Xpmos_2196 a_n26151_19794# VDD VDD a_n26495_19794# pmos
Xpmos_2185 a_n26151_16918# VDD VDD a_n26495_16918# pmos
Xpmos_611 a_n74975_n5278# VDD VDD a_n75122_n5358# pmos
Xpmos_600 a_n70456_n3970# VDD VDD a_n70603_n4050# pmos
Xpmos_1495 a_n59916_20882# VDD VDD a_n60063_21101# pmos
Xpmos_1484 a_n60063_19793# VDD a_n59916_19574# VDD pmos
Xpmos_1473 a_n54048_18485# VDD a_n53901_18266# VDD pmos
Xpmos_633 a_n72108_173# VDD a_n71961_n46# VDD pmos
Xpmos_644 a_n70456_n1354# VDD VDD a_n70603_n1434# pmos
Xpmos_622 a_n71961_n2662# VDD VDD a_n72108_n2742# pmos
Xpmos_655 a_n56915_n13126# VDD VDD a_n57062_n13206# pmos
Xpmos_666 a_n57062_n11898# VDD a_n56915_n11818# VDD pmos
Xpmos_677 a_n59916_n9202# VDD VDD a_n60063_n9282# pmos
Xnmos$2_4609 WL_3 VSS SL_23N a_n46516_23717# nmos$2
Xpmos_699 a_n63077_n13206# VDD a_n62930_n13126# VDD pmos
Xpmos_688 a_n55410_n10510# VDD VDD a_n55557_n10590# pmos
Xnmos$2_3908 WL_14 VSS a_n37338_9110# SL_29 nmos$2
Xnmos$2_3919 WL_14 VSS a_n38843_9110# SL_28 nmos$2
Xnmos$2_807 a_n58411_n28971# VSS PSL_15 a_n58097_n28982# nmos$2
Xnmos$2_818 a_n53901_n28971# VSS PSL_18 a_n53587_n28982# nmos$2
Xnmos$2_829 WL VSS a_n64438_n28971# PSL_11 nmos$2
Xnmos$5_601 VEVAL VSS m1_n71550_22387# VSS nmos$5
Xnmos$5_645 VEVAL VSS m1_n77577_27619# VSS nmos$5
Xnmos$5_634 VEVAL VSS m1_n74564_21079# VSS nmos$5
Xnmos$5_612 VEVAL VSS m1_n74564_18463# VSS nmos$5
Xnmos$5_623 VEVAL VSS m1_n80591_18463# VSS nmos$5
Xnmos$5_667 VEVAL VSS m1_n71550_26311# VSS nmos$5
Xnmos$5_656 VEVAL VSS m1_n79086_26311# VSS nmos$5
Xnmos$5_678 VEVAL VSS m1_n59505_17155# VSS nmos$5
Xnmos$5_689 VEVAL VSS m1_n56504_21079# VSS nmos$5
Xnmos$3_11 a_n46516_n29051# VSS VSS a_n46369_n28971# nmos$3
Xnmos$3_22 a_n45017_n10590# VSS VSS a_n44870_n10510# nmos$3
Xnmos$3_44 a_n48021_n13206# VSS VSS a_n47874_n13126# nmos$3
Xnmos$3_55 a_n52543_n7974# VSS VSS a_n52396_n7894# nmos$3
Xnmos$3_33 a_n42003_n6666# VSS VSS a_n41856_n6586# nmos$3
Xnmos$3_77 a_n51035_n1434# VSS VSS a_n50888_n1354# nmos$3
Xnmos$3_88 a_n51035_n2742# VSS VSS a_n50888_n2662# nmos$3
Xnmos$3_66 a_n48021_n9282# VSS VSS a_n47874_n9202# nmos$3
Xnmos$3_99 a_n43512_n4050# VSS VSS a_n43365_n3970# nmos$3
Xpmos_1270 a_n72108_15869# VDD a_n71961_15650# VDD pmos
Xnmos$2_5107 a_n37485_26333# VSS a_n37024_26103# SL_29N nmos$2
Xpmos_1292 a_n69104_13253# VDD a_n68957_13034# VDD pmos
Xpmos_1281 a_n70603_13253# VDD a_n70456_13034# VDD pmos
Xpmos_452 a_n69104_n11898# VDD a_n68957_n11818# VDD pmos
Xpmos_441 a_n75122_n29051# VDD a_n74975_n28971# VDD pmos
Xpmos_430 a_n73470_n28971# VDD VDD a_n73617_n29051# pmos
Xnmos$2_5118 WL_1 VSS a_n35829_26114# SL_30 nmos$2
Xnmos$2_5129 a_n37024_1251# VSS ML_20 m1_n36927_1459# nmos$2
Xpmos_463 a_n71961_n10510# VDD VDD a_n72108_n10590# pmos
Xpmos_485 a_n70603_n10590# VDD a_n70456_n10510# VDD pmos
Xpmos_474 a_n71961_n7894# VDD VDD a_n72108_n7974# pmos
Xnmos$2_4439 a_n43365_13034# VSS SL_25 a_n43051_13023# nmos$2
Xnmos$2_4428 WL_12 VSS SL_23N a_n46516_11945# nmos$2
Xnmos$2_4406 WL_13 VSS a_n43365_10418# SL_25 nmos$2
Xnmos$2_4417 a_n46055_10407# VSS ML_13 m1_n45958_10615# nmos$2
Xpmos_496 a_n76630_n13206# VDD a_n76483_n13126# VDD pmos
Xnmos$2_3727 a_n53587_27411# VSS ML_0 m1_n53490_27619# nmos$2
Xnmos$2_3705 a_n65629_27411# VSS ML_0 m1_n65532_27619# nmos$2
Xnmos$2_3716 WL_2 VSS SL_16N a_n57062_25025# nmos$2
Xnmos_1190 a_n35829_18266# VSS a_n35976_18485# VSS nmos
Xnmos$2_3738 a_n57062_26333# VSS a_n56601_26103# SL_16N nmos$2
Xnmos$2_3749 a_n58411_24806# VSS SL_15 a_n58097_24795# nmos$2
Xnmos$1_103 a_n28089_20738# VSS a_n27274_21232# m1_n28364_21155# nmos$1
Xnmos$2_615 a_n38990_n13206# VSS a_n38529_n13137# SL_28N nmos$2
Xnmos$2_637 a_n37338_n11818# VSS SL_29 a_n37024_n11829# nmos$2
Xnmos$2_604 a_n34010_n11829# VSS ML_30 m1_n33913_n11621# nmos$2
Xnmos$2_626 a_n38990_n10590# VSS a_n38529_n10521# SL_28N nmos$2
Xnmos$1_114 a_n28089_30804# VSS a_n27274_31298# m1_n28364_31221# nmos$1
Xnmos$1_125 a_n28089_16424# VSS m1_n26796_16930# a_n26151_16918# nmos$1
Xnmos$2_659 a_n34010_n9213# VSS ML_28 m1_n33913_n9005# nmos$2
Xnmos$2_648 a_n38529_n7905# VSS ML_27 m1_n38432_n7697# nmos$2
Xnmos$2_4940 a_n34010_16947# VSS ML_8 m1_n33913_17155# nmos$2
Xnmos$2_4951 a_n34324_16958# VSS SL_31 a_n34010_16947# nmos$2
Xnmos$5_420 VEVAL VSS m1_n64027_1459# VSS nmos$5
Xnmos$2_4995 a_n37485_21101# VSS a_n37024_20871# SL_29N nmos$2
Xnmos$2_4962 a_n34010_19563# VSS ML_6 m1_n33913_19771# nmos$2
Xnmos$2_4984 WL_6 VSS SL_28N a_n38990_19793# nmos$2
Xnmos$2_4973 a_n37024_16947# VSS ML_8 m1_n36927_17155# nmos$2
Xnmos$5_442 VEVAL VSS m1_n67041_15847# VSS nmos$5
Xnmos$5_431 VEVAL VSS m1_n61014_11923# VSS nmos$5
Xnmos$5_453 VEVAL VSS m1_n64027_11923# VSS nmos$5
Xnmos$5_475 VEVAL VSS m1_n54999_14539# VSS nmos$5
Xnmos$5_464 VEVAL VSS m1_n59505_9307# VSS nmos$5
Xnmos$5_486 VEVAL VSS m1_n71550_2767# VSS nmos$5
Xnmos$5_497 VEVAL VSS m1_n71550_7999# VSS nmos$5
Xpmos$1_18 a_n27990_n9846# VDD a_n26151_n10404# a_n27618_n10404# pmos$1
Xpmos$1_29 a_n28089_n5146# VDD m1_n27919_n4640# a_n27274_n4652# pmos$1
Xnmos_911 a_n37338_15650# VSS a_n37485_15869# VSS nmos
Xnmos_900 a_n37338_9110# VSS a_n37485_9329# VSS nmos
Xpmos_260 m2_n30953_n7856# VDD m1_n28364_n10481# VDD pmos
Xnmos_944 ML_10 VSS VSS a_n28485_17016# nmos
Xnmos_933 a_n26495_12604# VSS m1_n26796_12616# VSS nmos
Xnmos_922 a_n28485_9826# VSS VSS m1_n28364_9651# nmos
Xnmos$2_4203 a_n48021_5405# VSS a_n47560_5175# SL_22N nmos$2
Xnmos$2_4214 a_n49383_5186# VSS SL_21 a_n49069_5175# nmos$2
Xpmos_271 a_n37338_n13126# VDD VDD a_n37485_n13206# pmos
Xpmos_282 a_n37338_n10510# VDD VDD a_n37485_n10590# pmos
Xpmos_293 a_n37485_n7974# VDD a_n37338_n7894# VDD pmos
Xnmos$2_3502 a_n56915_18266# VSS SL_16 a_n56601_18255# nmos$2
Xnmos_955 a_n26495_15480# VSS VSS COMP11 nmos
Xnmos$2_4236 WL_13 VSS SL_22N a_n48021_10637# nmos$2
Xnmos$2_4247 WL_14 VSS a_n49383_9110# SL_21 nmos$2
Xnmos$2_4225 WL_15 VSS SL_22N a_n48021_8021# nmos$2
Xnmos_977 a_n43365_6494# VSS a_n43512_6713# VSS nmos
Xnmos_966 a_n46369_3878# VSS a_n46516_4097# VSS nmos
Xnmos$2_3535 WL_6 VSS a_n61425_19574# SL_13 nmos$2
Xnmos$2_3524 a_n62616_18255# VSS ML_7 m1_n62519_18463# nmos$2
Xnmos$2_3513 a_n61572_17177# VSS a_n61111_16947# SL_13N nmos$2
Xnmos$2_4258 WL_12 VSS a_n46369_11726# SL_23 nmos$2
Xnmos$2_4269 WL_14 VSS SL_20N a_n51035_9329# nmos$2
Xnmos$2_2801 a_n67452_9110# VSS SL_9 a_n67138_9099# nmos$2
Xnmos_999 a_n47874_7802# VSS a_n48021_8021# VSS nmos
Xnmos_988 a_n52396_6494# VSS a_n52543_6713# VSS nmos
Xnmos$3_924 a_n43512_23717# VSS VSS a_n43365_23498# nmos$3
Xnmos$2_3579 WL_5 VSS SL_10N a_n66090_21101# nmos$2
Xnmos$3_935 a_n49530_19793# VSS VSS a_n49383_19574# nmos$3
Xnmos$2_3568 a_n66090_19793# VSS a_n65629_19563# SL_10N nmos$2
Xnmos$2_3546 a_n64124_18255# VSS ML_7 m1_n64027_18463# nmos$2
Xnmos$2_3557 WL_7 VSS SL_9N a_n67599_18485# nmos$2
Xnmos$3_913 a_n43512_17177# VSS VSS a_n43365_16958# nmos$3
Xnmos$3_902 a_n40498_13253# VSS VSS a_n40351_13034# nmos$3
Xnmos$2_2823 a_n70142_11715# VSS ML_12 m1_n70045_11923# nmos$2
Xnmos$2_2812 WL_13 VSS SL_7N a_n70603_10637# nmos$2
Xnmos$2_2834 WL_14 VSS a_n68957_9110# SL_8 nmos$2
Xnmos$2_401 a_n50574_n2673# VSS ML_23 m1_n50477_n2465# nmos$2
Xnmos$3_968 a_n48021_26333# VSS VSS a_n47874_26114# nmos$3
Xnmos$3_957 a_n46516_23717# VSS VSS a_n46369_23498# nmos$3
Xnmos$3_946 a_n51035_21101# VSS VSS a_n50888_20882# nmos$3
Xnmos$2_2867 a_n71961_11726# VSS SL_6 a_n71647_11715# nmos$2
Xnmos$2_2856 a_n73617_10637# VSS a_n73156_10407# SL_5N nmos$2
Xnmos$2_2845 a_n73156_10407# VSS ML_13 m1_n73059_10615# nmos$2
Xnmos$2_445 WL_25 VSS SL_23N a_n46516_n5358# nmos$2
Xnmos$2_434 a_n42003_n5358# VSS a_n41542_n5289# SL_26N nmos$2
Xnmos$2_412 a_n40351_n5278# VSS SL_27 a_n40037_n5289# nmos$2
Xnmos$2_423 WL_24 VSS a_n41856_n3970# SL_26 nmos$2
Xnmos$3_979 a_n42003_25025# VSS VSS a_n41856_24806# nmos$3
Xnmos$2_2878 WL_10 VSS a_n71961_14342# SL_6 nmos$2
Xnmos$2_2889 a_n73156_14331# VSS ML_10 m1_n73059_14539# nmos$2
Xnmos$2_478 a_n44556_n1365# VSS ML_22 m1_n44459_n1157# nmos$2
Xnmos$2_467 a_n46055_n1365# VSS ML_22 m1_n45958_n1157# nmos$2
Xnmos$2_456 a_n44556_n5289# VSS ML_25 m1_n44459_n5081# nmos$2
Xnmos$2_489 a_n43512_n1434# VSS a_n43051_n1365# SL_25N nmos$2
Xnmos_1 a_n31996_n28654# VSS VSS a_n31183_n28668# nmos
Xnmos$2_4792 a_n47560_23487# VSS ML_3 m1_n47463_23695# nmos$2
Xnmos$2_4770 WL_4 VSS SL_22N a_n48021_22409# nmos$2
Xnmos$2_4781 a_n49383_20882# VSS SL_21 a_n49069_20871# nmos$2
Xnmos$5_261 VEVAL VSS m1_n71550_n1157# VSS nmos$5
Xnmos$5_250 VEVAL VSS m1_n76072_n2465# VSS nmos$5
Xnmos$5_272 VEVAL VSS m1_n71550_n2465# VSS nmos$5
Xnmos$5_283 VEVAL VSS m1_n58000_n10313# VSS nmos$5
Xnmos$5_294 VEVAL VSS m1_n56504_n6389# VSS nmos$5
Xnmos$2_990 a_n71961_n7894# VSS SL_6 a_n71647_n7905# nmos$2
Xnmos_229 m2_n30953_n488# VSS VSS m1_n28364_n1853# nmos
Xnmos_207 a_n28485_n5992# VSS VSS m1_n28364_n6167# nmos
Xnmos_218 ML_26 VSS VSS a_n28485_n5992# nmos
Xpmos_80 a_n53901_n13126# VDD VDD a_n54048_n13206# pmos
Xnmos$2_2108 a_n66090_8021# VSS a_n65629_7791# SL_10N nmos$2
Xnmos$2_2119 WL_17 VSS a_n61425_5186# SL_13 nmos$2
Xnmos$3_209 a_n75122_n11898# VSS VSS a_n74975_n11818# nmos$3
Xpmos_91 a_n53901_n9202# VDD VDD a_n54048_n9282# pmos
Xnmos$2_1418 a_n53901_n13126# VSS SL_18 a_n53587_n13137# nmos$2
Xnmos$2_1407 WL_26 VSS a_n71961_n6586# SL_6 nmos$2
Xnmos$2_1429 WL_29 VSS a_n55410_n10510# SL_17 nmos$2
Xnmos_741 a_n70456_27422# VSS a_n70603_27641# VSS nmos
Xnmos_730 a_n76483_27422# VSS a_n76630_27641# VSS nmos
Xnmos_752 a_n55410_18266# VSS a_n55557_18485# VSS nmos
Xnmos$2_4011 WL_18 VSS a_n41856_3878# SL_26 nmos$2
Xnmos$2_4000 WL_19 VSS SL_26N a_n42003_2789# nmos$2
Xnmos$2_4022 a_n42003_2789# VSS a_n41542_2559# SL_26N nmos$2
Xnmos$2_3310 WL_0 VSS a_n67452_27422# SL_9 nmos$2
Xnmos_774 a_n56915_23498# VSS a_n57062_23717# VSS nmos
Xnmos_763 a_n58411_19574# VSS a_n58558_19793# VSS nmos
Xnmos_785 a_n65943_18266# VSS a_n66090_18485# VSS nmos
Xnmos$2_4055 a_n43365_6494# VSS SL_25 a_n43051_6483# nmos$2
Xnmos$2_4044 a_n44556_2559# VSS ML_19 m1_n44459_2767# nmos$2
Xnmos$2_4033 WL_19 VSS a_n44870_2570# SL_24 nmos$2
Xnmos$5_1020 VEVAL VSS m1_n36927_27619# VSS nmos$5
Xnmos$2_3343 WL_0 VSS SL_4N a_n75122_27641# nmos$2
Xnmos$2_3321 a_n68957_26114# VSS SL_8 a_n68643_26103# nmos$2
Xnmos$2_3354 WL_1 VSS SL_4N a_n75122_26333# nmos$2
Xnmos$2_3332 a_n71647_24795# VSS ML_2 m1_n71550_25003# nmos$2
Xnmos_796 a_n65943_23498# VSS a_n66090_23717# VSS nmos
Xnmos$3_710 a_n55557_22409# VSS VSS a_n55410_22190# nmos$3
Xnmos$2_4066 a_n46516_8021# VSS a_n46055_7791# SL_23N nmos$2
Xnmos$2_4088 WL_16 VSS SL_26N a_n42003_6713# nmos$2
Xnmos$2_4077 a_n44556_5175# VSS ML_17 m1_n44459_5383# nmos$2
Xnmos$2_3365 a_n73156_26103# VSS ML_1 m1_n73059_26311# nmos$2
Xnmos$3_743 a_n64585_25025# VSS VSS a_n64438_24806# nmos$3
Xnmos$3_732 a_n61572_21101# VSS VSS a_n61425_20882# nmos$3
Xnmos$2_3387 a_n57062_19793# VSS a_n56601_19563# SL_16N nmos$2
Xnmos$3_721 a_n66090_18485# VSS VSS a_n65943_18266# nmos$3
Xnmos$2_3376 WL_8 VSS a_n55410_16958# SL_17 nmos$2
Xnmos$5_1042 VEVAL VSS m1_n53490_15847# VSS nmos$5
Xnmos$2_2620 a_n79497_7802# VSS SL_1 a_n79183_7791# nmos$2
Xnmos$2_4099 WL_16 VSS a_n41856_6494# SL_26 nmos$2
Xnmos$2_2631 a_n74661_6483# VSS ML_16 m1_n74564_6691# nmos$2
Xnmos$2_2642 a_n76483_5186# VSS SL_3 a_n76169_5175# nmos$2
Xnmos$5_1053 VEVAL VSS m1_n53490_4075# VSS nmos$5
Xnmos$2_220 WL_31 VSS SL_18N a_n54048_n13206# nmos$2
Xnmos$5_1031 VEVAL VSS m1_n53490_n10313# VSS nmos$5
Xnmos$3_754 a_n54048_27641# VSS VSS a_n53901_27422# nmos$3
Xnmos$2_3398 a_n55096_16947# VSS ML_8 m1_n54999_17155# nmos$2
Xnmos$2_2664 a_n74661_10407# VSS ML_13 m1_n74564_10615# nmos$2
Xnmos$2_2675 WL_14 VSS SL_2N a_n78135_9329# nmos$2
Xnmos$2_2653 WL_15 VSS SL_2N a_n78135_8021# nmos$2
Xnmos$3_776 a_n38990_6713# VSS VSS a_n38843_6494# nmos$3
Xnmos$3_765 a_n34471_4097# VSS VSS a_n34324_3878# nmos$3
Xnmos$2_1930 a_n55410_3878# VSS SL_17 a_n55096_3867# nmos$2
Xnmos$2_242 WL_30 VSS a_n50888_n11818# SL_20 nmos$2
Xnmos$2_231 a_n52082_n10521# VSS ML_29 m1_n51985_n10313# nmos$2
Xnmos$2_253 a_n50574_n9213# VSS ML_28 m1_n50477_n9005# nmos$2
Xnmos$3_798 a_n35976_14561# VSS VSS a_n35829_14342# nmos$3
Xnmos$2_2686 a_n76483_11726# VSS SL_3 a_n76169_11715# nmos$2
Xnmos$2_2697 a_n79644_10637# VSS a_n79183_10407# SL_1N nmos$2
Xnmos$3_787 a_n37485_9329# VSS VSS a_n37338_9110# nmos$3
Xnmos$2_1974 WL_17 VSS a_n58411_5186# SL_15 nmos$2
Xnmos$2_1941 a_n55096_3867# VSS ML_18 m1_n54999_4075# nmos$2
Xnmos$2_1963 WL_18 VSS SL_15N a_n58558_4097# nmos$2
Xnmos$2_1952 a_n59602_2559# VSS ML_19 m1_n59505_2767# nmos$2
Xnmos$2_275 a_n47560_n9213# VSS ML_28 m1_n47463_n9005# nmos$2
Xnmos$2_264 a_n54048_n7974# VSS a_n53587_n7905# SL_18N nmos$2
Xnmos$2_286 a_n49530_n7974# VSS a_n49069_n7905# SL_21N nmos$2
Xnmos$2_1996 WL_15 VSS a_n56915_7802# SL_16 nmos$2
Xnmos$2_1985 a_n59916_6494# VSS SL_14 a_n59602_6483# nmos$2
Xnmos$2_297 a_n48021_n5358# VSS a_n47560_n5289# SL_22N nmos$2
Xpmos_1803 a_n27618_12604# VDD VDD m1_n27919_12616# pmos
Xpmos_1836 a_n45017_6713# VDD a_n44870_6494# VDD pmos
Xpmos_1814 a_n42003_4097# VDD a_n41856_3878# VDD pmos
Xpmos_1825 a_n46369_3878# VDD VDD a_n46516_4097# pmos
Xpmos_1847 a_n42003_6713# VDD a_n41856_6494# VDD pmos
Xpmos_1858 a_n49383_2570# VDD VDD a_n49530_2789# pmos
Xpmos_1869 a_n52396_2570# VDD VDD a_n52543_2789# pmos
Xnmos$5_6 VEVAL VSS m1_n41445_n28774# VSS nmos$5
Xnmos$2_1215 a_n77674_n57# VSS ML_21 m1_n77577_151# nmos$2
Xnmos$2_1204 a_n74975_n1354# VSS SL_4 a_n74661_n1365# nmos$2
Xnmos$2_1226 a_n77988_n2662# VSS SL_2 a_n77674_n2673# nmos$2
Xnmos$2_1237 a_n81149_n2742# VSS a_n80688_n2673# SL_0N nmos$2
Xnmos$2_1248 a_n68957_n5278# VSS SL_8 a_n68643_n5289# nmos$2
Xnmos$2_1259 a_n70142_n3981# VSS ML_24 m1_n70045_n3773# nmos$2
Xnmos_1008 a_n49383_10418# VSS a_n49530_10637# VSS nmos
Xnmos_1019 a_n53901_14342# VSS a_n54048_14561# VSS nmos
Xnmos_560 a_n58411_14342# VSS a_n58558_14561# VSS nmos
Xnmos_571 a_n55410_15650# VSS a_n55557_15869# VSS nmos
Xnmos_593 a_n70456_5186# VSS a_n70603_5405# VSS nmos
Xnmos_582 a_n71961_5186# VSS a_n72108_5405# VSS nmos
Xnmos$2_3162 a_n79183_22179# VSS ML_4 m1_n79086_22387# nmos$2
Xnmos$2_3151 WL_6 VSS SL_1N a_n79644_19793# nmos$2
Xnmos$2_3140 a_n81002_18266# VSS SL_0 a_n80688_18255# nmos$2
Xnmos$2_3184 a_n79183_23487# VSS ML_3 m1_n79086_23695# nmos$2
Xnmos$2_3195 WL_4 VSS a_n74975_22190# SL_4 nmos$2
Xnmos$2_3173 WL_4 VSS a_n81002_22190# SL_0 nmos$2
Xnmos$3_551 a_n81149_13253# VSS VSS a_n81002_13034# nmos$3
Xnmos$3_540 a_n78135_10637# VSS VSS a_n77988_10418# nmos$3
Xnmos$2_2450 a_n71647_2559# VSS ML_19 m1_n71550_2767# nmos$2
Xnmos$3_595 a_n70603_18485# VSS VSS a_n70456_18266# nmos$3
Xnmos$3_562 a_n75122_15869# VSS VSS a_n74975_15650# nmos$3
Xnmos$3_584 a_n67599_14561# VSS VSS a_n67452_14342# nmos$3
Xnmos$3_573 a_n72108_10637# VSS VSS a_n71961_10418# nmos$3
Xnmos$2_2483 a_n72108_6713# VSS a_n71647_6483# SL_6N nmos$2
Xnmos$2_2494 WL_16 VSS a_n73470_6494# SL_5 nmos$2
Xnmos$2_2461 a_n73617_4097# VSS a_n73156_3867# SL_5N nmos$2
Xnmos$2_2472 WL_18 VSS SL_5N a_n73617_4097# nmos$2
Xnmos$2_1782 a_n58097_n5289# VSS ML_25 m1_n58000_n5081# nmos$2
Xnmos$2_1760 WL_25 VSS SL_17N a_n55557_n5358# nmos$2
Xnmos$2_1771 a_n57062_n4050# VSS a_n56601_n3981# SL_16N nmos$2
Xnmos$2_1793 WL_24 VSS a_n59916_n3970# SL_14 nmos$2
Xpmos_2301 OUTP VDD VDD a_n28089_25052# pmos
Xpmos_2312 ML_2 VDD a_n28485_28520# VDD pmos
Xpmos_2334 a_n28485_31396# VDD m1_n28364_31221# VDD pmos
Xpmos_2323 a_n28485_29958# VDD m1_n28364_29783# VDD pmos
Xpmos_2356 a_n40351_27422# VDD VDD a_n40498_27641# pmos
Xpmos_1611 a_n58411_27422# VDD VDD a_n58558_27641# pmos
Xpmos_1600 a_n55410_26114# VDD VDD a_n55557_26333# pmos
Xpmos_2345 a_n40351_16958# VDD VDD a_n40498_17177# pmos
Xpmos_1622 a_n61425_22190# VDD VDD a_n61572_22409# pmos
Xpmos_1644 ML_18 VDD a_n28485_5512# VDD pmos
Xpmos_1633 a_n26495_3976# VDD COMP19 VDD pmos
Xpmos_2367 a_n26495_1100# VDD VDD m1_n26796_1112# pmos
Xpmos_1655 a_n27274_8290# VDD VDD a_n27618_8290# pmos
Xpmos_1666 a_n26495_6852# VDD COMP17 VDD pmos
Xpmos_1677 a_n37338_2570# VDD VDD a_n37485_2789# pmos
Xpmos_826 a_n58558_173# VDD a_n58411_n46# VDD pmos
Xpmos_815 a_n58411_n2662# VDD VDD a_n58558_n2742# pmos
Xpmos_804 a_n59916_n6586# VDD VDD a_n60063_n6666# pmos
Xpmos_1699 a_n38990_5405# VDD a_n38843_5186# VDD pmos
Xpmos_1688 a_n37338_3878# VDD VDD a_n37485_4097# pmos
Xpmos_859 a_n56915_3878# VDD VDD a_n57062_4097# pmos
Xpmos_837 a_n55410_n46# VDD VDD a_n55557_173# pmos
Xpmos_848 a_n61425_n3970# VDD VDD a_n61572_n4050# pmos
Xnmos$3_3 a_n37485_n29051# VSS VSS a_n37338_n28971# nmos$3
Xnmos$5_816 VEVAL VSS m1_n39940_5383# VSS nmos$5
Xnmos$5_827 VEVAL VSS m1_n42954_5383# VSS nmos$5
Xnmos$5_805 VEVAL VSS m1_n44459_2767# VSS nmos$5
Xnmos$5_849 VEVAL VSS m1_n48972_6691# VSS nmos$5
Xnmos$5_838 VEVAL VSS m1_n51985_4075# VSS nmos$5
Xnmos$2_1001 WL_28 VSS SL_7N a_n70603_n9282# nmos$2
Xnmos$2_1034 WL_30 VSS SL_2N a_n78135_n11898# nmos$2
Xnmos$2_1023 a_n76483_n13126# VSS SL_3 a_n76169_n13137# nmos$2
Xnmos$2_1012 WL_27 VSS SL_8N a_n69104_n7974# nmos$2
Xnmos$2_1067 WL_30 VSS a_n81002_n11818# SL_0 nmos$2
Xnmos$2_1056 WL_31 VSS a_n81002_n13126# SL_0 nmos$2
Xnmos$2_1078 WL_29 VSS a_n77988_n10510# SL_2 nmos$2
Xnmos$2_1045 a_n74975_n10510# VSS SL_4 a_n74661_n10521# nmos$2
Xnmos$2_1089 WL_28 VSS a_n77988_n9202# SL_2 nmos$2
Xnmos_390 a_n58411_n6586# VSS a_n58558_n6666# VSS nmos
Xnmos$2_2280 a_n61111_15639# VSS ML_9 m1_n61014_15847# nmos$2
Xnmos$2_2291 a_n53901_10418# VSS SL_18 a_n53587_10407# nmos$2
Xnmos$3_392 a_n58558_2789# VSS VSS a_n58411_2570# nmos$3
Xnmos$3_370 a_n60063_n1434# VSS VSS a_n59916_n1354# nmos$3
Xnmos$3_381 a_n55557_n2742# VSS VSS a_n55410_n2662# nmos$3
Xnmos$2_1590 WL_29 VSS a_n64438_n10510# SL_11 nmos$2
Xpmos_2131 a_n49383_24806# VDD VDD a_n49530_25025# pmos
Xpmos_2120 a_n48021_23717# VDD a_n47874_23498# VDD pmos
Xpmos_2164 a_n42003_27641# VDD a_n41856_27422# VDD pmos
Xpmos_2142 a_n48021_26333# VDD a_n47874_26114# VDD pmos
Xpmos_2153 a_n51035_26333# VDD a_n50888_26114# VDD pmos
Xpmos_1441 a_n70456_27422# VDD VDD a_n70603_27641# pmos
Xpmos_2175 a_n46369_26114# VDD VDD a_n46516_26333# pmos
Xpmos_1430 a_n78135_26333# VDD a_n77988_26114# VDD pmos
Xpmos_1452 a_n74975_24806# VDD VDD a_n75122_25025# pmos
Xpmos_2197 a_n26495_18356# VDD VDD m1_n26796_18368# pmos
Xpmos_2186 a_n26495_16918# VDD COMP10 VDD pmos
Xpmos_601 a_n70603_n4050# VDD a_n70456_n3970# VDD pmos
Xpmos_1463 a_n73470_26114# VDD VDD a_n73617_26333# pmos
Xpmos_1496 a_n59916_23498# VDD VDD a_n60063_23717# pmos
Xpmos_1474 a_n55410_18266# VDD VDD a_n55557_18485# pmos
Xpmos_1485 a_n58411_18266# VDD VDD a_n58558_18485# pmos
Xpmos_634 a_n73470_n1354# VDD VDD a_n73617_n1434# pmos
Xpmos_623 a_n72108_n2742# VDD a_n71961_n2662# VDD pmos
Xpmos_612 a_n74975_n6586# VDD VDD a_n75122_n6666# pmos
Xpmos_645 a_n70456_n46# VDD VDD a_n70603_173# pmos
Xpmos_667 a_n58411_n11818# VDD VDD a_n58558_n11898# pmos
Xpmos_656 a_n56915_n11818# VDD VDD a_n57062_n11898# pmos
Xpmos_678 a_n60063_n7974# VDD a_n59916_n7894# VDD pmos
Xpmos_689 a_n56915_n9202# VDD VDD a_n57062_n9282# pmos
Xnmos$2_3909 a_n37338_9110# VSS SL_29 a_n37024_9099# nmos$2
Xnmos$2_819 WL VSS PSL_14N a_n60063_n29051# nmos$2
Xnmos$2_808 a_n56601_n28982# VSS a_n32313_n28669# m1_n56504_n28774# nmos$2
Xnmos$1_0 OUTP VSS a_n26151_n13280# a_n27618_n13280# nmos$1
Xnmos$5_602 VEVAL VSS m1_n73059_22387# VSS nmos$5
Xnmos$5_635 VEVAL VSS m1_n76072_22387# VSS nmos$5
Xnmos$5_613 VEVAL VSS m1_n76072_18463# VSS nmos$5
Xnmos$5_624 VEVAL VSS m1_n80591_17155# VSS nmos$5
Xnmos$5_646 VEVAL VSS m1_n74564_27619# VSS nmos$5
Xnmos$5_668 VEVAL VSS m1_n73059_26311# VSS nmos$5
Xnmos$5_657 VEVAL VSS m1_n68546_25003# VSS nmos$5
Xnmos$5_679 VEVAL VSS m1_n59505_19771# VSS nmos$5
Xnmos$3_12 a_n52543_n29051# VSS VSS a_n52396_n28971# nmos$3
Xnmos$3_23 a_n43512_n11898# VSS VSS a_n43365_n11818# nmos$3
Xnmos$3_45 a_n48021_n10590# VSS VSS a_n47874_n10510# nmos$3
Xnmos$3_56 a_n51035_n7974# VSS VSS a_n50888_n7894# nmos$3
Xnmos$3_34 a_n42003_n7974# VSS VSS a_n41856_n7894# nmos$3
Xnmos$3_78 a_n52543_n1434# VSS VSS a_n52396_n1354# nmos$3
Xnmos$3_89 a_n49530_n2742# VSS VSS a_n49383_n2662# nmos$3
Xnmos$3_67 a_n46516_n5358# VSS VSS a_n46369_n5278# nmos$3
Xpmos_1271 a_n71961_15650# VDD VDD a_n72108_15869# pmos
Xpmos_1260 a_n74975_10418# VDD VDD a_n75122_10637# pmos
Xpmos_1293 a_n67599_14561# VDD a_n67452_14342# VDD pmos
Xpmos_1282 a_n70456_13034# VDD VDD a_n70603_13253# pmos
Xpmos_453 a_n71961_n13126# VDD VDD a_n72108_n13206# pmos
Xpmos_442 a_n81002_n28971# VDD VDD a_n81149_n29051# pmos
Xpmos_431 a_n70603_n29051# VDD a_n70456_n28971# VDD pmos
Xpmos_420 a_n66090_n29051# VDD a_n65943_n28971# VDD pmos
Xnmos$2_5119 a_n35829_26114# VSS SL_30 a_n35515_26103# nmos$2
Xnmos$2_5108 WL_1 VSS SL_29N a_n37485_26333# nmos$2
Xpmos_475 a_n73470_n9202# VDD VDD a_n73617_n9282# pmos
Xpmos_464 a_n72108_n9282# VDD a_n71961_n9202# VDD pmos
Xpmos_486 a_n70456_n7894# VDD VDD a_n70603_n7974# pmos
Xnmos$2_4429 WL_12 VSS m2_n44135_352# a_n45017_11945# nmos$2
Xnmos$2_4407 a_n43365_10418# VSS SL_25 a_n43051_10407# nmos$2
Xnmos$2_4418 a_n46055_9099# VSS ML_14 m1_n45958_9307# nmos$2
Xpmos_497 a_n77988_n11818# VDD VDD a_n78135_n11898# pmos
Xnmos$2_3728 a_n53901_27422# VSS SL_18 a_n53587_27411# nmos$2
Xnmos$2_3717 a_n55410_24806# VSS SL_17 a_n55096_24795# nmos$2
Xnmos$2_3706 a_n65629_24795# VSS ML_2 m1_n65532_25003# nmos$2
Xnmos_1180 a_n26495_22670# VSS m1_n26796_22682# VSS nmos
Xnmos$2_3739 a_n53901_26114# VSS SL_18 a_n53587_26103# nmos$2
Xnmos_1191 a_n35829_16958# VSS a_n35976_17177# VSS nmos
Xnmos$1_104 OUTP VSS m1_n27919_25558# a_n27274_25546# nmos$1
Xnmos$2_616 a_n38529_n13137# VSS ML_31 m1_n38432_n12929# nmos$2
Xnmos$2_627 a_n38529_n10521# VSS ML_29 m1_n38432_n10313# nmos$2
Xnmos$2_605 a_n34471_n10590# VSS a_n34010_n10521# SL_31N nmos$2
Xnmos$1_115 OUTP VSS m1_n27919_29872# a_n27274_29860# nmos$1
Xnmos$1_126 OUTP VSS a_n26151_16918# a_n27618_16918# nmos$1
Xnmos$2_638 a_n37485_n9282# VSS a_n37024_n9213# SL_29N nmos$2
Xnmos$2_649 a_n38843_n7894# VSS SL_28 a_n38529_n7905# nmos$2
Xnmos$2_4930 a_n43365_26114# VSS SL_25 a_n43051_26103# nmos$2
Xnmos$2_4941 WL_8 VSS SL_31N a_n34471_17177# nmos$2
Xnmos$2_4952 WL_8 VSS a_n34324_16958# SL_31 nmos$2
Xnmos$5_410 VEVAL VSS m1_n67041_6691# VSS nmos$5
Xnmos$2_4963 a_n34471_19793# VSS a_n34010_19563# SL_31N nmos$2
Xnmos$2_4985 a_n38990_19793# VSS a_n38529_19563# SL_28N nmos$2
Xnmos$2_4974 a_n38990_18485# VSS a_n38529_18255# SL_28N nmos$2
Xnmos$5_443 VEVAL VSS m1_n65532_15847# VSS nmos$5
Xnmos$5_432 VEVAL VSS m1_n65532_9307# VSS nmos$5
Xnmos$5_421 VEVAL VSS m1_n64027_5383# VSS nmos$5
Xnmos$2_4996 WL_5 VSS SL_29N a_n37485_21101# nmos$2
Xnmos$5_476 VEVAL VSS m1_n56504_13231# VSS nmos$5
Xnmos$5_454 VEVAL VSS m1_n64027_13231# VSS nmos$5
Xnmos$5_465 VEVAL VSS m1_n59505_10615# VSS nmos$5
Xnmos$5_487 VEVAL VSS m1_n71550_1459# VSS nmos$5
Xnmos$5_498 VEVAL VSS m1_n68546_5383# VSS nmos$5
Xpmos$1_19 OUTP VDD m1_n26796_n10392# a_n26151_n10404# pmos$1
Xnmos_901 a_n37338_10418# VSS a_n37485_10637# VSS nmos
Xpmos_1090 a_n74975_3878# VDD VDD a_n75122_4097# pmos
Xpmos_261 a_n26495_n10404# VDD VDD m1_n26796_n10392# pmos
Xpmos_250 a_n28485_n8868# VDD m1_n28364_n9043# VDD pmos
Xnmos_912 a_n34324_13034# VSS a_n34471_13253# VSS nmos
Xnmos_934 a_n26495_11166# VSS VSS COMP14 nmos
Xnmos_923 a_n27274_9728# VSS a_n27618_9728# VSS nmos
Xnmos$2_4204 a_n47560_5175# VSS ML_17 m1_n47463_5383# nmos$2
Xpmos_272 a_n35976_n13206# VDD a_n35829_n13126# VDD pmos
Xpmos_294 a_n37485_n9282# VDD a_n37338_n9202# VDD pmos
Xpmos_283 a_n35976_n9282# VDD a_n35829_n9202# VDD pmos
Xnmos$2_3503 a_n56915_16958# VSS SL_16 a_n56601_16947# nmos$2
Xnmos_945 ML_9 VSS VSS a_n28485_18454# nmos
Xnmos_956 a_n26151_15480# VSS a_n26495_15480# VSS nmos
Xnmos$2_4237 a_n48021_10637# VSS a_n47560_10407# SL_22N nmos$2
Xnmos_978 a_n43365_7802# VSS a_n43512_8021# VSS nmos
Xnmos$2_4226 WL_15 VSS a_n46369_7802# SL_23 nmos$2
Xnmos$2_4215 WL_17 VSS SL_21N a_n49530_5405# nmos$2
Xnmos_967 a_n44870_3878# VSS a_n45017_4097# VSS nmos
Xnmos$2_3536 a_n61111_19563# VSS ML_6 m1_n61014_19771# nmos$2
Xnmos$2_3514 a_n64585_18485# VSS a_n64124_18255# SL_11N nmos$2
Xnmos$2_3525 a_n64585_17177# VSS a_n64124_16947# SL_11N nmos$2
Xnmos$2_4259 a_n47560_11715# VSS ML_12 m1_n47463_11923# nmos$2
Xnmos$2_4248 a_n49530_9329# VSS a_n49069_9099# SL_21N nmos$2
Xnmos_989 a_n52396_5186# VSS a_n52543_5405# VSS nmos
Xnmos$3_925 a_n40498_22409# VSS VSS a_n40351_22190# nmos$3
Xnmos$2_3569 WL_6 VSS SL_10N a_n66090_19793# nmos$2
Xnmos$3_914 a_n43512_18485# VSS VSS a_n43365_18266# nmos$3
Xnmos$2_3558 a_n65943_18266# VSS SL_10 a_n65629_18255# nmos$2
Xnmos$2_3547 a_n64438_16958# VSS SL_11 a_n64124_16947# nmos$2
Xnmos$3_903 a_n42003_14561# VSS VSS a_n41856_14342# nmos$3
Xnmos$2_2824 a_n70456_11726# VSS SL_7 a_n70142_11715# nmos$2
Xnmos$2_2802 a_n68643_10407# VSS ML_13 m1_n68546_10615# nmos$2
Xnmos$2_2813 a_n70603_10637# VSS a_n70142_10407# SL_7N nmos$2
Xnmos$2_402 a_n47874_n2662# VSS SL_22 a_n47560_n2673# nmos$2
Xnmos$3_969 a_n48021_27641# VSS VSS a_n47874_27422# nmos$3
Xnmos$3_958 a_n48021_23717# VSS VSS a_n47874_23498# nmos$3
Xnmos$3_947 a_n51035_22409# VSS VSS a_n50888_22190# nmos$3
Xnmos$3_936 a_n46516_19793# VSS VSS a_n46369_19574# nmos$3
Xnmos$2_2868 WL_12 VSS SL_5N a_n73617_11945# nmos$2
Xnmos$2_2857 WL_12 VSS SL_4N a_n75122_11945# nmos$2
Xnmos$2_2835 a_n71961_9110# VSS SL_6 a_n71647_9099# nmos$2
Xnmos$2_2846 a_n75122_9329# VSS a_n74661_9099# SL_4N nmos$2
Xnmos$2_413 WL_25 VSS a_n40351_n5278# SL_27 nmos$2
Xnmos$2_424 a_n43512_n4050# VSS a_n43051_n3981# SL_25N nmos$2
Xnmos$2_435 a_n42003_n4050# VSS a_n41542_n3981# SL_26N nmos$2
Xnmos$2_2879 a_n71961_13034# VSS SL_6 a_n71647_13023# nmos$2
Xnmos$2_479 a_n44556_n57# VSS ML_21 m1_n44459_151# nmos$2
Xnmos$2_468 a_n46055_n57# VSS ML_21 m1_n45958_151# nmos$2
Xnmos$2_446 a_n46516_n4050# VSS a_n46055_n3981# SL_23N nmos$2
Xnmos$2_457 a_n44556_n3981# VSS ML_24 m1_n44459_n3773# nmos$2
Xnmos_2 a_n37338_n28971# VSS a_n37485_n29051# VSS nmos
Xnmos$2_4760 a_n47560_22179# VSS ML_4 m1_n47463_22387# nmos$2
Xnmos$2_4793 a_n48021_25025# VSS a_n47560_24795# SL_22N nmos$2
Xnmos$2_4782 a_n49069_23487# VSS ML_3 m1_n48972_23695# nmos$2
Xnmos$2_4771 WL_4 VSS a_n47874_22190# SL_22 nmos$2
Xnmos$5_240 VEVAL VSS m1_n80591_151# VSS nmos$5
Xnmos$5_262 VEVAL VSS m1_n73059_n1157# VSS nmos$5
Xnmos$5_251 VEVAL VSS m1_n77577_n2465# VSS nmos$5
Xnmos$5_273 VEVAL VSS m1_n54999_n12929# VSS nmos$5
Xnmos$5_284 VEVAL VSS m1_n58000_n11621# VSS nmos$5
Xnmos$5_295 VEVAL VSS m1_n54999_n7697# VSS nmos$5
Xnmos$2_991 WL_28 VSS SL_5N a_n73617_n9282# nmos$2
Xnmos$2_980 a_n73156_n7905# VSS ML_27 m1_n73059_n7697# nmos$2
Xnmos_219 ML_27 VSS VSS a_n28485_n7430# nmos
Xnmos_208 a_n28485_n4554# VSS VSS m1_n28364_n4729# nmos
Xpmos_70 a_n49530_n13206# VDD a_n49383_n13126# VDD pmos
Xpmos_81 a_n52543_n13206# VDD a_n52396_n13126# VDD pmos
Xnmos$2_2109 a_n64124_7791# VSS ML_15 m1_n64027_7999# nmos$2
Xpmos_92 a_n52543_n10590# VDD a_n52396_n10510# VDD pmos
Xnmos$2_1408 a_n71961_n6586# VSS SL_6 a_n71647_n6597# nmos$2
Xnmos$2_1419 WL_31 VSS a_n55410_n13126# SL_17 nmos$2
Xnmos_742 a_n68957_27422# VSS a_n69104_27641# VSS nmos
Xnmos_731 a_n79497_24806# VSS a_n79644_25025# VSS nmos
Xnmos_720 a_n76483_22190# VSS a_n76630_22409# VSS nmos
Xnmos_753 a_n55410_16958# VSS a_n55557_17177# VSS nmos
Xnmos$2_4012 a_n43512_4097# VSS a_n43051_3867# SL_25N nmos$2
Xnmos$2_4001 a_n40351_2570# VSS SL_27 a_n40037_2559# nmos$2
Xnmos$2_3311 a_n67452_27422# VSS SL_9 a_n67138_27411# nmos$2
Xnmos$2_3300 WL_2 VSS SL_7N a_n70603_25025# nmos$2
Xnmos_775 a_n55410_23498# VSS a_n55557_23717# VSS nmos
Xnmos_764 a_n58411_22190# VSS a_n58558_22409# VSS nmos
Xnmos_786 a_n65943_16958# VSS a_n66090_17177# VSS nmos
Xnmos$2_4056 WL_16 VSS a_n44870_6494# SL_24 nmos$2
Xnmos$2_4023 a_n42003_4097# VSS a_n41542_3867# SL_26N nmos$2
Xnmos$2_4045 a_n44556_3867# VSS ML_18 m1_n44459_4075# nmos$2
Xnmos$2_4034 a_n46516_4097# VSS a_n46055_3867# SL_23N nmos$2
Xnmos$2_3344 a_n73470_27422# VSS SL_5 a_n73156_27411# nmos$2
Xnmos$2_3322 WL_1 VSS SL_8N a_n69104_26333# nmos$2
Xnmos$5_1010 VEVAL VSS m1_n33913_23695# VSS nmos$5
Xnmos$2_3333 a_n72108_25025# VSS a_n71647_24795# SL_6N nmos$2
Xnmos$3_700 a_n60063_21101# VSS VSS a_n59916_20882# nmos$3
Xnmos_797 a_n61425_22190# VSS a_n61572_22409# VSS nmos
Xnmos$2_4078 a_n44556_7791# VSS ML_15 m1_n44459_7999# nmos$2
Xnmos$2_4067 a_n46055_7791# VSS ML_15 m1_n45958_7999# nmos$2
Xnmos$2_4089 WL_17 VSS SL_27N a_n40498_5405# nmos$2
Xnmos$5_1021 VEVAL VSS m1_n38432_26311# VSS nmos$5
Xnmos$2_3355 a_n73470_26114# VSS SL_5 a_n73156_26103# nmos$2
Xnmos$5_1054 VEVAL VSS m1_n53490_23695# VSS nmos$5
Xnmos$3_711 a_n55557_23717# VSS VSS a_n55410_23498# nmos$3
Xnmos$3_733 a_n63077_21101# VSS VSS a_n62930_20882# nmos$3
Xnmos$2_3377 WL_7 VSS SL_16N a_n57062_18485# nmos$2
Xnmos$2_3366 a_n53587_16947# VSS ML_8 m1_n53490_17155# nmos$2
Xnmos$3_722 a_n66090_17177# VSS VSS a_n65943_16958# nmos$3
Xnmos$5_1043 VEVAL VSS m1_n53490_10615# VSS nmos$5
Xnmos$2_2621 WL_15 VSS SL_1N a_n79644_8021# nmos$2
Xnmos$2_2643 a_n78135_6713# VSS a_n77674_6483# SL_2N nmos$2
Xnmos$2_2632 a_n74975_5186# VSS SL_4 a_n74661_5175# nmos$2
Xnmos$2_2610 a_n81149_5405# VSS a_n80688_5175# SL_0N nmos$2
Xnmos$2_210 WL_30 VSS SL_22N a_n48021_n11898# nmos$2
Xnmos$5_1032 VEVAL VSS m1_n53490_n7697# VSS nmos$5
Xnmos$3_744 a_n64585_26333# VSS VSS a_n64438_26114# nmos$3
Xnmos$3_755 a_n57062_25025# VSS VSS a_n56915_24806# nmos$3
Xnmos$2_3388 WL_6 VSS SL_16N a_n57062_19793# nmos$2
Xnmos$2_3399 a_n58558_18485# VSS a_n58097_18255# SL_15N nmos$2
Xnmos$2_2665 a_n74975_9110# VSS SL_4 a_n74661_9099# nmos$2
Xnmos$2_2676 a_n78135_9329# VSS a_n77674_9099# SL_2N nmos$2
Xnmos$2_2654 a_n78135_8021# VSS a_n77674_7791# SL_2N nmos$2
Xnmos$3_777 a_n38990_5405# VSS VSS a_n38843_5186# nmos$3
Xnmos$2_1931 a_n56601_3867# VSS ML_18 m1_n56504_4075# nmos$2
Xnmos$3_766 a_n37485_2789# VSS VSS a_n37338_2570# nmos$3
Xnmos$2_1920 a_n55557_2789# VSS a_n55096_2559# SL_17N nmos$2
Xnmos$2_221 a_n54048_n13206# VSS a_n53587_n13137# SL_18N nmos$2
Xnmos$2_243 a_n50888_n11818# VSS SL_20 a_n50574_n11829# nmos$2
Xnmos$2_232 WL_29 VSS a_n52396_n10510# SL_19 nmos$2
Xnmos$3_799 a_n37485_13253# VSS VSS a_n37338_13034# nmos$3
Xnmos$2_2687 a_n78135_11945# VSS a_n77674_11715# SL_2N nmos$2
Xnmos$3_788 a_n37485_10637# VSS VSS a_n37338_10418# nmos$3
Xnmos$2_2698 a_n77988_10418# VSS SL_2 a_n77674_10407# nmos$2
Xnmos$2_1964 WL_17 VSS a_n56915_5186# SL_16 nmos$2
Xnmos$2_1953 a_n60063_4097# VSS a_n59602_3867# SL_14N nmos$2
Xnmos$2_1942 WL_19 VSS a_n58411_2570# SL_15 nmos$2
Xnmos$2_254 WL_28 VSS SL_20N a_n51035_n9282# nmos$2
Xnmos$2_276 WL_28 VSS a_n47874_n9202# SL_22 nmos$2
Xnmos$2_265 WL_27 VSS SL_18N a_n54048_n7974# nmos$2
Xnmos$2_287 WL_27 VSS SL_21N a_n49530_n7974# nmos$2
Xnmos$2_1986 a_n60063_8021# VSS a_n59602_7791# SL_14N nmos$2
Xnmos$2_1975 a_n58097_6483# VSS ML_16 m1_n58000_6691# nmos$2
Xnmos$2_1997 a_n55557_5405# VSS a_n55096_5175# SL_17N nmos$2
Xnmos$2_298 a_n47560_n5289# VSS ML_25 m1_n47463_n5081# nmos$2
Xpmos_1804 a_n27274_12604# VDD VDD a_n27618_12604# pmos
Xpmos_1815 a_n40498_4097# VDD a_n40351_3878# VDD pmos
Xpmos_1826 a_n45017_4097# VDD a_n44870_3878# VDD pmos
Xpmos_1837 a_n45017_8021# VDD a_n44870_7802# VDD pmos
Xpmos_1848 a_n42003_5405# VDD a_n41856_5186# VDD pmos
Xpmos_1859 a_n49530_2789# VDD a_n49383_2570# VDD pmos
Xnmos$2_4590 a_n43051_20871# VSS ML_5 m1_n42954_21079# nmos$2
Xnmos$5_7 VEVAL VSS m1_n42954_n28774# VSS nmos$5
Xnmos$2_1216 a_n76483_n46# VSS SL_3 a_n76169_n57# nmos$2
Xnmos$2_1205 a_n76630_n1434# VSS a_n76169_n1365# SL_3N nmos$2
Xnmos$2_1227 a_n79644_n2742# VSS a_n79183_n2673# SL_1N nmos$2
Xnmos$2_1238 WL_23 VSS SL_0N a_n81149_n2742# nmos$2
Xnmos$2_1249 a_n69104_n5358# VSS a_n68643_n5289# SL_8N nmos$2
Xnmos_1009 a_n49383_11726# VSS a_n49530_11945# VSS nmos
Xnmos_561 a_n58411_13034# VSS a_n58558_13253# VSS nmos
Xnmos_550 a_n56915_10418# VSS a_n57062_10637# VSS nmos
Xnmos_594 a_n70456_6494# VSS a_n70603_6713# VSS nmos
Xnmos_583 a_n71961_6494# VSS a_n72108_6713# VSS nmos
Xnmos_572 a_n68957_2570# VSS a_n69104_2789# VSS nmos
Xnmos$2_3152 a_n79644_19793# VSS a_n79183_19563# SL_1N nmos$2
Xnmos$2_3130 a_n79644_18485# VSS a_n79183_18255# SL_1N nmos$2
Xnmos$2_3141 a_n81149_17177# VSS a_n80688_16947# SL_0N nmos$2
Xnmos$2_3185 WL_3 VSS SL_1N a_n79644_23717# nmos$2
Xnmos$2_3196 a_n74975_22190# VSS SL_4 a_n74661_22179# nmos$2
Xnmos$2_3163 WL_4 VSS SL_1N a_n79644_22409# nmos$2
Xnmos$2_3174 WL_5 VSS a_n81002_20882# SL_0 nmos$2
Xnmos$3_552 a_n79644_14561# VSS VSS a_n79497_14342# nmos$3
Xnmos$3_541 a_n81149_9329# VSS VSS a_n81002_9110# nmos$3
Xnmos$3_530 a_n76630_6713# VSS VSS a_n76483_6494# nmos$3
Xnmos$2_2440 WL_18 VSS SL_7N a_n70603_4097# nmos$2
Xnmos$2_2451 WL_19 VSS SL_6N a_n72108_2789# nmos$2
Xnmos$3_585 a_n67599_13253# VSS VSS a_n67452_13034# nmos$3
Xnmos$3_563 a_n67599_10637# VSS VSS a_n67452_10418# nmos$3
Xnmos$3_574 a_n73617_9329# VSS VSS a_n73470_9110# nmos$3
Xnmos$2_2484 a_n73470_6494# VSS SL_5 a_n73156_6483# nmos$2
Xnmos$2_2462 WL_18 VSS a_n73470_3878# SL_5 nmos$2
Xnmos$2_2473 WL_19 VSS SL_5N a_n73617_2789# nmos$2
Xnmos$3_596 a_n70603_17177# VSS VSS a_n70456_16958# nmos$3
Xnmos$2_2495 WL_17 VSS SL_4N a_n75122_5405# nmos$2
Xnmos$2_1750 WL_23 VSS a_n65943_n2662# SL_10 nmos$2
Xnmos$2_1761 a_n55557_n5358# VSS a_n55096_n5289# SL_17N nmos$2
Xnmos$2_1772 WL_24 VSS SL_16N a_n57062_n4050# nmos$2
Xnmos$2_1783 WL_25 VSS a_n58411_n5278# SL_15 nmos$2
Xnmos$2_1794 WL_24 VSS SL_14N a_n60063_n4050# nmos$2
Xpmos_2313 ML_0 VDD a_n28485_31396# VDD pmos
Xpmos_2302 a_n26495_25546# VDD VDD m1_n26796_25558# pmos
Xpmos_2324 a_n27274_31298# VDD VDD a_n27618_31298# pmos
Xpmos_1601 a_n55410_27422# VDD VDD a_n55557_27641# pmos
Xpmos_2335 a_n27274_24108# VDD VDD a_n27618_24108# pmos
Xpmos_2346 a_n40351_15650# VDD VDD a_n40498_15869# pmos
Xpmos_1612 a_n57062_27641# VDD a_n56915_27422# VDD pmos
Xpmos_1623 a_n61425_23498# VDD VDD a_n61572_23717# pmos
Xpmos_2357 a_n40351_19574# VDD VDD a_n40498_19793# pmos
Xpmos_1645 ML_17 VDD a_n28485_6950# VDD pmos
Xpmos_1634 a_n26495_3976# VDD VDD m1_n26796_3988# pmos
Xpmos_2368 a_n26151_1100# VDD VDD a_n26495_1100# pmos
Xpmos_1656 a_n27618_8290# VDD VDD m1_n27919_8302# pmos
Xpmos_1667 a_n26151_6852# VDD VDD a_n26495_6852# pmos
Xpmos_1678 a_n35976_1481# VDD a_n35829_1262# VDD pmos
Xpmos_827 a_n55410_n1354# VDD VDD a_n55557_n1434# pmos
Xpmos_816 a_n60063_n2742# VDD a_n59916_n2662# VDD pmos
Xpmos_805 a_n59916_n3970# VDD VDD a_n60063_n4050# pmos
Xpmos_1689 a_n37485_4097# VDD a_n37338_3878# VDD pmos
Xpmos_838 a_n54048_173# VDD a_n53901_n46# VDD pmos
Xpmos_849 a_n61425_n5278# VDD VDD a_n61572_n5358# pmos
Xnmos$3_4 a_n45017_n29051# VSS VSS a_n44870_n28971# nmos$3
Xnmos$5_817 VEVAL VSS m1_n39940_6691# VSS nmos$5
Xnmos$5_806 VEVAL VSS m1_n45958_2767# VSS nmos$5
Xnmos$5_839 VEVAL VSS m1_n50477_4075# VSS nmos$5
Xnmos$5_828 VEVAL VSS m1_n47463_2767# VSS nmos$5
Xnmos$2_1002 WL_28 VSS a_n70456_n9202# SL_7 nmos$2
Xnmos$2_1024 WL_31 VSS SL_2N a_n78135_n13206# nmos$2
Xnmos$2_1035 a_n78135_n10590# VSS a_n77674_n10521# SL_2N nmos$2
Xnmos$2_1013 a_n68957_n7894# VSS SL_8 a_n68643_n7905# nmos$2
Xnmos$2_1046 a_n74661_n11829# VSS ML_30 m1_n74564_n11621# nmos$2
Xnmos$2_1057 a_n81149_n13206# VSS a_n80688_n13137# SL_0N nmos$2
Xnmos$2_1068 a_n81149_n10590# VSS a_n80688_n10521# SL_0N nmos$2
Xnmos$2_1079 a_n77988_n10510# VSS SL_2 a_n77674_n10521# nmos$2
Xnmos_380 a_n58411_n13126# VSS a_n58558_n13206# VSS nmos
Xnmos_391 a_n58411_n7894# VSS a_n58558_n7974# VSS nmos
Xnmos$3_360 a_n55557_n5358# VSS VSS a_n55410_n5278# nmos$3
Xnmos$2_2281 a_n61572_15869# VSS a_n61111_15639# SL_13N nmos$2
Xnmos$2_2270 WL_10 VSS a_n62930_14342# SL_12 nmos$2
Xnmos$2_2292 a_n53901_9110# VSS SL_18 a_n53587_9099# nmos$2
Xnmos$3_393 a_n58558_4097# VSS VSS a_n58411_3878# nmos$3
Xnmos$3_371 a_n60063_173# VSS VSS a_n59916_n46# nmos$3
Xnmos$3_382 a_n57062_n2742# VSS VSS a_n56915_n2662# nmos$3
Xnmos$2_1591 WL_30 VSS SL_10N a_n66090_n11898# nmos$2
Xnmos$2_1580 WL_29 VSS a_n65943_n10510# SL_10 nmos$2
Xpmos_2121 a_n48021_21101# VDD a_n47874_20882# VDD pmos
Xpmos_2110 a_n49383_20882# VDD VDD a_n49530_21101# pmos
Xpmos_2143 a_n48021_27641# VDD a_n47874_27422# VDD pmos
Xpmos_2154 a_n52396_26114# VDD VDD a_n52543_26333# pmos
Xpmos_2132 a_n49530_25025# VDD a_n49383_24806# VDD pmos
Xpmos_1420 a_n79497_24806# VDD VDD a_n79644_25025# pmos
Xpmos_1431 a_n78135_27641# VDD a_n77988_27422# VDD pmos
Xpmos_2165 a_n42003_26333# VDD a_n41856_26114# VDD pmos
Xpmos_2176 a_n45017_26333# VDD a_n44870_26114# VDD pmos
Xpmos_1442 a_n70456_26114# VDD VDD a_n70603_26333# pmos
Xpmos_1453 a_n73617_25025# VDD a_n73470_24806# VDD pmos
Xpmos_2198 a_n26495_18356# VDD COMP9 VDD pmos
Xpmos_2187 a_n28485_17016# VDD m1_n28364_16841# VDD pmos
Xpmos_602 a_n68957_n3970# VDD VDD a_n69104_n4050# pmos
Xpmos_1464 a_n73470_24806# VDD VDD a_n73617_25025# pmos
Xpmos_1475 a_n54048_19793# VDD a_n53901_19574# VDD pmos
Xpmos_1486 a_n57062_18485# VDD a_n56915_18266# VDD pmos
Xpmos_635 a_n73470_n46# VDD VDD a_n73617_173# pmos
Xpmos_624 a_n72108_n1434# VDD a_n71961_n1354# VDD pmos
Xpmos_613 a_n73617_n6666# VDD a_n73470_n6586# VDD pmos
Xpmos_1497 a_n60063_23717# VDD a_n59916_23498# VDD pmos
Xpmos_646 a_n70603_173# VDD a_n70456_n46# VDD pmos
Xpmos_668 a_n58558_n13206# VDD a_n58411_n13126# VDD pmos
Xpmos_657 a_n55557_n11898# VDD a_n55410_n11818# VDD pmos
Xpmos_679 a_n59916_n7894# VDD VDD a_n60063_n7974# pmos
Xnmos$2_809 WL VSS a_n56915_n28971# PSL_16 nmos$2
Xnmos$1_1 OUTP VSS m1_n27919_n11830# a_n27274_n11842# nmos$1
Xnmos$5_636 VEVAL VSS m1_n74564_22387# VSS nmos$5
Xnmos$5_603 VEVAL VSS m1_n73059_21079# VSS nmos$5
Xnmos$5_625 VEVAL VSS m1_n80591_19771# VSS nmos$5
Xnmos$5_614 VEVAL VSS m1_n76072_17155# VSS nmos$5
Xnmos$5_647 VEVAL VSS m1_n76072_27619# VSS nmos$5
Xnmos$5_658 VEVAL VSS m1_n70045_25003# VSS nmos$5
Xnmos$5_669 VEVAL VSS m1_n54999_18463# VSS nmos$5
Xnmos_90 a_n53901_n2662# VSS a_n54048_n2742# VSS nmos
Xnmos$3_190 a_n72108_n9282# VSS VSS a_n71961_n9202# nmos$3
Xnmos$3_13 a_n40498_n13206# VSS VSS a_n40351_n13126# nmos$3
Xnmos$3_46 a_n51035_n13206# VSS VSS a_n50888_n13126# nmos$3
Xnmos$3_24 a_n43512_n10590# VSS VSS a_n43365_n10510# nmos$3
Xnmos$3_35 a_n40498_n6666# VSS VSS a_n40351_n6586# nmos$3
Xnmos$3_79 a_n52543_173# VSS VSS a_n52396_n46# nmos$3
Xnmos$3_57 a_n51035_n6666# VSS VSS a_n50888_n6586# nmos$3
Xnmos$3_68 a_n49530_n5358# VSS VSS a_n49383_n5278# nmos$3
Xpmos_1261 a_n72108_10637# VDD a_n71961_10418# VDD pmos
Xpmos_1250 a_n71961_9110# VDD VDD a_n72108_9329# pmos
Xpmos_410 a_n58411_n28971# VDD VDD a_n58558_n29051# pmos
Xpmos_1294 a_n68957_16958# VDD VDD a_n69104_17177# pmos
Xpmos_1283 a_n70603_15869# VDD a_n70456_15650# VDD pmos
Xpmos_1272 a_n74975_14342# VDD VDD a_n75122_14561# pmos
Xpmos_443 a_n67599_n13206# VDD a_n67452_n13126# VDD pmos
Xpmos_432 a_n70456_n28971# VDD VDD a_n70603_n29051# pmos
Xpmos_421 a_n64585_n29051# VDD a_n64438_n28971# VDD pmos
Xnmos$2_5109 a_n38529_26103# VSS ML_1 m1_n38432_26311# nmos$2
Xpmos_454 a_n72108_n13206# VDD a_n71961_n13126# VDD pmos
Xpmos_465 a_n72108_n10590# VDD a_n71961_n10510# VDD pmos
Xpmos_476 a_n73470_n7894# VDD VDD a_n73617_n7974# pmos
Xnmos$2_4408 a_n45017_10637# VSS a_n44556_10407# m2_n44135_352# nmos$2
Xnmos$2_4419 WL_14 VSS a_n44870_9110# SL_24 nmos$2
Xpmos_498 a_n76630_n11898# VDD a_n76483_n11818# VDD pmos
Xpmos_487 a_n70603_n7974# VDD a_n70456_n7894# VDD pmos
Xnmos$2_3707 a_n64438_26114# VSS SL_11 a_n64124_26103# nmos$2
Xnmos$2_3718 WL_2 VSS a_n55410_24806# SL_17 nmos$2
Xnmos_1181 a_n26151_22670# VSS a_n26495_22670# VSS nmos
Xnmos_1170 a_n26151_21232# VSS a_n26495_21232# VSS nmos
Xnmos$2_3729 WL_0 VSS SL_17N a_n55557_27641# nmos$2
Xnmos_1192 a_n35829_19574# VSS a_n35976_19793# VSS nmos
Xnmos$2_617 WL_31 VSS SL_28N a_n38990_n13206# nmos$2
Xnmos$2_628 a_n37485_n10590# VSS a_n37024_n10521# SL_29N nmos$2
Xnmos$2_606 WL_29 VSS SL_31N a_n34471_n10590# nmos$2
Xnmos$1_116 a_n28089_29366# VSS m1_n26796_29872# a_n26151_29860# nmos$1
Xnmos$1_105 a_n28089_26490# VSS a_n27274_26984# m1_n28364_26907# nmos$1
Xnmos$1_127 a_n28089_16424# VSS a_n27274_16918# m1_n28364_16841# nmos$1
Xnmos$2_639 a_n37024_n9213# VSS ML_28 m1_n36927_n9005# nmos$2
Xnmos$2_4920 a_n45017_26333# VSS a_n44556_26103# m2_n44135_352# nmos$2
Xnmos$2_4942 a_n34010_18255# VSS ML_7 m1_n33913_18463# nmos$2
Xnmos$2_4931 a_n46369_16958# VSS SL_23 a_n46055_16947# nmos$2
Xnmos$5_411 VEVAL VSS m1_n67041_5383# VSS nmos$5
Xnmos$5_400 VEVAL VSS m1_n62519_4075# VSS nmos$5
Xnmos$2_4986 a_n38843_19574# VSS SL_28 a_n38529_19563# nmos$2
Xnmos$2_4964 WL_7 VSS SL_29N a_n37485_18485# nmos$2
Xnmos$2_4953 a_n35515_16947# VSS ML_8 m1_n35418_17155# nmos$2
Xnmos$2_4975 a_n38843_16958# VSS SL_28 a_n38529_16947# nmos$2
Xnmos$5_444 VEVAL VSS m1_n61014_14539# VSS nmos$5
Xnmos$5_433 VEVAL VSS m1_n65532_10615# VSS nmos$5
Xnmos$5_422 VEVAL VSS m1_n64027_6691# VSS nmos$5
Xnmos$2_4997 a_n37338_20882# VSS SL_29 a_n37024_20871# nmos$2
Xnmos$5_455 VEVAL VSS m1_n64027_15847# VSS nmos$5
Xnmos$5_477 VEVAL VSS m1_n56504_14539# VSS nmos$5
Xnmos$5_466 VEVAL VSS m1_n59505_11923# VSS nmos$5
Xnmos$5_499 VEVAL VSS m1_n68546_6691# VSS nmos$5
Xnmos$5_488 VEVAL VSS m1_n73059_2767# VSS nmos$5
Xnmos_902 a_n38843_9110# VSS a_n38990_9329# VSS nmos
Xpmos_1080 a_n69104_4097# VDD a_n68957_3878# VDD pmos
Xpmos_1091 a_n72108_4097# VDD a_n71961_3878# VDD pmos
Xpmos_251 a_n27274_n8966# VDD VDD a_n27618_n8966# pmos
Xpmos_240 ML_29 VDD m2_n30953_n7856# VDD pmos
Xnmos_913 a_n34324_14342# VSS a_n34471_14561# VSS nmos
Xnmos_935 a_n26151_12604# VSS a_n26495_12604# VSS nmos
Xnmos_924 a_n27618_9728# VSS m1_n27919_9740# VSS nmos
Xnmos$2_4205 WL_17 VSS a_n46369_5186# SL_23 nmos$2
Xpmos_273 a_n38990_n13206# VDD a_n38843_n13126# VDD pmos
Xpmos_295 a_n37485_n10590# VDD a_n37338_n10510# VDD pmos
Xpmos_262 a_n26151_n10404# VDD VDD a_n26495_n10404# pmos
Xpmos_284 a_n37338_n9202# VDD VDD a_n37485_n9282# pmos
Xnmos_957 OUTP VSS a_n28089_13548# VSS nmos
Xnmos_946 a_n28485_14140# VSS VSS m1_n28364_13965# nmos
Xnmos$2_4238 a_n47560_10407# VSS ML_13 m1_n47463_10615# nmos$2
Xnmos$2_4227 WL_15 VSS a_n47874_7802# SL_22 nmos$2
Xnmos_968 a_n44870_6494# VSS a_n45017_6713# VSS nmos
Xnmos$2_4216 a_n49530_5405# VSS a_n49069_5175# SL_21N nmos$2
Xnmos$2_3526 WL_6 VSS SL_11N a_n64585_19793# nmos$2
Xnmos$2_3504 a_n61111_18255# VSS ML_7 m1_n61014_18463# nmos$2
Xnmos$2_3515 WL_7 VSS SL_11N a_n64585_18485# nmos$2
Xnmos$2_4249 a_n49069_9099# VSS ML_14 m1_n48972_9307# nmos$2
Xnmos_979 a_n41856_7802# VSS a_n42003_8021# VSS nmos
Xnmos$3_926 a_n40498_21101# VSS VSS a_n40351_20882# nmos$3
Xnmos$3_915 a_n45017_18485# VSS VSS a_n44870_18266# nmos$3
Xnmos$2_3559 WL_7 VSS a_n65943_18266# SL_10 nmos$2
Xnmos$2_3537 WL_8 VSS SL_12N a_n63077_17177# nmos$2
Xnmos$2_3548 WL_8 VSS a_n64438_16958# SL_11 nmos$2
Xnmos$3_904 a_n42003_13253# VSS VSS a_n41856_13034# nmos$3
Xnmos$2_2825 WL_12 VSS a_n70456_11726# SL_7 nmos$2
Xnmos$2_2803 WL_13 VSS a_n67452_10418# SL_9 nmos$2
Xnmos$2_2814 a_n70142_10407# VSS ML_13 m1_n70045_10615# nmos$2
Xnmos$3_959 a_n48021_21101# VSS VSS a_n47874_20882# nmos$3
Xnmos$3_948 a_n52543_22409# VSS VSS a_n52396_22190# nmos$3
Xnmos$3_937 a_n48021_18485# VSS VSS a_n47874_18266# nmos$3
Xnmos$2_2858 a_n73617_11945# VSS a_n73156_11715# SL_5N nmos$2
Xnmos$2_2836 a_n71647_10407# VSS ML_13 m1_n71550_10615# nmos$2
Xnmos$2_2847 a_n73470_9110# VSS SL_5 a_n73156_9099# nmos$2
Xnmos$2_403 a_n50888_n2662# VSS SL_20 a_n50574_n2673# nmos$2
Xnmos$2_436 WL_25 VSS a_n43365_n5278# SL_25 nmos$2
Xnmos$2_414 a_n40498_n5358# VSS a_n40037_n5289# SL_27N nmos$2
Xnmos$2_425 a_n41856_n3970# VSS SL_26 a_n41542_n3981# nmos$2
Xnmos$2_2869 WL_13 VSS SL_5N a_n73617_10637# nmos$2
Xnmos$2_469 WL_21 VSS a_n44870_n46# SL_24 nmos$2
Xnmos$2_458 WL_22 VSS m2_n44135_352# a_n45017_n1434# nmos$2
Xnmos$2_447 WL_24 VSS a_n44870_n3970# SL_24 nmos$2
Xnmos_3 a_n32313_n28669# VSS VSS a_n31996_n28654# nmos
Xnmos$2_4750 WL_3 VSS SL_20N a_n51035_23717# nmos$2
Xnmos$2_4794 WL_2 VSS SL_22N a_n48021_25025# nmos$2
Xnmos$2_4783 a_n49530_23717# VSS a_n49069_23487# SL_21N nmos$2
Xnmos$2_4761 WL_5 VSS a_n46369_20882# SL_23 nmos$2
Xnmos$2_4772 WL_5 VSS a_n49383_20882# SL_21 nmos$2
Xnmos$5_241 VEVAL VSS m1_n79086_151# VSS nmos$5
Xnmos$5_252 VEVAL VSS m1_n80591_n2465# VSS nmos$5
Xnmos$5_230 VEVAL VSS m1_n77577_n5081# VSS nmos$5
Xnmos$5_263 VEVAL VSS m1_n73059_151# VSS nmos$5
Xnmos$5_274 VEVAL VSS m1_n56504_n12929# VSS nmos$5
Xnmos$5_285 VEVAL VSS m1_n58000_n9005# VSS nmos$5
Xnmos$5_296 VEVAL VSS m1_n54999_n6389# VSS nmos$5
Xnmos$2_970 WL_28 VSS a_n71961_n9202# SL_6 nmos$2
Xnmos$2_981 a_n75122_n7974# VSS a_n74661_n7905# SL_4N nmos$2
Xnmos$2_992 WL_27 VSS SL_5N a_n73617_n7974# nmos$2
Xnmos_209 a_n27274_n4652# VSS a_n27618_n4652# VSS nmos
Xpmos_71 a_n49383_n13126# VDD VDD a_n49530_n13206# pmos
Xpmos_60 a_n42003_n10590# VDD a_n41856_n10510# VDD pmos
Xpmos_82 a_n53901_n11818# VDD VDD a_n54048_n11898# pmos
Xpmos_93 a_n53901_n10510# VDD VDD a_n54048_n10590# pmos
Xnmos$2_1409 WL_26 VSS a_n68957_n6586# SL_8 nmos$2
Xnmos_710 a_n81002_16958# VSS a_n81149_17177# VSS nmos
Xnmos_732 a_n79497_26114# VSS a_n79644_26333# VSS nmos
Xnmos_743 a_n71961_24806# VSS a_n72108_25025# VSS nmos
Xnmos_721 a_n77988_20882# VSS a_n78135_21101# VSS nmos
Xnmos$2_4013 a_n41856_3878# VSS SL_26 a_n41542_3867# nmos$2
Xnmos$2_4002 WL_19 VSS a_n40351_2570# SL_27 nmos$2
Xnmos$2_3301 a_n70603_25025# VSS a_n70142_24795# SL_7N nmos$2
Xnmos_765 a_n58411_20882# VSS a_n58558_21101# VSS nmos
Xnmos_776 a_n61425_18266# VSS a_n61572_18485# VSS nmos
Xnmos_754 a_n56915_16958# VSS a_n57062_17177# VSS nmos
Xnmos$2_4046 WL_16 VSS a_n43365_6494# SL_25 nmos$2
Xnmos$2_4035 WL_18 VSS SL_23N a_n46516_4097# nmos$2
Xnmos$2_4024 a_n43365_2570# VSS SL_25 a_n43051_2559# nmos$2
Xnmos$2_3312 WL_0 VSS SL_8N a_n69104_27641# nmos$2
Xnmos$2_3345 WL_0 VSS a_n73470_27422# SL_5 nmos$2
Xnmos$2_3323 a_n69104_26333# VSS a_n68643_26103# SL_8N nmos$2
Xnmos$5_1011 VEVAL VSS m1_n33913_25003# VSS nmos$5
Xnmos$2_3334 WL_2 VSS SL_6N a_n72108_25025# nmos$2
Xnmos$5_1000 VEVAL VSS m1_n36927_21079# VSS nmos$5
Xnmos$3_701 a_n60063_22409# VSS VSS a_n59916_22190# nmos$3
Xnmos_798 a_n62930_22190# VSS a_n63077_22409# VSS nmos
Xnmos_787 a_n67452_18266# VSS a_n67599_18485# VSS nmos
Xnmos$2_4068 WL_15 VSS a_n44870_7802# SL_24 nmos$2
Xnmos$2_4079 a_n40037_5175# VSS ML_17 m1_n39940_5383# nmos$2
Xnmos$2_4057 WL_17 VSS SL_23N a_n46516_5405# nmos$2
Xnmos$2_2600 a_n79183_5175# VSS ML_17 m1_n79086_5383# nmos$2
Xnmos$5_1022 VEVAL VSS m1_n36927_26311# VSS nmos$5
Xnmos$2_3356 WL_1 VSS a_n73470_26114# SL_5 nmos$2
Xnmos$3_712 a_n54048_23717# VSS VSS a_n53901_23498# nmos$3
Xnmos$3_734 a_n63077_22409# VSS VSS a_n62930_22190# nmos$3
Xnmos$3_723 a_n66090_19793# VSS VSS a_n65943_19574# nmos$3
Xnmos$2_3378 WL_7 VSS a_n55410_18266# SL_17 nmos$2
Xnmos$2_3367 WL_8 VSS a_n53901_16958# SL_18 nmos$2
Xnmos$5_1033 VEVAL VSS m1_n53490_14539# VSS nmos$5
Xnmos$2_2622 a_n79183_7791# VSS ML_15 m1_n79086_7999# nmos$2
Xnmos$2_2633 WL_16 VSS a_n74975_6494# SL_4 nmos$2
Xnmos$2_2611 a_n80688_6483# VSS ML_16 m1_n80591_6691# nmos$2
Xnmos$2_211 WL_30 VSS a_n47874_n11818# SL_22 nmos$2
Xnmos$2_200 WL_29 VSS a_n49383_n10510# SL_21 nmos$2
Xnmos$5_1044 VEVAL VSS m1_n53490_n5081# VSS nmos$5
Xnmos$3_756 a_n57062_26333# VSS VSS a_n56915_26114# nmos$3
Xnmos$3_745 a_n66090_26333# VSS VSS a_n65943_26114# nmos$3
Xnmos$2_3389 a_n55410_19574# VSS SL_17 a_n55096_19563# nmos$2
Xnmos$2_2666 WL_13 VSS SL_3N a_n76630_10637# nmos$2
Xnmos$5_1055 VEVAL VSS m1_n53490_7999# VSS nmos$5
Xnmos$2_2655 a_n77674_7791# VSS ML_15 m1_n77577_7999# nmos$2
Xnmos$2_2644 WL_17 VSS SL_2N a_n78135_5405# nmos$2
Xnmos$3_767 a_n35976_2789# VSS VSS a_n35829_2570# nmos$3
Xnmos$2_1921 a_n53901_2570# VSS SL_18 a_n53587_2559# nmos$2
Xnmos$2_222 a_n52396_n13126# VSS SL_19 a_n52082_n13137# nmos$2
Xnmos$2_233 WL_30 VSS SL_18N a_n54048_n11898# nmos$2
Xnmos$2_244 WL_29 VSS SL_20N a_n51035_n10590# nmos$2
Xnmos$2_1910 WL_26 VSS a_n61425_n6586# SL_13 nmos$2
Xnmos$2_2688 a_n77674_11715# VSS ML_12 m1_n77577_11923# nmos$2
Xnmos$2_2677 a_n77674_10407# VSS ML_13 m1_n77577_10615# nmos$2
Xnmos$3_789 a_n35976_9329# VSS VSS a_n35829_9110# nmos$3
Xnmos$2_2699 a_n79644_9329# VSS a_n79183_9099# SL_1N nmos$2
Xnmos$3_778 a_n38990_8021# VSS VSS a_n38843_7802# nmos$3
Xnmos$2_1965 WL_16 VSS a_n58411_6494# SL_15 nmos$2
Xnmos$2_1932 WL_18 VSS a_n55410_3878# SL_17 nmos$2
Xnmos$2_1954 a_n59602_3867# VSS ML_18 m1_n59505_4075# nmos$2
Xnmos$2_1943 a_n58097_2559# VSS ML_19 m1_n58000_2767# nmos$2
Xnmos$2_255 WL_28 VSS a_n50888_n9202# SL_20 nmos$2
Xnmos$2_277 WL_28 VSS a_n46369_n9202# SL_23 nmos$2
Xnmos$2_266 WL_27 VSS a_n50888_n7894# SL_20 nmos$2
Xnmos$2_1987 WL_15 VSS SL_14N a_n60063_8021# nmos$2
Xnmos$2_1998 a_n53587_5175# VSS ML_17 m1_n53490_5383# nmos$2
Xnmos$2_1976 a_n59916_5186# VSS SL_14 a_n59602_5175# nmos$2
Xnmos$2_288 WL_27 VSS a_n49383_n7894# SL_21 nmos$2
Xnmos$2_299 a_n47874_n5278# VSS SL_22 a_n47560_n5289# nmos$2
Xpmos_1816 a_n41856_3878# VDD VDD a_n42003_4097# pmos
Xpmos_1827 a_n43512_4097# VDD a_n43365_3878# VDD pmos
Xpmos_1805 a_n40498_2789# VDD a_n40351_2570# VDD pmos
Xpmos_1849 a_n43365_7802# VDD VDD a_n43512_8021# pmos
Xpmos_1838 a_n46369_7802# VDD VDD a_n46516_8021# pmos
Xnmos$2_5270 a_n62616_1251# VSS ML_20 m1_n62519_1459# nmos$2
Xnmos$2_4591 a_n43365_20882# VSS SL_25 a_n43051_20871# nmos$2
Xnmos$2_4580 a_n45017_19793# VSS a_n44556_19563# m2_n44135_352# nmos$2
Xnmos$2_3890 a_n35515_9099# VSS ML_14 m1_n35418_9307# nmos$2
Xnmos$5_8 VEVAL VSS m1_n45958_n28774# VSS nmos$5
Xnmos$2_1217 WL_21 VSS a_n76483_n46# SL_3 nmos$2
Xnmos$2_1206 WL_22 VSS SL_3N a_n76630_n1434# nmos$2
Xnmos$2_1239 WL_23 VSS SL_3N a_n76630_n2742# nmos$2
Xnmos$2_1228 WL_23 VSS a_n76483_n2662# SL_3 nmos$2
Xnmos$1_90 OUTP VSS a_n26151_19794# a_n27618_19794# nmos$1
Xnmos_540 a_n61425_13034# VSS a_n61572_13253# VSS nmos
Xnmos_551 a_n56915_9110# VSS a_n57062_9329# VSS nmos
Xnmos_562 a_n59916_14342# VSS a_n60063_14561# VSS nmos
Xnmos_595 a_n70456_7802# VSS a_n70603_8021# VSS nmos
Xnmos_584 a_n74975_6494# VSS a_n75122_6713# VSS nmos
Xnmos_573 a_n70456_2570# VSS a_n70603_2789# VSS nmos
Xnmos$2_3153 WL_6 VSS a_n79497_19574# SL_1 nmos$2
Xnmos$2_3142 a_n81149_19793# VSS a_n80688_19563# SL_0N nmos$2
Xnmos$2_3120 a_n79183_18255# VSS ML_7 m1_n79086_18463# nmos$2
Xnmos$2_3131 a_n79497_18266# VSS SL_1 a_n79183_18255# nmos$2
Xnmos$2_3186 a_n79644_23717# VSS a_n79183_23487# SL_1N nmos$2
Xnmos$2_3164 WL_4 VSS a_n77988_22190# SL_2 nmos$2
Xnmos$2_3175 a_n80688_22179# VSS ML_4 m1_n80591_22387# nmos$2
Xnmos$3_542 a_n81149_10637# VSS VSS a_n81002_10418# nmos$3
Xnmos$3_531 a_n76630_8021# VSS VSS a_n76483_7802# nmos$3
Xnmos$3_520 a_n79644_5405# VSS VSS a_n79497_5186# nmos$3
Xnmos$2_2441 a_n70142_3867# VSS ML_18 m1_n70045_4075# nmos$2
Xnmos$2_2430 WL_19 VSS a_n67452_2570# SL_9 nmos$2
Xnmos$2_3197 a_n74661_22179# VSS ML_4 m1_n74564_22387# nmos$2
Xnmos$3_553 a_n81149_14561# VSS VSS a_n81002_14342# nmos$3
Xnmos$3_575 a_n73617_10637# VSS VSS a_n73470_10418# nmos$3
Xnmos$3_564 a_n67599_9329# VSS VSS a_n67452_9110# nmos$3
Xnmos$2_2474 WL_16 VSS a_n71961_6494# SL_6 nmos$2
Xnmos$2_2485 a_n75122_5405# VSS a_n74661_5175# SL_4N nmos$2
Xnmos$2_2463 WL_18 VSS SL_4N a_n75122_4097# nmos$2
Xnmos$2_2452 WL_19 VSS a_n71961_2570# SL_6 nmos$2
Xnmos$2_1740 a_n64585_n2742# VSS a_n64124_n2673# SL_11N nmos$2
Xnmos$3_597 a_n70603_19793# VSS VSS a_n70456_19574# nmos$3
Xnmos$3_586 a_n70603_14561# VSS VSS a_n70456_14342# nmos$3
Xnmos$2_2496 a_n75122_8021# VSS a_n74661_7791# SL_4N nmos$2
Xnmos$2_1751 a_n65943_n2662# VSS SL_10 a_n65629_n2673# nmos$2
Xnmos$2_1762 a_n53901_n5278# VSS SL_18 a_n53587_n5289# nmos$2
Xnmos$2_1773 WL_24 VSS a_n55410_n3970# SL_17 nmos$2
Xnmos$2_1784 WL_25 VSS SL_15N a_n58558_n5358# nmos$2
Xnmos$2_1795 a_n59916_n3970# VSS SL_14 a_n59602_n3981# nmos$2
Xpmos_2303 a_n27618_25546# VDD VDD m1_n27919_25558# pmos
Xpmos_2325 OUTP VDD VDD a_n28089_30804# pmos
Xpmos_2314 a_n27274_28422# VDD VDD a_n27618_28422# pmos
Xpmos_1602 a_n54048_27641# VDD a_n53901_27422# VDD pmos
Xpmos_2336 a_n26495_24108# VDD COMP5 VDD pmos
Xpmos_2347 a_n40351_14342# VDD VDD a_n40498_14561# pmos
Xpmos_2358 a_n40351_26114# VDD VDD a_n40498_26333# pmos
Xpmos_1613 a_n57062_26333# VDD a_n56915_26114# VDD pmos
Xpmos_1624 a_n61425_24806# VDD VDD a_n61572_25025# pmos
Xpmos_1635 a_n27618_3976# VDD VDD m1_n27919_3988# pmos
Xpmos_2369 a_n28485_1198# VDD m1_n28364_1023# VDD pmos
Xpmos_1657 a_n26151_8290# VDD VDD a_n26495_8290# pmos
Xpmos_1646 ML_16 VDD a_n28485_8388# VDD pmos
Xpmos_1668 a_n34324_1262# VDD VDD a_n34471_1481# pmos
Xpmos_817 a_n60063_n1434# VDD a_n59916_n1354# VDD pmos
Xpmos_806 a_n60063_n4050# VDD a_n59916_n3970# VDD pmos
Xpmos_1679 a_n35976_2789# VDD a_n35829_2570# VDD pmos
Xpmos_828 a_n54048_n2742# VDD a_n53901_n2662# VDD pmos
Xpmos_839 a_n61425_n9202# VDD VDD a_n61572_n9282# pmos
Xnmos$3_5 a_n43512_n29051# VSS VSS a_n43365_n28971# nmos$3
Xnmos$5_818 VEVAL VSS m1_n41445_5383# VSS nmos$5
Xnmos$5_807 VEVAL VSS m1_n45958_1459# VSS nmos$5
Xnmos$5_829 VEVAL VSS m1_n47463_1459# VSS nmos$5
Xnmos$2_1025 a_n78135_n13206# VSS a_n77674_n13137# SL_2N nmos$2
Xnmos$2_1003 a_n70142_n9213# VSS ML_28 m1_n70045_n9005# nmos$2
Xnmos$2_1014 a_n68643_n7905# VSS ML_27 m1_n68546_n7697# nmos$2
Xnmos$2_1047 a_n74975_n11818# VSS SL_4 a_n74661_n11829# nmos$2
Xnmos$2_1069 a_n81149_n11898# VSS a_n80688_n11829# SL_0N nmos$2
Xnmos$2_1058 WL_31 VSS SL_0N a_n81149_n13206# nmos$2
Xnmos$2_1036 a_n77674_n10521# VSS ML_29 m1_n77577_n10313# nmos$2
Xnmos_370 a_n68957_n2662# VSS a_n69104_n2742# VSS nmos
Xnmos_381 a_n59916_n13126# VSS a_n60063_n13206# VSS nmos
Xnmos_392 a_n55410_n9202# VSS a_n55557_n9282# VSS nmos
Xnmos$3_350 a_n64585_173# VSS VSS a_n64438_n46# nmos$3
Xnmos$2_2282 WL_9 VSS SL_13N a_n61572_15869# nmos$2
Xnmos$2_2260 a_n61111_13023# VSS ML_11 m1_n61014_13231# nmos$2
Xnmos$2_2271 a_n62616_13023# VSS ML_11 m1_n62519_13231# nmos$2
Xnmos$2_2293 WL_14 VSS a_n53901_9110# SL_18 nmos$2
Xnmos$3_394 a_n57062_5405# VSS VSS a_n56915_5186# nmos$3
Xnmos$3_372 a_n57062_173# VSS VSS a_n56915_n46# nmos$3
Xnmos$3_383 a_n60063_n2742# VSS VSS a_n59916_n2662# nmos$3
Xnmos$3_361 a_n55557_n4050# VSS VSS a_n55410_n3970# nmos$3
Xnmos$2_1570 WL_31 VSS a_n65943_n13126# SL_10 nmos$2
Xnmos$2_1581 a_n67599_n10590# VSS a_n67138_n10521# SL_9N nmos$2
Xnmos$2_1592 a_n66090_n11898# VSS a_n65629_n11829# SL_10N nmos$2
Xpmos_2122 a_n48021_22409# VDD a_n47874_22190# VDD pmos
Xpmos_2100 a_n52543_22409# VDD a_n52396_22190# VDD pmos
Xpmos_2111 a_n49530_21101# VDD a_n49383_20882# VDD pmos
Xpmos_2133 a_n49530_27641# VDD a_n49383_27422# VDD pmos
Xpmos_2155 a_n52396_27422# VDD VDD a_n52543_27641# pmos
Xpmos_2144 a_n52396_24806# VDD VDD a_n52543_25025# pmos
Xpmos_1410 a_n77988_24806# VDD VDD a_n78135_25025# pmos
Xpmos_2177 a_n45017_27641# VDD a_n44870_27422# VDD pmos
Xpmos_1443 a_n68957_27422# VDD VDD a_n69104_27641# pmos
Xpmos_2166 a_n43365_26114# VDD VDD a_n43512_26333# pmos
Xpmos_1421 a_n78135_25025# VDD a_n77988_24806# VDD pmos
Xpmos_1432 a_n79644_25025# VDD a_n79497_24806# VDD pmos
Xpmos_2188 a_n27618_16918# VDD VDD m1_n27919_16930# pmos
Xpmos_1454 a_n74975_27422# VDD VDD a_n75122_27641# pmos
Xpmos_1476 a_n55410_19574# VDD VDD a_n55557_19793# pmos
Xpmos_1487 a_n57062_19793# VDD a_n56915_19574# VDD pmos
Xpmos_2199 a_n27274_18356# VDD VDD a_n27618_18356# pmos
Xpmos_1465 a_n54048_17177# VDD a_n53901_16958# VDD pmos
Xpmos_625 a_n71961_n1354# VDD VDD a_n72108_n1434# pmos
Xpmos_614 a_n73617_n5358# VDD a_n73470_n5278# VDD pmos
Xpmos_603 a_n67599_n4050# VDD a_n67452_n3970# VDD pmos
Xpmos_1498 a_n59916_22190# VDD VDD a_n60063_22409# pmos
Xpmos_647 a_n68957_n46# VDD VDD a_n69104_173# pmos
Xpmos_636 a_n73470_n2662# VDD VDD a_n73617_n2742# pmos
Xpmos_669 a_n58558_n11898# VDD a_n58411_n11818# VDD pmos
Xpmos_658 a_n54048_n11898# VDD a_n53901_n11818# VDD pmos
Xnmos$1_2 a_n28089_n13774# VSS m1_n26796_n13268# a_n26151_n13280# nmos$1
Xnmos$5_604 VEVAL VSS m1_n73059_23695# VSS nmos$5
Xnmos$5_626 VEVAL VSS m1_n79086_19771# VSS nmos$5
Xnmos$5_615 VEVAL VSS m1_n74564_17155# VSS nmos$5
Xnmos$5_659 VEVAL VSS m1_n70045_27619# VSS nmos$5
Xnmos$5_648 VEVAL VSS m1_n77577_26311# VSS nmos$5
Xnmos$5_637 VEVAL VSS m1_n77577_22387# VSS nmos$5
Xnmos_80 a_n52396_n46# VSS a_n52543_173# VSS nmos
Xnmos_91 a_n52396_n2662# VSS a_n52543_n2742# VSS nmos
Xnmos$2_2090 a_n66090_5405# VSS a_n65629_5175# SL_10N nmos$2
Xnmos$3_180 a_n67599_n10590# VSS VSS a_n67452_n10510# nmos$3
Xnmos$3_191 a_n73617_n9282# VSS VSS a_n73470_n9202# nmos$3
Xnmos$3_14 a_n42003_n13206# VSS VSS a_n41856_n13126# nmos$3
Xnmos$3_47 a_n52543_n13206# VSS VSS a_n52396_n13126# nmos$3
Xnmos$3_25 a_n43512_n9282# VSS VSS a_n43365_n9202# nmos$3
Xnmos$3_36 a_n40498_n7974# VSS VSS a_n40351_n7894# nmos$3
Xnmos$3_58 a_n46516_n9282# VSS VSS a_n46369_n9202# nmos$3
Xnmos$3_69 a_n49530_n4050# VSS VSS a_n49383_n3970# nmos$3
Xpmos_1240 a_n67599_11945# VDD a_n67452_11726# VDD pmos
Xpmos_1262 a_n73617_10637# VDD a_n73470_10418# VDD pmos
Xpmos_1251 a_n74975_9110# VDD VDD a_n75122_9329# pmos
Xpmos_400 a_n40351_n9202# VDD VDD a_n40498_n9282# pmos
Xpmos_1295 a_n67599_17177# VDD a_n67452_16958# VDD pmos
Xpmos_1284 a_n70456_15650# VDD VDD a_n70603_15869# pmos
Xpmos_1273 a_n73470_14342# VDD VDD a_n73617_14561# pmos
Xpmos_444 a_n68957_n13126# VDD VDD a_n69104_n13206# pmos
Xpmos_433 a_n73617_n29051# VDD a_n73470_n28971# VDD pmos
Xpmos_422 a_n62930_n28971# VDD VDD a_n63077_n29051# pmos
Xpmos_411 a_n59916_n28971# VDD VDD a_n60063_n29051# pmos
Xpmos_455 a_n73617_n13206# VDD a_n73470_n13126# VDD pmos
Xpmos_477 a_n73470_n10510# VDD VDD a_n73617_n10590# pmos
Xpmos_466 a_n71961_n9202# VDD VDD a_n72108_n9282# pmos
Xnmos$2_4409 a_n45017_9329# VSS a_n44556_9099# m2_n44135_352# nmos$2
Xpmos_499 a_n75122_n11898# VDD a_n74975_n11818# VDD pmos
Xpmos_488 a_n68957_n7894# VDD VDD a_n69104_n7974# pmos
Xnmos$2_3708 WL_1 VSS a_n64438_26114# SL_11 nmos$2
Xnmos$2_3719 a_n56601_24795# VSS ML_2 m1_n56504_25003# nmos$2
Xnmos_1171 a_n26495_21232# VSS VSS COMP7 nmos
Xnmos_1160 OUTP VSS a_n28089_19300# VSS nmos
Xnmos_1182 a_n26495_24108# VSS m1_n26796_24120# VSS nmos
Xnmos_1193 a_n34324_19574# VSS a_n34471_19793# VSS nmos
Xnmos$2_618 a_n38843_n11818# VSS SL_28 a_n38529_n11829# nmos$2
Xnmos$2_607 a_n34010_n10521# VSS ML_29 m1_n33913_n10313# nmos$2
Xnmos$1_117 a_n28089_30804# VSS m1_n26796_31310# a_n26151_31298# nmos$1
Xnmos$1_106 OUTP VSS m1_n27919_26996# a_n27274_26984# nmos$1
Xnmos$2_629 a_n37024_n11829# VSS ML_30 m1_n36927_n11621# nmos$2
Xnmos$2_4910 a_n46516_27641# VSS a_n46055_27411# SL_23N nmos$2
Xnmos$2_4921 WL_1 VSS m2_n44135_352# a_n45017_26333# nmos$2
Xnmos$2_4943 WL_7 VSS SL_31N a_n34471_18485# nmos$2
Xnmos$2_4932 a_n46369_18266# VSS SL_23 a_n46055_18255# nmos$2
Xnmos$5_401 VEVAL VSS m1_n61014_4075# VSS nmos$5
Xnmos$2_4954 WL_8 VSS SL_30N a_n35976_17177# nmos$2
Xnmos$2_4965 WL_8 VSS a_n37338_16958# SL_29 nmos$2
Xnmos$2_4976 a_n38529_16947# VSS ML_8 m1_n38432_17155# nmos$2
Xnmos$5_434 VEVAL VSS m1_n67041_10615# VSS nmos$5
Xnmos$5_412 VEVAL VSS m1_n67041_7999# VSS nmos$5
Xnmos$5_423 VEVAL VSS m1_n64027_4075# VSS nmos$5
Xnmos$2_4998 WL_5 VSS a_n37338_20882# SL_29 nmos$2
Xnmos$2_4987 a_n38529_19563# VSS ML_6 m1_n38432_19771# nmos$2
Xnmos$5_478 VEVAL VSS m1_n56504_15847# VSS nmos$5
Xnmos$5_445 VEVAL VSS m1_n61014_13231# VSS nmos$5
Xnmos$5_467 VEVAL VSS m1_n58000_11923# VSS nmos$5
Xnmos$5_456 VEVAL VSS m1_n54999_9307# VSS nmos$5
Xnmos$5_489 VEVAL VSS m1_n73059_1459# VSS nmos$5
Xnmos$5_990 VEVAL VSS m1_n35418_18463# VSS nmos$5
Xpmos_1070 a_n70603_1481# VDD a_n70456_1262# VDD pmos
Xpmos_1092 a_n71961_3878# VDD VDD a_n72108_4097# pmos
Xpmos_1081 a_n71961_1262# VDD VDD a_n72108_1481# pmos
Xpmos_230 a_n27618_n11842# VDD VDD m1_n27919_n11830# pmos
Xpmos_241 ML_30 VDD m2_n30953_n9084# VDD pmos
Xpmos_252 a_n26495_n7528# VDD VDD m1_n26796_n7516# pmos
Xnmos_914 a_n35829_14342# VSS a_n35976_14561# VSS nmos
Xnmos_925 a_n27274_12604# VSS a_n27618_12604# VSS nmos
Xnmos_903 a_n38843_10418# VSS a_n38990_10637# VSS nmos
Xpmos_274 a_n38843_n13126# VDD VDD a_n38990_n13206# pmos
Xpmos_285 a_n38990_n10590# VDD a_n38843_n10510# VDD pmos
Xpmos_263 a_n27618_n10404# VDD VDD m1_n27919_n10392# pmos
Xnmos_947 a_n27274_15480# VSS a_n27618_15480# VSS nmos
Xnmos_958 a_n26495_14042# VSS VSS COMP12 nmos
Xnmos_936 a_n26151_11166# VSS a_n26495_11166# VSS nmos
Xnmos$2_4228 a_n47560_7791# VSS ML_15 m1_n47463_7999# nmos$2
Xnmos$2_4206 a_n47560_6483# VSS ML_16 m1_n47463_6691# nmos$2
Xnmos$2_4217 WL_16 VSS SL_21N a_n49530_6713# nmos$2
Xnmos_969 a_n44870_5186# VSS a_n45017_5405# VSS nmos
Xpmos_296 a_n34324_n10510# VDD VDD a_n34471_n10590# pmos
Xnmos$2_3527 a_n62930_19574# VSS SL_12 a_n62616_19563# nmos$2
Xnmos$2_3505 a_n61425_18266# VSS SL_13 a_n61111_18255# nmos$2
Xnmos$2_3516 WL_7 VSS a_n62930_18266# SL_12 nmos$2
Xnmos$2_4239 WL_13 VSS a_n47874_10418# SL_22 nmos$2
Xnmos$2_3538 WL_7 VSS SL_12N a_n63077_18485# nmos$2
Xnmos$2_3549 a_n66090_18485# VSS a_n65629_18255# SL_10N nmos$2
Xnmos$3_916 a_n45017_17177# VSS VSS a_n44870_16958# nmos$3
Xnmos$3_905 a_n42003_15869# VSS VSS a_n41856_15650# nmos$3
Xnmos$2_2804 a_n67452_10418# VSS SL_9 a_n67138_10407# nmos$2
Xnmos$2_2815 a_n70142_9099# VSS ML_14 m1_n70045_9307# nmos$2
Xnmos$3_927 a_n42003_21101# VSS VSS a_n41856_20882# nmos$3
Xnmos$3_949 a_n52543_21101# VSS VSS a_n52396_20882# nmos$3
Xnmos$3_938 a_n48021_19793# VSS VSS a_n47874_19574# nmos$3
Xnmos$2_2826 WL_12 VSS a_n67452_11726# SL_9 nmos$2
Xnmos$2_2859 WL_12 VSS a_n73470_11726# SL_5 nmos$2
Xnmos$2_2837 a_n71647_9099# VSS ML_14 m1_n71550_9307# nmos$2
Xnmos$2_2848 WL_14 VSS a_n73470_9110# SL_5 nmos$2
Xnmos$2_404 WL_23 VSS a_n47874_n2662# SL_22 nmos$2
Xnmos$2_415 WL_25 VSS SL_26N a_n42003_n5358# nmos$2
Xnmos$2_426 WL_24 VSS SL_25N a_n43512_n4050# nmos$2
Xnmos$2_459 WL_22 VSS a_n43365_n1354# SL_25 nmos$2
Xnmos$2_437 a_n43365_n5278# VSS SL_25 a_n43051_n5289# nmos$2
Xnmos$2_448 a_n44870_n3970# VSS SL_24 a_n44556_n3981# nmos$2
Xnmos_4 a_n35829_n28971# VSS a_n35976_n29051# VSS nmos
Xnmos$2_4751 a_n50574_23487# VSS ML_3 m1_n50477_23695# nmos$2
Xnmos$2_4740 WL_4 VSS a_n52396_22190# SL_19 nmos$2
Xnmos$2_4784 WL_3 VSS SL_21N a_n49530_23717# nmos$2
Xnmos$2_4762 WL_5 VSS SL_22N a_n48021_21101# nmos$2
Xnmos$2_4773 a_n49383_22190# VSS SL_21 a_n49069_22179# nmos$2
Xnmos$5_242 VEVAL VSS m1_n76072_n1157# VSS nmos$5
Xnmos$5_220 VEVAL VSS m1_n76072_n9005# VSS nmos$5
Xnmos$5_253 VEVAL VSS m1_n68546_n5081# VSS nmos$5
Xnmos$5_231 VEVAL VSS m1_n77577_n3773# VSS nmos$5
Xnmos$2_4795 a_n47874_24806# VSS SL_22 a_n47560_24795# nmos$2
Xnmos$5_264 VEVAL VSS m1_n71550_151# VSS nmos$5
Xnmos$5_275 VEVAL VSS m1_n56504_n10313# VSS nmos$5
Xnmos$5_286 VEVAL VSS m1_n59505_n9005# VSS nmos$5
Xnmos$5_297 VEVAL VSS m1_n61014_n12929# VSS nmos$5
Xnmos$2_960 a_n71961_n11818# VSS SL_6 a_n71647_n11829# nmos$2
Xnmos$2_971 a_n71647_n9213# VSS ML_28 m1_n71550_n9005# nmos$2
Xnmos$2_982 WL_27 VSS SL_4N a_n75122_n7974# nmos$2
Xnmos$2_993 a_n68957_n9202# VSS SL_8 a_n68643_n9213# nmos$2
Xpmos_72 a_n49530_n11898# VDD a_n49383_n11818# VDD pmos
Xpmos_50 a_n46369_n10510# VDD VDD a_n46516_n10590# pmos
Xpmos_61 a_n42003_n9282# VDD a_n41856_n9202# VDD pmos
Xpmos_83 a_n52543_n11898# VDD a_n52396_n11818# VDD pmos
Xpmos_94 a_n53901_n7894# VDD VDD a_n54048_n7974# pmos
Xnmos_700 a_n68957_23498# VSS a_n69104_23717# VSS nmos
Xnmos_744 a_n71961_26114# VSS a_n72108_26333# VSS nmos
Xnmos_733 a_n81002_26114# VSS a_n81149_26333# VSS nmos
Xnmos_722 a_n77988_22190# VSS a_n78135_22409# VSS nmos
Xnmos_711 a_n81002_19574# VSS a_n81149_19793# VSS nmos
Xnmos$2_4003 a_n40037_2559# VSS ML_19 m1_n39940_2767# nmos$2
Xnmos$2_3302 a_n70142_24795# VSS ML_2 m1_n70045_25003# nmos$2
Xnmos_766 a_n59916_20882# VSS a_n60063_21101# VSS nmos
Xnmos_755 a_n56915_18266# VSS a_n57062_18485# VSS nmos
Xnmos_777 a_n61425_16958# VSS a_n61572_17177# VSS nmos
Xnmos$2_4047 a_n43051_6483# VSS ML_16 m1_n42954_6691# nmos$2
Xnmos$2_4014 WL_18 VSS SL_25N a_n43512_4097# nmos$2
Xnmos$2_4036 WL_18 VSS a_n44870_3878# SL_24 nmos$2
Xnmos$2_4025 WL_19 VSS m2_n44135_352# a_n45017_2789# nmos$2
Xnmos$2_3313 a_n69104_27641# VSS a_n68643_27411# SL_8N nmos$2
Xnmos$2_3324 a_n68643_26103# VSS ML_1 m1_n68546_26311# nmos$2
Xnmos$2_3335 a_n75122_25025# VSS a_n74661_24795# SL_4N nmos$2
Xnmos$5_1001 VEVAL VSS m1_n38432_21079# VSS nmos$5
Xnmos_799 a_n62930_20882# VSS a_n63077_21101# VSS nmos
Xnmos_788 a_n67452_16958# VSS a_n67599_17177# VSS nmos
Xnmos$2_4069 WL_15 VSS SL_23N a_n46516_8021# nmos$2
Xnmos$2_4058 a_n46516_5405# VSS a_n46055_5175# SL_23N nmos$2
Xnmos$5_1023 VEVAL VSS m1_n53490_27619# VSS nmos$5
Xnmos$2_3346 a_n73156_27411# VSS ML_0 m1_n73059_27619# nmos$2
Xnmos$2_3357 WL_1 VSS SL_5N a_n73617_26333# nmos$2
Xnmos$5_1012 VEVAL VSS m1_n35418_25003# VSS nmos$5
Xnmos$5_1045 VEVAL VSS m1_n53490_25003# VSS nmos$5
Xnmos$3_702 a_n60063_23717# VSS VSS a_n59916_23498# nmos$3
Xnmos$3_724 a_n64585_19793# VSS VSS a_n64438_19574# nmos$3
Xnmos$2_3368 a_n53901_18266# VSS SL_18 a_n53587_18255# nmos$2
Xnmos$3_713 a_n61572_18485# VSS VSS a_n61425_18266# nmos$3
Xnmos$5_1034 VEVAL VSS m1_n53490_13231# VSS nmos$5
Xnmos$2_2623 a_n79644_8021# VSS a_n79183_7791# SL_1N nmos$2
Xnmos$2_2634 WL_16 VSS SL_3N a_n76630_6713# nmos$2
Xnmos$2_2601 a_n77988_6494# VSS SL_2 a_n77674_6483# nmos$2
Xnmos$2_2612 WL_17 VSS a_n81002_5186# SL_0 nmos$2
Xnmos$2_201 a_n49383_n10510# VSS SL_21 a_n49069_n10521# nmos$2
Xnmos$3_757 a_n60063_25025# VSS VSS a_n59916_24806# nmos$3
Xnmos$3_746 a_n66090_25025# VSS VSS a_n65943_24806# nmos$3
Xnmos$3_735 a_n63077_23717# VSS VSS a_n62930_23498# nmos$3
Xnmos$2_3379 a_n56601_18255# VSS ML_7 m1_n56504_18463# nmos$2
Xnmos$2_2667 a_n76630_10637# VSS a_n76169_10407# SL_3N nmos$2
Xnmos$2_2656 WL_15 VSS SL_3N a_n76630_8021# nmos$2
Xnmos$2_2645 a_n76169_5175# VSS ML_17 m1_n76072_5383# nmos$2
Xnmos$3_768 a_n38990_2789# VSS VSS a_n38843_2570# nmos$3
Xnmos$2_1922 WL_19 VSS a_n53901_2570# SL_18 nmos$2
Xnmos$2_223 WL_31 VSS a_n52396_n13126# SL_19 nmos$2
Xnmos$2_234 WL_29 VSS SL_18N a_n54048_n10590# nmos$2
Xnmos$2_212 a_n47560_n10521# VSS ML_29 m1_n47463_n10313# nmos$2
Xnmos$2_1900 a_n66090_n6666# VSS a_n65629_n6597# SL_10N nmos$2
Xnmos$2_1911 a_n61572_n6666# VSS a_n61111_n6597# SL_13N nmos$2
Xnmos$2_2689 a_n74661_11715# VSS ML_12 m1_n74564_11923# nmos$2
Xnmos$2_2678 WL_13 VSS a_n76483_10418# SL_3 nmos$2
Xnmos$3_779 a_n37485_8021# VSS VSS a_n37338_7802# nmos$3
Xnmos$2_1933 a_n57062_4097# VSS a_n56601_3867# SL_16N nmos$2
Xnmos$2_1955 a_n59916_3878# VSS SL_14 a_n59602_3867# nmos$2
Xnmos$2_1944 a_n58558_2789# VSS a_n58097_2559# SL_15N nmos$2
Xnmos$2_245 WL_29 VSS SL_19N a_n52543_n10590# nmos$2
Xnmos$2_256 a_n54048_n9282# VSS a_n53587_n9213# SL_18N nmos$2
Xnmos$2_278 a_n48021_n9282# VSS a_n47560_n9213# SL_22N nmos$2
Xnmos$2_267 a_n51035_n7974# VSS a_n50574_n7905# SL_20N nmos$2
Xnmos$2_1988 a_n59916_7802# VSS SL_14 a_n59602_7791# nmos$2
Xnmos$2_1999 a_n53587_6483# VSS ML_16 m1_n53490_6691# nmos$2
Xnmos$2_1977 a_n59602_6483# VSS ML_16 m1_n59505_6691# nmos$2
Xnmos$2_1966 a_n58411_5186# VSS SL_15 a_n58097_5175# nmos$2
Xnmos$2_289 a_n49383_n7894# VSS SL_21 a_n49069_n7905# nmos$2
Xpmos_1817 a_n43512_2789# VDD a_n43365_2570# VDD pmos
Xpmos_1806 a_n40498_1481# VDD a_n40351_1262# VDD pmos
Xpmos_1839 a_n44870_7802# VDD VDD a_n45017_8021# pmos
Xpmos_1828 a_n44870_3878# VDD VDD a_n45017_4097# pmos
Xnmos$2_5271 WL_20 VSS a_n49383_1262# SL_21 nmos$2
Xnmos$2_5260 WL_20 VSS SL_6N a_n72108_1481# nmos$2
Xnmos$2_4581 a_n43365_19574# VSS SL_25 a_n43051_19563# nmos$2
Xnmos$2_4592 WL_5 VSS a_n43365_20882# SL_25 nmos$2
Xnmos$2_4570 WL_8 VSS SL_23N a_n46516_17177# nmos$2
Xnmos$2_3880 a_n34471_9329# VSS a_n34010_9099# SL_31N nmos$2
Xnmos$2_3891 a_n35976_9329# VSS a_n35515_9099# SL_30N nmos$2
Xnmos$2_790 a_n34324_n6586# VSS SL_31 a_n34010_n6597# nmos$2
Xnmos$5_9 VEVAL VSS m1_n47463_n28774# VSS nmos$5
Xnmos$2_1218 a_n76169_n57# VSS ML_21 m1_n76072_151# nmos$2
Xnmos$2_1207 a_n76483_n1354# VSS SL_3 a_n76169_n1365# nmos$2
Xnmos$2_1229 a_n77674_n2673# VSS ML_23 m1_n77577_n2465# nmos$2
Xnmos$1_91 a_n28089_19300# VSS m1_n26796_19806# a_n26151_19794# nmos$1
Xnmos$1_80 a_n28089_14986# VSS a_n27274_15480# m1_n28364_15403# nmos$1
Xnmos_541 a_n62930_14342# VSS a_n63077_14561# VSS nmos
Xnmos_552 a_n56915_11726# VSS a_n57062_11945# VSS nmos
Xnmos_530 a_n67452_10418# VSS a_n67599_10637# VSS nmos
Xnmos$2_3110 WL_6 VSS SL_2N a_n78135_19793# nmos$2
Xnmos_563 a_n59916_13034# VSS a_n60063_13253# VSS nmos
Xnmos_585 a_n74975_5186# VSS a_n75122_5405# VSS nmos
Xnmos_574 a_n70456_3878# VSS a_n70603_4097# VSS nmos
Xnmos$2_3143 WL_6 VSS SL_0N a_n81149_19793# nmos$2
Xnmos$2_3121 a_n79183_16947# VSS ML_8 m1_n79086_17155# nmos$2
Xnmos$2_3132 WL_8 VSS a_n81002_16958# SL_0 nmos$2
Xnmos_596 a_n68957_7802# VSS a_n69104_8021# VSS nmos
Xnmos$2_3187 a_n79497_23498# VSS SL_1 a_n79183_23487# nmos$2
Xnmos$2_3165 a_n77988_22190# VSS SL_2 a_n77674_22179# nmos$2
Xnmos$2_3176 WL_5 VSS SL_0N a_n81149_21101# nmos$2
Xnmos$2_3154 WL_7 VSS a_n79497_18266# SL_1 nmos$2
Xnmos$2_2420 a_n56915_15650# VSS SL_16 a_n56601_15639# nmos$2
Xnmos$3_543 a_n79644_10637# VSS VSS a_n79497_10418# nmos$3
Xnmos$3_532 a_n75122_8021# VSS VSS a_n74975_7802# nmos$3
Xnmos$3_521 a_n81149_5405# VSS VSS a_n81002_5186# nmos$3
Xnmos$2_2442 WL_18 VSS SL_8N a_n69104_4097# nmos$2
Xnmos$3_510 a_n76630_4097# VSS VSS a_n76483_3878# nmos$3
Xnmos$2_2431 a_n67452_2570# VSS SL_9 a_n67138_2559# nmos$2
Xnmos$2_3198 a_n74661_20871# VSS ML_5 m1_n74564_21079# nmos$2
Xnmos$3_554 a_n79644_15869# VSS VSS a_n79497_15650# nmos$3
Xnmos$3_576 a_n73617_11945# VSS VSS a_n73470_11726# nmos$3
Xnmos$3_565 a_n70603_9329# VSS VSS a_n70456_9110# nmos$3
Xnmos$2_2475 a_n71961_6494# VSS SL_6 a_n71647_6483# nmos$2
Xnmos$2_2464 a_n75122_4097# VSS a_n74661_3867# SL_4N nmos$2
Xnmos$2_2453 a_n71961_2570# VSS SL_6 a_n71647_2559# nmos$2
Xnmos$2_1730 WL_21 VSS a_n61425_n46# SL_13 nmos$2
Xnmos$3_598 a_n67599_19793# VSS VSS a_n67452_19574# nmos$3
Xnmos$3_587 a_n70603_13253# VSS VSS a_n70456_13034# nmos$3
Xnmos$2_2497 a_n73156_7791# VSS ML_15 m1_n73059_7999# nmos$2
Xnmos$2_2486 a_n75122_6713# VSS a_n74661_6483# SL_4N nmos$2
Xnmos$2_1741 a_n61572_n2742# VSS a_n61111_n2673# SL_13N nmos$2
Xnmos$2_1752 WL_23 VSS SL_9N a_n67599_n2742# nmos$2
Xnmos$2_1763 WL_25 VSS a_n53901_n5278# SL_18 nmos$2
Xnmos$2_1785 WL_25 VSS a_n56915_n5278# SL_16 nmos$2
Xnmos$2_1796 a_n60063_n4050# VSS a_n59602_n3981# SL_14N nmos$2
Xnmos$2_1774 a_n53901_n3970# VSS SL_18 a_n53587_n3981# nmos$2
Xpmos_2304 a_n27274_25546# VDD VDD a_n27618_25546# pmos
Xpmos_2326 a_n26495_29860# VDD VDD m1_n26796_29872# pmos
Xpmos_2315 a_n28485_28520# VDD m1_n28364_28345# VDD pmos
Xpmos_2337 OUTP VDD VDD a_n28089_23614# pmos
Xpmos_1614 a_n58411_26114# VDD VDD a_n58558_26333# pmos
Xpmos_1625 a_n61425_26114# VDD VDD a_n61572_26333# pmos
Xpmos_2359 a_n40351_24806# VDD VDD a_n40498_25025# pmos
Xpmos_1603 a_n58411_24806# VDD VDD a_n58558_25025# pmos
Xpmos_2348 a_n40351_11726# VDD VDD a_n40498_11945# pmos
Xpmos_1636 a_n28485_2636# VDD m1_n28364_2461# VDD pmos
Xpmos_1658 a_n26495_8290# VDD VDD m1_n26796_8302# pmos
Xpmos_1647 OUTP VDD VDD a_n28089_4920# pmos
Xpmos_1669 a_n34324_2570# VDD VDD a_n34471_2789# pmos
Xpmos_818 a_n59916_n2662# VDD VDD a_n60063_n2742# pmos
Xpmos_807 a_n58411_n3970# VDD VDD a_n58558_n4050# pmos
Xpmos_829 a_n54048_n1434# VDD a_n53901_n1354# VDD pmos
Xnmos$2_5090 a_n38843_24806# VSS SL_28 a_n38529_24795# nmos$2
Xnmos$3_6 a_n42003_n29051# VSS VSS a_n41856_n28971# nmos$3
Xnmos$5_808 VEVAL VSS m1_n45958_4075# VSS nmos$5
Xnmos$5_819 VEVAL VSS m1_n41445_6691# VSS nmos$5
Xnmos$2_1026 a_n77674_n13137# VSS ML_31 m1_n77577_n12929# nmos$2
Xnmos$2_1015 WL_28 VSS a_n68957_n9202# SL_8 nmos$2
Xnmos$2_1004 a_n70142_n7905# VSS ML_27 m1_n70045_n7697# nmos$2
Xnmos$2_1037 a_n77674_n11829# VSS ML_30 m1_n77577_n11621# nmos$2
Xnmos$2_1059 a_n80688_n13137# VSS ML_31 m1_n80591_n12929# nmos$2
Xnmos$2_1048 WL_29 VSS SL_3N a_n76630_n10590# nmos$2
Xnmos_360 a_n74975_n1354# VSS a_n75122_n1434# VSS nmos
Xnmos_371 a_n70456_n2662# VSS a_n70603_n2742# VSS nmos
Xnmos_382 a_n59916_n10510# VSS a_n60063_n10590# VSS nmos
Xnmos_393 a_n56915_n9202# VSS a_n57062_n9282# VSS nmos
Xnmos$2_2250 a_n65629_13023# VSS ML_11 m1_n65532_13231# nmos$2
Xnmos$3_351 a_n61572_n1434# VSS VSS a_n61425_n1354# nmos$3
Xnmos$3_340 a_n63077_n5358# VSS VSS a_n62930_n5278# nmos$3
Xnmos$2_2283 WL_9 VSS a_n61425_15650# SL_13 nmos$2
Xnmos$2_2261 WL_10 VSS a_n61425_14342# SL_13 nmos$2
Xnmos$2_2272 WL_11 VSS SL_11N a_n64585_13253# nmos$2
Xnmos$3_384 a_n54048_2789# VSS VSS a_n53901_2570# nmos$3
Xnmos$3_373 a_n58558_173# VSS VSS a_n58411_n46# nmos$3
Xnmos$3_362 a_n54048_n4050# VSS VSS a_n53901_n3970# nmos$3
Xnmos$2_2294 a_n53587_10407# VSS ML_13 m1_n53490_10615# nmos$2
Xnmos$3_395 a_n57062_6713# VSS VSS a_n56915_6494# nmos$3
Xnmos$2_1571 a_n65943_n13126# VSS SL_10 a_n65629_n13137# nmos$2
Xnmos$2_1582 a_n65943_n10510# VSS SL_10 a_n65629_n10521# nmos$2
Xnmos$2_1560 WL_29 VSS SL_13N a_n61572_n10590# nmos$2
Xnmos$2_1593 a_n64438_n10510# VSS SL_11 a_n64124_n10521# nmos$2
Xpmos_2112 a_n49530_23717# VDD a_n49383_23498# VDD pmos
Xpmos_2101 a_n53901_22190# VDD VDD a_n54048_22409# pmos
Xpmos_2134 a_n49383_27422# VDD VDD a_n49530_27641# pmos
Xpmos_2145 a_n51035_25025# VDD a_n50888_24806# VDD pmos
Xpmos_1411 a_n76630_25025# VDD a_n76483_24806# VDD pmos
Xpmos_1400 a_n77988_22190# VDD VDD a_n78135_22409# pmos
Xpmos_2123 a_n50888_20882# VDD VDD a_n51035_21101# pmos
Xpmos_2167 a_n41856_27422# VDD VDD a_n42003_27641# pmos
Xpmos_2178 a_n46369_27422# VDD VDD a_n46516_27641# pmos
Xpmos_1433 a_n79644_27641# VDD a_n79497_27422# VDD pmos
Xpmos_2156 a_n50888_26114# VDD VDD a_n51035_26333# pmos
Xpmos_1444 a_n68957_26114# VDD VDD a_n69104_26333# pmos
Xpmos_1422 a_n81002_24806# VDD VDD a_n81149_25025# pmos
Xpmos_2189 a_n27274_16918# VDD VDD a_n27618_16918# pmos
Xpmos_1455 a_n74975_26114# VDD VDD a_n75122_26333# pmos
Xpmos_1466 a_n55410_16958# VDD VDD a_n55557_17177# pmos
Xpmos_1477 a_n58411_16958# VDD VDD a_n58558_17177# pmos
Xpmos_626 a_n74975_n1354# VDD VDD a_n75122_n1434# pmos
Xpmos_604 a_n69104_n6666# VDD a_n68957_n6586# VDD pmos
Xpmos_615 a_n73617_n4050# VDD a_n73470_n3970# VDD pmos
Xpmos_1499 a_n60063_22409# VDD a_n59916_22190# VDD pmos
Xpmos_1488 a_n58411_19574# VDD VDD a_n58558_19793# pmos
Xpmos_648 a_n67599_173# VDD a_n67452_n46# VDD pmos
Xpmos_637 a_n68957_n1354# VDD VDD a_n69104_n1434# pmos
Xpmos_659 a_n55410_n11818# VDD VDD a_n55557_n11898# pmos
Xnmos$1_3 OUTP VSS m1_n27919_n10392# a_n27274_n10404# nmos$1
Xnmos$5_605 VEVAL VSS m1_n71550_23695# VSS nmos$5
Xnmos$5_627 VEVAL VSS m1_n79086_22387# VSS nmos$5
Xnmos$5_616 VEVAL VSS m1_n77577_18463# VSS nmos$5
Xnmos$5_649 VEVAL VSS m1_n74564_26311# VSS nmos$5
Xnmos$5_638 VEVAL VSS m1_n77577_21079# VSS nmos$5
Xnmos_70 a_n49383_n5278# VSS a_n49530_n5358# VSS nmos
Xnmos_81 a_n47874_n1354# VSS a_n48021_n1434# VSS nmos
Xnmos_92 a_n50888_n5278# VSS a_n51035_n5358# VSS nmos
Xnmos_190 a_n35829_n1354# VSS a_n35976_n1434# VSS nmos
Xnmos$2_2091 a_n67599_5405# VSS a_n67138_5175# SL_9N nmos$2
Xnmos$2_2080 a_n65629_2559# VSS ML_19 m1_n65532_2767# nmos$2
Xnmos$3_181 a_n69104_n13206# VSS VSS a_n68957_n13126# nmos$3
Xnmos$3_170 a_n76630_n29051# VSS VSS a_n76483_n28971# nmos$3
Xnmos$3_192 a_n73617_n6666# VSS VSS a_n73470_n6586# nmos$3
Xnmos$2_1390 WL_26 VSS SL_1N a_n79644_n6666# nmos$2
Xnmos$3_37 a_n46516_n13206# VSS VSS a_n46369_n13126# nmos$3
Xnmos$3_15 a_n42003_n10590# VSS VSS a_n41856_n10510# nmos$3
Xnmos$3_26 a_n45017_n9282# VSS VSS a_n44870_n9202# nmos$3
Xnmos$3_48 a_n52543_n11898# VSS VSS a_n52396_n11818# nmos$3
Xnmos$3_59 a_n49530_n9282# VSS VSS a_n49383_n9202# nmos$3
Xpmos_1230 a_n75122_14561# VDD a_n74975_14342# VDD pmos
Xpmos_1241 a_n68957_11726# VDD VDD a_n69104_11945# pmos
Xpmos_1252 a_n73617_9329# VDD a_n73470_9110# VDD pmos
Xpmos_401 a_n40351_n13126# VDD VDD a_n40498_n13206# pmos
Xpmos_1285 a_n67599_15869# VDD a_n67452_15650# VDD pmos
Xpmos_1274 a_n73470_13034# VDD VDD a_n73617_13253# pmos
Xpmos_1263 a_n73470_9110# VDD VDD a_n73617_9329# pmos
Xpmos_434 a_n79497_n28971# VDD VDD a_n79644_n29051# pmos
Xpmos_423 a_n61425_n28971# VDD VDD a_n61572_n29051# pmos
Xpmos_412 a_n55557_n29051# VDD a_n55410_n28971# VDD pmos
Xpmos_1296 a_n70456_16958# VDD VDD a_n70603_17177# pmos
Xpmos_445 a_n70603_n13206# VDD a_n70456_n13126# VDD pmos
Xpmos_456 a_n74975_n13126# VDD VDD a_n75122_n13206# pmos
Xpmos_467 a_n73617_n9282# VDD a_n73470_n9202# VDD pmos
Xpmos_478 a_n67599_n9282# VDD a_n67452_n9202# VDD pmos
Xpmos_489 a_n67599_n7974# VDD a_n67452_n7894# VDD pmos
Xnmos$2_3709 a_n64124_26103# VSS ML_1 m1_n64027_26311# nmos$2
Xnmos_1172 a_n27618_21232# VSS m1_n27919_21244# VSS nmos
Xnmos_1161 ML_7 VSS VSS a_n28485_21330# nmos
Xnmos_1150 a_n27618_16918# VSS m1_n27919_16930# VSS nmos
Xnmos_1183 a_n26151_24108# VSS a_n26495_24108# VSS nmos
Xnmos_1194 a_n37338_18266# VSS a_n37485_18485# VSS nmos
Xnmos$2_608 a_n37338_n13126# VSS SL_29 a_n37024_n13137# nmos$2
Xnmos$2_619 WL_30 VSS SL_28N a_n38990_n11898# nmos$2
Xnmos$1_118 OUTP VSS a_n26151_29860# a_n27618_29860# nmos$1
Xnmos$1_107 a_n28089_25052# VSS m1_n26796_25558# a_n26151_25546# nmos$1
Xnmos$2_4900 WL_2 VSS m2_n44135_352# a_n45017_25025# nmos$2
Xpmos_990 a_n64438_13034# VDD VDD a_n64585_13253# pmos
Xnmos$2_4911 WL_0 VSS SL_23N a_n46516_27641# nmos$2
Xnmos$2_4922 a_n46055_26103# VSS ML_1 m1_n45958_26311# nmos$2
Xnmos$2_4933 a_n46369_19574# VSS SL_23 a_n46055_19563# nmos$2
Xnmos$5_402 VEVAL VSS m1_n65532_2767# VSS nmos$5
Xnmos$2_4966 a_n37024_18255# VSS ML_7 m1_n36927_18463# nmos$2
Xnmos$2_4977 a_n38843_18266# VSS SL_28 a_n38529_18255# nmos$2
Xnmos$2_4944 a_n34471_17177# VSS a_n34010_16947# SL_31N nmos$2
Xnmos$2_4955 a_n35976_17177# VSS a_n35515_16947# SL_30N nmos$2
Xnmos$5_435 VEVAL VSS m1_n67041_9307# VSS nmos$5
Xnmos$5_413 VEVAL VSS m1_n65532_7999# VSS nmos$5
Xnmos$5_424 VEVAL VSS m1_n64027_2767# VSS nmos$5
Xnmos$2_4999 a_n37338_22190# VSS SL_29 a_n37024_22179# nmos$2
Xnmos$2_4988 WL_6 VSS a_n38843_19574# SL_28 nmos$2
Xnmos$5_446 VEVAL VSS m1_n62519_14539# VSS nmos$5
Xnmos$5_468 VEVAL VSS m1_n58000_13231# VSS nmos$5
Xnmos$5_457 VEVAL VSS m1_n54999_10615# VSS nmos$5
Xnmos$5_479 VEVAL VSS m1_n54999_15847# VSS nmos$5
Xnmos$5_980 VEVAL VSS m1_n45958_27619# VSS nmos$5
Xnmos$5_991 VEVAL VSS m1_n35418_19771# VSS nmos$5
Xpmos_1060 a_n61425_9110# VDD VDD a_n61572_9329# pmos
Xpmos_1082 a_n71961_2570# VDD VDD a_n72108_2789# pmos
Xpmos_1071 a_n70456_1262# VDD VDD a_n70603_1481# pmos
Xpmos_1093 a_n73470_1262# VDD VDD a_n73617_1481# pmos
Xpmos_220 a_n42003_n1434# VDD a_n41856_n1354# VDD pmos
Xpmos_231 OUTP VDD VDD a_n28089_n13774# pmos
Xpmos_242 ML_28 VDD a_n28485_n8868# VDD pmos
Xnmos_915 a_n35829_13034# VSS a_n35976_13253# VSS nmos
Xnmos_926 a_n27618_12604# VSS m1_n27919_12616# VSS nmos
Xnmos_904 a_n38843_11726# VSS a_n38990_11945# VSS nmos
Xpmos_275 a_n38843_n11818# VDD VDD a_n38990_n11898# pmos
Xpmos_264 a_n26495_n10404# VDD COMP29 VDD pmos
Xpmos_286 a_n38843_n9202# VDD VDD a_n38990_n9282# pmos
Xpmos_253 a_n26151_n7528# VDD VDD a_n26495_n7528# pmos
Xnmos_948 OUTP VSS a_n28089_14986# VSS nmos
Xnmos_959 a_n26151_14042# VSS a_n26495_14042# VSS nmos
Xnmos_937 a_n26495_11166# VSS m1_n26796_11178# VSS nmos
Xnmos$2_4229 a_n48021_8021# VSS a_n47560_7791# SL_22N nmos$2
Xnmos$2_4207 WL_16 VSS a_n47874_6494# SL_22 nmos$2
Xnmos$2_4218 a_n49069_6483# VSS ML_16 m1_n48972_6691# nmos$2
Xpmos_297 a_n34324_n9202# VDD VDD a_n34471_n9282# pmos
Xnmos$2_3517 a_n63077_18485# VSS a_n62616_18255# SL_12N nmos$2
Xnmos$2_3506 WL_8 VSS SL_13N a_n61572_17177# nmos$2
Xnmos$3_917 a_n45017_19793# VSS VSS a_n44870_19574# nmos$3
Xnmos$2_3539 WL_6 VSS SL_12N a_n63077_19793# nmos$2
Xnmos$2_3528 WL_6 VSS a_n62930_19574# SL_12 nmos$2
Xnmos$3_906 a_n40498_15869# VSS VSS a_n40351_15650# nmos$3
Xnmos$2_2805 a_n69104_9329# VSS a_n68643_9099# SL_8N nmos$2
Xnmos$2_2816 WL_14 VSS a_n70456_9110# SL_7 nmos$2
Xnmos$3_928 a_n42003_22409# VSS VSS a_n41856_22190# nmos$3
Xnmos$3_939 a_n48021_17177# VSS VSS a_n47874_16958# nmos$3
Xnmos$2_2827 a_n68957_11726# VSS SL_8 a_n68643_11715# nmos$2
Xnmos$2_2838 WL_14 VSS a_n71961_9110# SL_6 nmos$2
Xnmos$2_2849 a_n73617_9329# VSS a_n73156_9099# SL_5N nmos$2
Xnmos$2_405 a_n49069_n2673# VSS ML_23 m1_n48972_n2465# nmos$2
Xnmos$2_416 WL_25 VSS SL_27N a_n40498_n5358# nmos$2
Xnmos$2_427 a_n41542_n3981# VSS ML_24 m1_n41445_n3773# nmos$2
Xnmos$2_438 a_n43051_n5289# VSS ML_25 m1_n42954_n5081# nmos$2
Xnmos$2_449 a_n46055_n3981# VSS ML_24 m1_n45958_n3773# nmos$2
Xnmos_5 a_n34324_n28971# VSS a_n34471_n29051# VSS nmos
Xnmos$2_4730 WL_4 VSS SL_20N a_n51035_22409# nmos$2
Xnmos$2_4741 a_n54048_21101# VSS a_n53587_20871# SL_18N nmos$2
Xnmos$5_210 VEVAL VSS m1_n80591_n10313# VSS nmos$5
Xnmos$2_4785 a_n49383_23498# VSS SL_21 a_n49069_23487# nmos$2
Xnmos$2_4752 a_n51035_23717# VSS a_n50574_23487# SL_20N nmos$2
Xnmos$2_4763 WL_4 VSS a_n46369_22190# SL_23 nmos$2
Xnmos$2_4774 a_n49530_22409# VSS a_n49069_22179# SL_21N nmos$2
Xnmos$5_243 VEVAL VSS m1_n74564_n1157# VSS nmos$5
Xnmos$5_221 VEVAL VSS m1_n77577_n9005# VSS nmos$5
Xnmos$5_232 VEVAL VSS m1_n74564_n3773# VSS nmos$5
Xnmos$2_4796 WL_2 VSS a_n47874_24806# SL_22 nmos$2
Xnmos$5_265 VEVAL VSS m1_n68546_n1157# VSS nmos$5
Xnmos$5_276 VEVAL VSS m1_n56504_n11621# VSS nmos$5
Xnmos$5_254 VEVAL VSS m1_n70045_n5081# VSS nmos$5
Xnmos$5_298 VEVAL VSS m1_n62519_n12929# VSS nmos$5
Xnmos$5_287 VEVAL VSS m1_n59505_n6389# VSS nmos$5
Xnmos$2_950 WL_30 VSS SL_4N a_n75122_n11898# nmos$2
Xnmos$2_961 WL_29 VSS SL_6N a_n72108_n10590# nmos$2
Xnmos$2_972 WL_28 VSS SL_6N a_n72108_n9282# nmos$2
Xnmos$2_983 WL_27 VSS a_n73470_n7894# SL_5 nmos$2
Xnmos$2_994 a_n68643_n9213# VSS ML_28 m1_n68546_n9005# nmos$2
Xpmos_40 a_n45017_n11898# VDD a_n44870_n11818# VDD pmos
Xpmos_51 a_n45017_n10590# VDD a_n44870_n10510# VDD pmos
Xpmos_62 a_n43365_n9202# VDD VDD a_n43512_n9282# pmos
Xpmos_84 a_n52396_n11818# VDD VDD a_n52543_n11898# pmos
Xpmos_73 a_n49383_n11818# VDD VDD a_n49530_n11898# pmos
Xpmos_95 a_n52543_n7974# VDD a_n52396_n7894# VDD pmos
Xnmos_701 a_n76483_16958# VSS a_n76630_17177# VSS nmos
Xnmos_734 a_n81002_24806# VSS a_n81149_25025# VSS nmos
Xnmos_723 a_n77988_23498# VSS a_n78135_23717# VSS nmos
Xnmos_712 a_n79497_19574# VSS a_n79644_19793# VSS nmos
Xnmos$2_4004 a_n40498_2789# VSS a_n40037_2559# SL_27N nmos$2
Xnmos_745 a_n74975_24806# VSS a_n75122_25025# VSS nmos
Xnmos_767 a_n59916_22190# VSS a_n60063_22409# VSS nmos
Xnmos_756 a_n56915_19574# VSS a_n57062_19793# VSS nmos
Xnmos$2_4015 a_n41542_3867# VSS ML_18 m1_n41445_4075# nmos$2
Xnmos$2_4037 a_n46055_3867# VSS ML_18 m1_n45958_4075# nmos$2
Xnmos$2_4026 WL_19 VSS a_n43365_2570# SL_25 nmos$2
Xnmos$2_3314 a_n68643_27411# VSS ML_0 m1_n68546_27619# nmos$2
Xnmos$2_3325 a_n70142_26103# VSS ML_1 m1_n70045_26311# nmos$2
Xnmos$2_3303 WL_2 VSS a_n70456_24806# SL_7 nmos$2
Xnmos$2_3336 WL_2 VSS SL_4N a_n75122_25025# nmos$2
Xnmos$5_1002 VEVAL VSS m1_n38432_22387# VSS nmos$5
Xnmos_789 a_n67452_19574# VSS a_n67599_19793# VSS nmos
Xnmos_778 a_n62930_18266# VSS a_n63077_18485# VSS nmos
Xnmos$2_4048 WL_17 VSS m2_n44135_352# a_n45017_5405# nmos$2
Xnmos$2_4059 WL_17 VSS a_n44870_5186# SL_24 nmos$2
Xnmos$5_1013 VEVAL VSS m1_n35418_27619# VSS nmos$5
Xnmos$2_3347 WL_0 VSS a_n71961_27422# SL_6 nmos$2
Xnmos$2_3358 WL_0 VSS SL_5N a_n73617_27641# nmos$2
Xnmos$3_703 a_n57062_23717# VSS VSS a_n56915_23498# nmos$3
Xnmos$3_725 a_n64585_21101# VSS VSS a_n64438_20882# nmos$3
Xnmos$2_3369 WL_7 VSS a_n53901_18266# SL_18 nmos$2
Xnmos$3_714 a_n61572_17177# VSS VSS a_n61425_16958# nmos$3
Xnmos$2_2624 WL_15 VSS a_n77988_7802# SL_2 nmos$2
Xnmos$2_2602 WL_17 VSS SL_1N a_n79644_5405# nmos$2
Xnmos$2_2613 a_n80688_5175# VSS ML_17 m1_n80591_5383# nmos$2
Xnmos$5_1035 VEVAL VSS m1_n53490_151# VSS nmos$5
Xnmos$5_1024 VEVAL VSS m1_n53490_n28774# VSS nmos$5
Xnmos$2_202 a_n49530_n10590# VSS a_n49069_n10521# SL_21N nmos$2
Xnmos$3_747 a_n66090_27641# VSS VSS a_n65943_27422# nmos$3
Xnmos$3_758 a_n60063_26333# VSS VSS a_n59916_26114# nmos$3
Xnmos$3_736 a_n61572_23717# VSS VSS a_n61425_23498# nmos$3
Xnmos$2_2657 WL_15 VSS a_n74975_7802# SL_4 nmos$2
Xnmos$2_2646 a_n77674_6483# VSS ML_16 m1_n77577_6691# nmos$2
Xnmos$5_1046 VEVAL VSS m1_n53490_5383# VSS nmos$5
Xnmos$2_2635 WL_17 VSS SL_3N a_n76630_5405# nmos$2
Xnmos$2_224 a_n52082_n13137# VSS ML_31 m1_n51985_n12929# nmos$2
Xnmos$2_213 WL_30 VSS a_n46369_n11818# SL_23 nmos$2
Xnmos$2_235 a_n50574_n10521# VSS ML_29 m1_n50477_n10313# nmos$2
Xnmos$2_1901 WL_26 VSS SL_10N a_n66090_n6666# nmos$2
Xnmos$2_1912 WL_26 VSS SL_13N a_n61572_n6666# nmos$2
Xnmos$2_2679 a_n76483_10418# VSS SL_3 a_n76169_10407# nmos$2
Xnmos$2_2668 a_n74661_9099# VSS ML_14 m1_n74564_9307# nmos$2
Xnmos$3_769 a_n38990_4097# VSS VSS a_n38843_3878# nmos$3
Xnmos$2_1934 WL_18 VSS SL_16N a_n57062_4097# nmos$2
Xnmos$2_1956 WL_18 VSS SL_14N a_n60063_4097# nmos$2
Xnmos$2_1923 WL_19 VSS SL_17N a_n55557_2789# nmos$2
Xnmos$2_1945 a_n58411_2570# VSS SL_15 a_n58097_2559# nmos$2
Xnmos$2_246 a_n52543_n13206# VSS a_n52082_n13137# SL_19N nmos$2
Xnmos$2_257 WL_28 VSS a_n52396_n9202# SL_19 nmos$2
Xnmos$2_268 a_n50888_n7894# VSS SL_20 a_n50574_n7905# nmos$2
Xnmos$2_1989 WL_15 VSS a_n59916_7802# SL_14 nmos$2
Xnmos$2_1978 a_n60063_6713# VSS a_n59602_6483# SL_14N nmos$2
Xnmos$2_1967 a_n58558_5405# VSS a_n58097_5175# SL_15N nmos$2
Xnmos$2_279 WL_28 VSS SL_22N a_n48021_n9282# nmos$2
Xpmos_1807 a_n41856_2570# VDD VDD a_n42003_2789# pmos
Xpmos_1818 a_n44870_1262# VDD VDD a_n45017_1481# pmos
Xpmos_1829 a_n44870_5186# VDD VDD a_n45017_5405# pmos
Xnmos$2_5250 a_n70603_1481# VSS a_n70142_1251# SL_7N nmos$2
Xnmos$2_5261 a_n72108_1481# VSS a_n71647_1251# SL_6N nmos$2
Xnmos$2_4560 WL_7 VSS m2_n44135_352# a_n45017_18485# nmos$2
Xnmos$2_5272 a_n49069_1251# VSS ML_20 m1_n48972_1459# nmos$2
Xnmos$2_4593 a_n45017_21101# VSS a_n44556_20871# m2_n44135_352# nmos$2
Xnmos$2_4582 WL_6 VSS m2_n44135_352# a_n45017_19793# nmos$2
Xnmos$2_4571 a_n46055_16947# VSS ML_8 m1_n45958_17155# nmos$2
Xnmos$2_3881 a_n34471_10637# VSS a_n34010_10407# SL_31N nmos$2
Xnmos$2_3870 WL_17 VSS a_n35829_5186# SL_30 nmos$2
Xnmos$2_3892 WL_14 VSS a_n34324_9110# SL_31 nmos$2
Xnmos$2_780 a_n34471_n2742# VSS a_n34010_n2673# SL_31N nmos$2
Xnmos$2_791 WL_26 VSS SL_30N a_n35976_n6666# nmos$2
Xnmos$2_1208 a_n76169_n1365# VSS ML_22 m1_n76072_n1157# nmos$2
Xnmos$2_1219 a_n74975_n46# VSS SL_4 a_n74661_n57# nmos$2
Xnmos$1_92 OUTP VSS a_n26151_24108# a_n27618_24108# nmos$1
Xnmos$1_81 a_n28089_13548# VSS a_n27274_14042# m1_n28364_13965# nmos$1
Xnmos$1_70 a_n28089_12110# VSS m1_n26796_12616# a_n26151_12604# nmos$1
Xnmos_542 a_n62930_13034# VSS a_n63077_13253# VSS nmos
Xnmos_531 a_n67452_11726# VSS a_n67599_11945# VSS nmos
Xnmos_520 a_n62930_9110# VSS a_n63077_9329# VSS nmos
Xnmos$2_3100 WL_8 VSS a_n76483_16958# SL_3 nmos$2
Xnmos_564 a_n59916_15650# VSS a_n60063_15869# VSS nmos
Xnmos_553 a_n55410_11726# VSS a_n55557_11945# VSS nmos
Xnmos_586 a_n74975_7802# VSS a_n75122_8021# VSS nmos
Xnmos_575 a_n68957_3878# VSS a_n69104_4097# VSS nmos
Xnmos$2_3111 a_n76169_19563# VSS ML_6 m1_n76072_19771# nmos$2
Xnmos$2_3144 WL_6 VSS a_n81002_19574# SL_0 nmos$2
Xnmos$2_3133 WL_7 VSS a_n81002_18266# SL_0 nmos$2
Xnmos$2_3122 WL_8 VSS a_n77988_16958# SL_2 nmos$2
Xnmos$3_500 a_n67599_5405# VSS VSS a_n67452_5186# nmos$3
Xnmos_597 a_n76483_2570# VSS a_n76630_2789# VSS nmos
Xnmos$2_3166 WL_5 VSS SL_1N a_n79644_21101# nmos$2
Xnmos$2_3177 a_n81149_21101# VSS a_n80688_20871# SL_0N nmos$2
Xnmos$2_3155 WL_8 VSS a_n79497_16958# SL_1 nmos$2
Xnmos$2_2410 a_n57062_15869# VSS a_n56601_15639# SL_16N nmos$2
Xnmos$2_2421 a_n56915_11726# VSS SL_16 a_n56601_11715# nmos$2
Xnmos$3_533 a_n75122_9329# VSS VSS a_n74975_9110# nmos$3
Xnmos$3_522 a_n79644_6713# VSS VSS a_n79497_6494# nmos$3
Xnmos$3_511 a_n75122_4097# VSS VSS a_n74975_3878# nmos$3
Xnmos$2_2432 a_n70456_2570# VSS SL_7 a_n70142_2559# nmos$2
Xnmos$2_3188 WL_3 VSS a_n77988_23498# SL_2 nmos$2
Xnmos$2_3199 a_n76630_22409# VSS a_n76169_22179# SL_3N nmos$2
Xnmos$3_555 a_n81149_15869# VSS VSS a_n81002_15650# nmos$3
Xnmos$3_566 a_n70603_10637# VSS VSS a_n70456_10418# nmos$3
Xnmos$3_544 a_n79644_9329# VSS VSS a_n79497_9110# nmos$3
Xnmos$2_2476 WL_17 VSS a_n71961_5186# SL_6 nmos$2
Xnmos$2_2443 a_n68957_3878# VSS SL_8 a_n68643_3867# nmos$2
Xnmos$2_2465 a_n73470_3878# VSS SL_5 a_n73156_3867# nmos$2
Xnmos$2_2454 a_n72108_2789# VSS a_n71647_2559# SL_6N nmos$2
Xnmos$2_1731 a_n61425_n46# VSS SL_13 a_n61111_n57# nmos$2
Xnmos$2_1720 a_n62930_n1354# VSS SL_12 a_n62616_n1365# nmos$2
Xnmos$3_599 a_n69104_19793# VSS VSS a_n68957_19574# nmos$3
Xnmos$3_588 a_n70603_15869# VSS VSS a_n70456_15650# nmos$3
Xnmos$3_577 a_n72108_11945# VSS VSS a_n71961_11726# nmos$3
Xnmos$2_2498 a_n73470_7802# VSS SL_5 a_n73156_7791# nmos$2
Xnmos$2_2487 WL_17 VSS a_n73470_5186# SL_5 nmos$2
Xnmos$2_1742 a_n61111_n2673# VSS ML_23 m1_n61014_n2465# nmos$2
Xnmos$2_1753 a_n67599_n2742# VSS a_n67138_n2673# SL_9N nmos$2
Xnmos$2_1764 a_n57062_n5358# VSS a_n56601_n5289# SL_16N nmos$2
Xnmos$2_1786 a_n58411_n5278# VSS SL_15 a_n58097_n5289# nmos$2
Xnmos$2_1797 WL_24 VSS SL_15N a_n58558_n4050# nmos$2
Xnmos$2_1775 WL_24 VSS a_n53901_n3970# SL_18 nmos$2
Xpmos_2327 a_n26151_31298# VDD VDD a_n26495_31298# pmos
Xpmos_2316 OUTP VDD VDD a_n28089_27928# pmos
Xpmos_2305 a_n28485_25644# VDD m1_n28364_25469# VDD pmos
Xpmos_2338 a_n27618_24108# VDD VDD m1_n27919_24120# pmos
Xpmos_1604 a_n57062_25025# VDD a_n56915_24806# VDD pmos
Xpmos_1615 a_n58558_25025# VDD a_n58411_24806# VDD pmos
Xpmos_1626 a_n61425_19574# VDD VDD a_n61572_19793# pmos
Xpmos_2349 a_n40351_10418# VDD VDD a_n40498_10637# pmos
Xpmos_1659 a_n26495_8290# VDD COMP16 VDD pmos
Xpmos_1648 a_n26495_5414# VDD VDD m1_n26796_5426# pmos
Xpmos_1637 a_n27618_2538# VDD VDD m1_n27919_2550# pmos
Xpmos_808 a_n57062_n4050# VDD a_n56915_n3970# VDD pmos
Xpmos_819 a_n59916_n1354# VDD VDD a_n60063_n1434# pmos
Xnmos$2_5080 WL_1 VSS a_n34324_26114# SL_31 nmos$2
Xnmos$2_5091 a_n38529_24795# VSS ML_2 m1_n38432_25003# nmos$2
Xnmos$2_4390 WL_12 VSS SL_25N a_n43512_11945# nmos$2
Xnmos$3_7 a_n40498_n29051# VSS VSS a_n40351_n28971# nmos$3
Xnmos$5_809 VEVAL VSS m1_n44459_4075# VSS nmos$5
Xnmos$2_1005 a_n70456_n7894# VSS SL_7 a_n70142_n7905# nmos$2
Xnmos$2_1016 WL_27 VSS a_n68957_n7894# SL_8 nmos$2
Xnmos$2_1049 WL_30 VSS SL_3N a_n76630_n11898# nmos$2
Xnmos$2_1027 WL_31 VSS a_n76483_n13126# SL_3 nmos$2
Xnmos$2_1038 a_n76169_n10521# VSS ML_29 m1_n76072_n10313# nmos$2
Xnmos_361 a_n74975_n46# VSS a_n75122_173# VSS nmos
Xnmos_350 a_n70456_n5278# VSS a_n70603_n5358# VSS nmos
Xnmos_372 a_n74975_n2662# VSS a_n75122_n2742# VSS nmos
Xnmos_383 a_n59916_n11818# VSS a_n60063_n11898# VSS nmos
Xnmos_394 a_n56915_n6586# VSS a_n57062_n6666# VSS nmos
Xnmos$2_2240 a_n65943_15650# VSS SL_10 a_n65629_15639# nmos$2
Xnmos$3_330 a_n66090_n6666# VSS VSS a_n65943_n6586# nmos$3
Xnmos$3_341 a_n63077_n4050# VSS VSS a_n62930_n3970# nmos$3
Xnmos$2_2284 a_n61425_15650# VSS SL_13 a_n61111_15639# nmos$2
Xnmos$2_2262 a_n63077_14561# VSS a_n62616_14331# SL_12N nmos$2
Xnmos$2_2251 a_n65629_14331# VSS ML_10 m1_n65532_14539# nmos$2
Xnmos$2_2273 a_n63077_13253# VSS a_n62616_13023# SL_12N nmos$2
Xnmos$3_385 a_n55557_2789# VSS VSS a_n55410_2570# nmos$3
Xnmos$3_374 a_n58558_n1434# VSS VSS a_n58411_n1354# nmos$3
Xnmos$3_352 a_n63077_n1434# VSS VSS a_n62930_n1354# nmos$3
Xnmos$3_363 a_n57062_n5358# VSS VSS a_n56915_n5278# nmos$3
Xnmos$2_2295 a_n55557_9329# VSS a_n55096_9099# SL_17N nmos$2
Xnmos$3_396 a_n60063_6713# VSS VSS a_n59916_6494# nmos$3
Xnmos$2_1572 WL_31 VSS SL_9N a_n67599_n13206# nmos$2
Xnmos$2_1550 a_n62930_n11818# VSS SL_12 a_n62616_n11829# nmos$2
Xnmos$2_1561 a_n61572_n10590# VSS a_n61111_n10521# SL_13N nmos$2
Xnmos$2_1583 a_n67138_n10521# VSS ML_29 m1_n67041_n10313# nmos$2
Xnmos$2_1594 WL_29 VSS SL_10N a_n66090_n10590# nmos$2
Xpmos_2113 a_n49383_23498# VDD VDD a_n49530_23717# pmos
Xpmos_2102 a_n53901_23498# VDD VDD a_n54048_23717# pmos
Xpmos_2135 a_n49383_26114# VDD VDD a_n49530_26333# pmos
Xpmos_2146 a_n52543_25025# VDD a_n52396_24806# VDD pmos
Xpmos_2124 a_n50888_23498# VDD VDD a_n51035_23717# pmos
Xpmos_1401 a_n76630_22409# VDD a_n76483_22190# VDD pmos
Xpmos_2168 a_n40498_27641# VDD a_n40351_27422# VDD pmos
Xpmos_2157 a_n50888_27422# VDD VDD a_n51035_27641# pmos
Xpmos_2179 a_n43512_26333# VDD a_n43365_26114# VDD pmos
Xpmos_1412 a_n76630_26333# VDD a_n76483_26114# VDD pmos
Xpmos_1434 a_n79644_26333# VDD a_n79497_26114# VDD pmos
Xpmos_1423 a_n81149_25025# VDD a_n81002_24806# VDD pmos
Xpmos_1445 a_n67599_26333# VDD a_n67452_26114# VDD pmos
Xpmos_1456 a_n73617_26333# VDD a_n73470_26114# VDD pmos
Xpmos_1467 a_n56915_16958# VDD VDD a_n57062_17177# pmos
Xpmos_1478 a_n57062_17177# VDD a_n56915_16958# VDD pmos
Xpmos_605 a_n69104_n5358# VDD a_n68957_n5278# VDD pmos
Xpmos_616 a_n74975_n3970# VDD VDD a_n75122_n4050# pmos
Xpmos_1489 a_n58558_19793# VDD a_n58411_19574# VDD pmos
Xpmos_649 a_n69104_173# VDD a_n68957_n46# VDD pmos
Xpmos_638 a_n67599_n2742# VDD a_n67452_n2662# VDD pmos
Xpmos_627 a_n74975_n2662# VDD VDD a_n75122_n2742# pmos
Xnmos_1310 a_n38843_1262# VSS a_n38990_1481# VSS nmos
Xpmos_1990 a_n45017_11945# VDD a_n44870_11726# VDD pmos
Xnmos$1_4 a_n28089_n12336# VSS a_n27274_n11842# m1_n28364_n11919# nmos$1
Xnmos$5_606 VEVAL VSS m1_n68546_21079# VSS nmos$5
Xnmos$5_617 VEVAL VSS m1_n77577_17155# VSS nmos$5
Xnmos$5_639 VEVAL VSS m1_n77577_23695# VSS nmos$5
Xnmos$5_628 VEVAL VSS m1_n79086_21079# VSS nmos$5
Xnmos_60 a_n49383_n6586# VSS a_n49530_n6666# VSS nmos
Xnmos_71 a_n49383_n3970# VSS a_n49530_n4050# VSS nmos
Xnmos_82 a_n49383_n1354# VSS a_n49530_n1434# VSS nmos
Xnmos_93 a_n49383_n2662# VSS a_n49530_n2742# VSS nmos
Xnmos_191 a_n35829_n46# VSS a_n35976_173# VSS nmos
Xnmos_180 a_n34324_n3970# VSS a_n34471_n4050# VSS nmos
Xnmos$3_160 a_n54048_n29051# VSS VSS a_n53901_n28971# nmos$3
Xnmos$2_2081 WL_16 VSS SL_10N a_n66090_6713# nmos$2
Xnmos$2_2092 a_n67138_5175# VSS ML_17 m1_n67041_5383# nmos$2
Xnmos$2_2070 WL_18 VSS a_n65943_3878# SL_10 nmos$2
Xnmos$3_182 a_n69104_n11898# VSS VSS a_n68957_n11818# nmos$3
Xnmos$3_171 a_n79644_n29051# VSS VSS a_n79497_n28971# nmos$3
Xnmos$3_193 a_n73617_n7974# VSS VSS a_n73470_n7894# nmos$3
Xnmos$2_1380 a_n73470_n6586# VSS SL_5 a_n73156_n6597# nmos$2
Xnmos$3_38 a_n49530_n13206# VSS VSS a_n49383_n13126# nmos$3
Xnmos$3_16 a_n42003_n11898# VSS VSS a_n41856_n11818# nmos$3
Xnmos$3_27 a_n45017_n7974# VSS VSS a_n44870_n7894# nmos$3
Xnmos$2_1391 WL_26 VSS a_n77988_n6586# SL_2 nmos$2
Xnmos$3_49 a_n52543_n10590# VSS VSS a_n52396_n10510# nmos$3
Xpmos_1231 a_n76630_14561# VDD a_n76483_14342# VDD pmos
Xpmos_1220 a_n79644_14561# VDD a_n79497_14342# VDD pmos
Xpmos_1253 a_n73617_11945# VDD a_n73470_11726# VDD pmos
Xpmos_1242 a_n69104_9329# VDD a_n68957_9110# VDD pmos
Xpmos_1286 a_n68957_15650# VDD VDD a_n69104_15869# pmos
Xpmos_1275 a_n71961_14342# VDD VDD a_n72108_14561# pmos
Xpmos_1264 a_n71961_13034# VDD VDD a_n72108_13253# pmos
Xpmos_402 a_n40351_n2662# VDD VDD a_n40498_n2742# pmos
Xpmos_435 a_n76483_n28971# VDD VDD a_n76630_n29051# pmos
Xpmos_424 a_n67599_n29051# VDD a_n67452_n28971# VDD pmos
Xpmos_413 a_n55410_n28971# VDD VDD a_n55557_n29051# pmos
Xpmos_1297 a_n70603_17177# VDD a_n70456_16958# VDD pmos
Xpmos_457 a_n74975_n11818# VDD VDD a_n75122_n11898# pmos
Xpmos_446 a_n70456_n13126# VDD VDD a_n70603_n13206# pmos
Xpmos_468 a_n73617_n10590# VDD a_n73470_n10510# VDD pmos
Xpmos_479 a_n68957_n9202# VDD VDD a_n69104_n9282# pmos
Xnmos_1162 ML_6 VSS VSS a_n28485_22768# nmos
Xnmos_1140 a_n26495_18356# VSS m1_n26796_18368# VSS nmos
Xnmos_1151 a_n28485_18454# VSS VSS m1_n28364_18279# nmos
Xnmos_1173 a_n27274_24108# VSS a_n27618_24108# VSS nmos
Xnmos_1184 a_n28485_21330# VSS VSS m1_n28364_21155# nmos
Xnmos_1195 a_n37338_16958# VSS a_n37485_17177# VSS nmos
Xnmos$2_609 a_n37485_n13206# VSS a_n37024_n13137# SL_29N nmos$2
Xnmos$1_119 OUTP VSS a_n26151_31298# a_n27618_31298# nmos$1
Xnmos$1_108 a_n28089_26490# VSS m1_n26796_26996# a_n26151_26984# nmos$1
Xpmos_980 a_n67452_15650# VDD VDD a_n67599_15869# pmos
Xnmos$2_4912 a_n44870_27422# VSS SL_24 a_n44556_27411# nmos$2
Xnmos$2_4934 a_n46369_27422# VSS SL_23 a_n46055_27411# nmos$2
Xnmos$2_4923 a_n46516_26333# VSS a_n46055_26103# SL_23N nmos$2
Xnmos$2_4901 WL_2 VSS a_n43365_24806# SL_25 nmos$2
Xpmos_991 a_n64438_15650# VDD VDD a_n64585_15869# pmos
Xnmos$2_4956 a_n35976_19793# VSS a_n35515_19563# SL_30N nmos$2
Xnmos$2_4945 a_n34471_18485# VSS a_n34010_18255# SL_31N nmos$2
Xnmos$2_4967 a_n37338_18266# VSS SL_29 a_n37024_18255# nmos$2
Xnmos$5_425 VEVAL VSS m1_n64027_7999# VSS nmos$5
Xnmos$5_414 VEVAL VSS m1_n61014_5383# VSS nmos$5
Xnmos$5_403 VEVAL VSS m1_n65532_1459# VSS nmos$5
Xnmos$2_4989 WL_6 VSS SL_29N a_n37485_19793# nmos$2
Xnmos$2_4978 WL_7 VSS a_n38843_18266# SL_28 nmos$2
Xnmos$5_469 VEVAL VSS m1_n58000_14539# VSS nmos$5
Xnmos$5_447 VEVAL VSS m1_n62519_13231# VSS nmos$5
Xnmos$5_436 VEVAL VSS m1_n67041_11923# VSS nmos$5
Xnmos$5_458 VEVAL VSS m1_n56504_9307# VSS nmos$5
Xnmos$5_981 VEVAL VSS m1_n44459_27619# VSS nmos$5
Xnmos$5_970 VEVAL VSS m1_n50477_26311# VSS nmos$5
Xnmos$5_992 VEVAL VSS m1_n33913_19771# VSS nmos$5
Xpmos_1050 a_n55410_14342# VDD VDD a_n55557_14561# pmos
Xpmos_1061 a_n61425_7802# VDD VDD a_n61572_8021# pmos
Xpmos_1094 a_n73470_3878# VDD VDD a_n73617_4097# pmos
Xpmos_1072 a_n70456_2570# VDD VDD a_n70603_2789# pmos
Xpmos_1083 a_n72108_2789# VDD a_n71961_2570# VDD pmos
Xpmos_210 a_n46369_n46# VDD VDD a_n46516_173# pmos
Xpmos_221 a_n42003_n2742# VDD a_n41856_n2662# VDD pmos
Xpmos_232 a_n27274_n13280# VDD VDD a_n27618_n13280# pmos
Xpmos_243 a_n26495_n8966# VDD VDD m1_n26796_n8954# pmos
Xnmos_916 a_n35829_15650# VSS a_n35976_15869# VSS nmos
Xnmos_905 a_n37338_11726# VSS a_n37485_11945# VSS nmos
Xpmos_265 a_n34324_n13126# VDD VDD a_n34471_n13206# pmos
Xpmos_276 a_n38990_n11898# VDD a_n38843_n11818# VDD pmos
Xpmos_254 a_n27618_n8966# VDD VDD m1_n27919_n8954# pmos
Xnmos_949 a_n27274_14042# VSS a_n27618_14042# VSS nmos
Xnmos_927 a_n28485_12702# VSS VSS m1_n28364_12527# nmos
Xnmos_938 OUTP VSS a_n28089_10672# VSS nmos
Xnmos$2_4219 a_n49530_8021# VSS a_n49069_7791# SL_21N nmos$2
Xnmos$2_4208 WL_17 VSS a_n47874_5186# SL_22 nmos$2
Xpmos_298 a_n34471_n10590# VDD a_n34324_n10510# VDD pmos
Xpmos_287 a_n38990_n9282# VDD a_n38843_n9202# VDD pmos
Xnmos$2_3518 a_n62930_18266# VSS SL_12 a_n62616_18255# nmos$2
Xnmos$2_3507 a_n61425_16958# VSS SL_13 a_n61111_16947# nmos$2
Xnmos$2_3529 a_n63077_19793# VSS a_n62616_19563# SL_12N nmos$2
Xnmos$3_907 a_n40498_17177# VSS VSS a_n40351_16958# nmos$3
Xnmos$2_2806 a_n68643_9099# VSS ML_14 m1_n68546_9307# nmos$2
Xnmos$3_929 a_n42003_23717# VSS VSS a_n41856_23498# nmos$3
Xnmos$3_918 a_n43512_19793# VSS VSS a_n43365_19574# nmos$3
Xnmos$2_2828 WL_12 VSS SL_8N a_n69104_11945# nmos$2
Xnmos$2_2839 WL_13 VSS a_n71961_10418# SL_6 nmos$2
Xnmos$2_2817 a_n70456_9110# VSS SL_7 a_n70142_9099# nmos$2
Xnmos$2_406 a_n49530_n2742# VSS a_n49069_n2673# SL_21N nmos$2
Xnmos$2_417 a_n40037_n5289# VSS ML_25 m1_n39940_n5081# nmos$2
Xnmos$2_439 a_n45017_n5358# VSS a_n44556_n5289# m2_n44135_352# nmos$2
Xnmos$2_428 WL_24 VSS SL_26N a_n42003_n4050# nmos$2
Xnmos_6 a_n44870_n28971# VSS a_n45017_n29051# VSS nmos
Xnmos$2_4742 WL_5 VSS SL_18N a_n54048_21101# nmos$2
Xnmos$2_4731 WL_5 VSS a_n50888_20882# SL_20 nmos$2
Xnmos$2_4720 a_n52543_18485# VSS a_n52082_18255# SL_19N nmos$2
Xnmos$5_200 VEVAL VSS m1_n77577_n12929# VSS nmos$5
Xnmos$2_4753 a_n50888_23498# VSS SL_20 a_n50574_23487# nmos$2
Xnmos$2_4775 WL_4 VSS SL_21N a_n49530_22409# nmos$2
Xnmos$2_4764 a_n47874_20882# VSS SL_22 a_n47560_20871# nmos$2
Xnmos$5_244 VEVAL VSS m1_n77577_n1157# VSS nmos$5
Xnmos$5_211 VEVAL VSS m1_n79086_n10313# VSS nmos$5
Xnmos$5_222 VEVAL VSS m1_n77577_n7697# VSS nmos$5
Xnmos$5_233 VEVAL VSS m1_n76072_n3773# VSS nmos$5
Xnmos$2_4797 WL_2 VSS a_n46369_24806# SL_23 nmos$2
Xnmos$2_4786 WL_3 VSS a_n49383_23498# SL_21 nmos$2
Xnmos$5_266 VEVAL VSS m1_n70045_n1157# VSS nmos$5
Xnmos$5_277 VEVAL VSS m1_n54999_n11621# VSS nmos$5
Xnmos$5_255 VEVAL VSS m1_n70045_n3773# VSS nmos$5
Xnmos$2_940 WL_31 VSS SL_4N a_n75122_n13206# nmos$2
Xnmos$5_299 VEVAL VSS m1_n62519_n10313# VSS nmos$5
Xnmos$5_288 VEVAL VSS m1_n59505_n7697# VSS nmos$5
Xnmos$2_951 a_n75122_n10590# VSS a_n74661_n10521# SL_4N nmos$2
Xnmos$2_962 WL_29 VSS a_n71961_n10510# SL_6 nmos$2
Xnmos$2_973 a_n72108_n9282# VSS a_n71647_n9213# SL_6N nmos$2
Xnmos$2_995 a_n67452_n9202# VSS SL_9 a_n67138_n9213# nmos$2
Xnmos$2_984 a_n73470_n7894# VSS SL_5 a_n73156_n7905# nmos$2
Xpmos_30 a_n43365_n13126# VDD VDD a_n43512_n13206# pmos
Xpmos_41 a_n46369_n11818# VDD VDD a_n46516_n11898# pmos
Xpmos_63 a_n43365_n10510# VDD VDD a_n43512_n10590# pmos
Xpmos_52 a_n46369_n7894# VDD VDD a_n46516_n7974# pmos
Xpmos_85 a_n51035_n11898# VDD a_n50888_n11818# VDD pmos
Xpmos_74 a_n47874_n11818# VDD VDD a_n48021_n11898# pmos
Xpmos_96 a_n51035_n7974# VDD a_n50888_n7894# VDD pmos
Xnmos_735 a_n81002_27422# VSS a_n81149_27641# VSS nmos
Xnmos_724 a_n76483_23498# VSS a_n76630_23717# VSS nmos
Xnmos_713 a_n79497_20882# VSS a_n79644_21101# VSS nmos
Xnmos_702 a_n76483_18266# VSS a_n76630_18485# VSS nmos
Xnmos_746 a_n74975_26114# VSS a_n75122_26333# VSS nmos
Xnmos_768 a_n59916_23498# VSS a_n60063_23717# VSS nmos
Xnmos_757 a_n55410_19574# VSS a_n55557_19793# VSS nmos
Xnmos$2_4016 a_n40037_3867# VSS ML_18 m1_n39940_4075# nmos$2
Xnmos$2_4038 a_n44870_3878# VSS SL_24 a_n44556_3867# nmos$2
Xnmos$2_4005 WL_19 VSS SL_27N a_n40498_2789# nmos$2
Xnmos$2_4027 a_n43051_2559# VSS ML_19 m1_n42954_2767# nmos$2
Xnmos$2_3315 a_n68957_27422# VSS SL_8 a_n68643_27411# nmos$2
Xnmos$2_3326 WL_2 VSS a_n68957_24806# SL_8 nmos$2
Xnmos$2_3304 a_n70456_24806# VSS SL_7 a_n70142_24795# nmos$2
Xnmos_779 a_n62930_16958# VSS a_n63077_17177# VSS nmos
Xnmos$2_4049 a_n43365_5186# VSS SL_25 a_n43051_5175# nmos$2
Xnmos$5_1014 VEVAL VSS m1_n33913_27619# VSS nmos$5
Xnmos$2_3348 a_n71647_27411# VSS ML_0 m1_n71550_27619# nmos$2
Xnmos$5_1003 VEVAL VSS m1_n38432_23695# VSS nmos$5
Xnmos$2_3337 a_n73617_25025# VSS a_n73156_24795# SL_5N nmos$2
Xnmos$2_3359 WL_2 VSS SL_5N a_n73617_25025# nmos$2
Xnmos$3_704 a_n58558_21101# VSS VSS a_n58411_20882# nmos$3
Xnmos$3_715 a_n63077_17177# VSS VSS a_n62930_16958# nmos$3
Xnmos$2_2614 WL_15 VSS SL_0N a_n81149_8021# nmos$2
Xnmos$2_2603 a_n79497_5186# VSS SL_1 a_n79183_5175# nmos$2
Xnmos$5_1025 VEVAL VSS m1_n53490_2767# VSS nmos$5
Xnmos$5_1036 VEVAL VSS m1_n53490_n1157# VSS nmos$5
Xnmos$3_759 a_n60063_27641# VSS VSS a_n59916_27422# nmos$3
Xnmos$3_748 a_n64585_27641# VSS VSS a_n64438_27422# nmos$3
Xnmos$3_737 a_n61572_26333# VSS VSS a_n61425_26114# nmos$3
Xnmos$3_726 a_n64585_22409# VSS VSS a_n64438_22190# nmos$3
Xnmos$2_2658 a_n74975_7802# VSS SL_4 a_n74661_7791# nmos$2
Xnmos$5_1047 VEVAL VSS m1_n53490_6691# VSS nmos$5
Xnmos$2_2647 a_n76483_6494# VSS SL_3 a_n76169_6483# nmos$2
Xnmos$2_2636 WL_17 VSS a_n74975_5186# SL_4 nmos$2
Xnmos$2_2625 WL_17 VSS a_n79497_5186# SL_1 nmos$2
Xnmos$2_214 a_n47874_n11818# VSS SL_22 a_n47560_n11829# nmos$2
Xnmos$2_203 a_n48021_n11898# VSS a_n47560_n11829# SL_22N nmos$2
Xnmos$2_225 a_n52396_n10510# VSS SL_19 a_n52082_n10521# nmos$2
Xnmos$2_1902 WL_26 VSS a_n64438_n6586# SL_11 nmos$2
Xnmos$2_1913 a_n61425_n6586# VSS SL_13 a_n61111_n6597# nmos$2
Xnmos$2_2669 WL_14 VSS SL_3N a_n76630_9329# nmos$2
Xnmos$2_1935 a_n53901_3878# VSS SL_18 a_n53587_3867# nmos$2
Xnmos$2_1924 a_n53587_2559# VSS ML_19 m1_n53490_2767# nmos$2
Xnmos$2_1946 WL_19 VSS a_n56915_2570# SL_16 nmos$2
Xnmos$2_247 WL_31 VSS SL_19N a_n52543_n13206# nmos$2
Xnmos$2_236 a_n50888_n10510# VSS SL_20 a_n50574_n10521# nmos$2
Xnmos$2_258 a_n52082_n9213# VSS ML_28 m1_n51985_n9005# nmos$2
Xnmos$2_269 WL_27 VSS SL_20N a_n51035_n7974# nmos$2
Xnmos$2_1968 a_n58558_6713# VSS a_n58097_6483# SL_15N nmos$2
Xnmos$2_1979 WL_17 VSS a_n59916_5186# SL_14 nmos$2
Xnmos$2_1957 WL_18 VSS a_n59916_3878# SL_14 nmos$2
Xpmos_1808 a_n41856_1262# VDD VDD a_n42003_1481# pmos
Xpmos_1819 a_n44870_2570# VDD VDD a_n45017_2789# pmos
Xnmos$2_5251 WL_20 VSS SL_7N a_n70603_1481# nmos$2
Xnmos$2_5262 a_n71961_1262# VSS SL_6 a_n71647_1251# nmos$2
Xnmos$2_5240 a_n73156_1251# VSS ML_20 m1_n73059_1459# nmos$2
Xnmos$2_4550 a_n42003_18485# VSS a_n41542_18255# SL_26N nmos$2
Xnmos$2_5273 a_n49530_1481# VSS a_n49069_1251# SL_21N nmos$2
Xnmos$2_4583 a_n44556_18255# VSS ML_7 m1_n44459_18463# nmos$2
Xnmos$2_4561 WL_8 VSS a_n43365_16958# SL_25 nmos$2
Xnmos$2_4572 a_n46516_17177# VSS a_n46055_16947# SL_23N nmos$2
Xnmos$2_4594 a_n43051_22179# VSS ML_4 m1_n42954_22387# nmos$2
Xnmos$2_3882 WL_14 VSS SL_31N a_n34471_9329# nmos$2
Xnmos$2_3860 WL_17 VSS a_n34324_5186# SL_31 nmos$2
Xnmos$2_3871 a_n35829_5186# VSS SL_30 a_n35515_5175# nmos$2
Xnmos$2_3893 a_n34324_9110# VSS SL_31 a_n34010_9099# nmos$2
Xnmos$2_781 WL_23 VSS SL_31N a_n34471_n2742# nmos$2
Xnmos$2_770 WL_23 VSS a_n34324_n2662# SL_31 nmos$2
Xnmos$2_792 WL_26 VSS SL_31N a_n34471_n6666# nmos$2
Xnmos$2_1209 WL_22 VSS a_n76483_n1354# SL_3 nmos$2
Xnmos$1_93 a_n28089_22176# VSS a_n27274_22670# m1_n28364_22593# nmos$1
Xnmos$1_82 OUTP VSS a_n26151_14042# a_n27618_14042# nmos$1
Xnmos$1_71 OUTP VSS a_n26151_12604# a_n27618_12604# nmos$1
Xnmos$1_60 a_n28089_7796# VSS a_n27274_8290# m1_n28364_8213# nmos$1
Xnmos_510 a_n61425_5186# VSS a_n61572_5405# VSS nmos
Xnmos_543 a_n64438_13034# VSS a_n64585_13253# VSS nmos
Xnmos_532 a_n65943_11726# VSS a_n66090_11945# VSS nmos
Xnmos_521 a_n61425_10418# VSS a_n61572_10637# VSS nmos
Xnmos$2_3101 WL_8 VSS SL_2N a_n78135_17177# nmos$2
Xnmos_565 a_n58411_15650# VSS a_n58558_15869# VSS nmos
Xnmos_554 a_n58411_10418# VSS a_n58558_10637# VSS nmos
Xnmos_576 a_n71961_2570# VSS a_n72108_2789# VSS nmos
Xnmos$2_3112 a_n76483_19574# VSS SL_3 a_n76169_19563# nmos$2
Xnmos$2_3123 a_n77988_16958# VSS SL_2 a_n77674_16947# nmos$2
Xnmos$2_3134 a_n81002_16958# VSS SL_0 a_n80688_16947# nmos$2
Xnmos_587 a_n71961_7802# VSS a_n72108_8021# VSS nmos
Xnmos_598 a_n77988_2570# VSS a_n78135_2789# VSS nmos
Xnmos$2_3178 WL_3 VSS SL_0N a_n81149_23717# nmos$2
Xnmos$2_3167 a_n79644_21101# VSS a_n79183_20871# SL_1N nmos$2
Xnmos$2_3156 a_n79183_20871# VSS ML_5 m1_n79086_21079# nmos$2
Xnmos$2_3145 a_n81002_19574# VSS SL_0 a_n80688_19563# nmos$2
Xnmos$2_2411 WL_9 VSS SL_16N a_n57062_15869# nmos$2
Xnmos$2_2400 WL_10 VSS SL_16N a_n57062_14561# nmos$2
Xnmos$3_534 a_n75122_10637# VSS VSS a_n74975_10418# nmos$3
Xnmos$2_2422 a_n56915_9110# VSS SL_16 a_n56601_9099# nmos$2
Xnmos$3_501 a_n70603_6713# VSS VSS a_n70456_6494# nmos$3
Xnmos$3_523 a_n81149_6713# VSS VSS a_n81002_6494# nmos$3
Xnmos$2_2433 a_n70142_2559# VSS ML_19 m1_n70045_2767# nmos$2
Xnmos$3_512 a_n78135_2789# VSS VSS a_n77988_2570# nmos$3
Xnmos$2_3189 WL_4 VSS a_n79497_22190# SL_1 nmos$2
Xnmos$3_556 a_n78135_15869# VSS VSS a_n77988_15650# nmos$3
Xnmos$3_567 a_n70603_11945# VSS VSS a_n70456_11726# nmos$3
Xnmos$3_545 a_n79644_11945# VSS VSS a_n79497_11726# nmos$3
Xnmos$2_2444 a_n67452_3878# VSS SL_9 a_n67138_3867# nmos$2
Xnmos$2_2466 a_n73156_3867# VSS ML_18 m1_n73059_4075# nmos$2
Xnmos$2_2455 WL_19 VSS SL_4N a_n75122_2789# nmos$2
Xnmos$2_1721 WL_22 VSS SL_11N a_n64585_n1434# nmos$2
Xnmos$2_1710 a_n65629_n1365# VSS ML_22 m1_n65532_n1157# nmos$2
Xnmos$3_589 a_n67599_15869# VSS VSS a_n67452_15650# nmos$3
Xnmos$3_578 a_n72108_13253# VSS VSS a_n71961_13034# nmos$3
Xnmos$2_2499 a_n73617_8021# VSS a_n73156_7791# SL_5N nmos$2
Xnmos$2_2477 a_n71961_5186# VSS SL_6 a_n71647_5175# nmos$2
Xnmos$2_2488 a_n73156_5175# VSS ML_17 m1_n73059_5383# nmos$2
Xnmos$2_1732 WL_21 VSS SL_13N a_n61572_173# nmos$2
Xnmos$2_1743 WL_23 VSS a_n61425_n2662# SL_13 nmos$2
Xnmos$2_1754 WL_23 VSS a_n64438_n2662# SL_11 nmos$2
Xnmos$2_1787 WL_25 VSS a_n59916_n5278# SL_14 nmos$2
Xnmos$2_1765 a_n56601_n5289# VSS ML_25 m1_n56504_n5081# nmos$2
Xnmos$2_1798 WL_24 VSS a_n56915_n3970# SL_16 nmos$2
Xnmos$2_1776 a_n53587_n3981# VSS ML_24 m1_n53490_n3773# nmos$2
Xpmos_2317 a_n26495_31298# VDD COMP0 VDD pmos
Xpmos_2328 OUTP VDD VDD a_n28089_29366# pmos
Xpmos_2306 a_n28485_27082# VDD m1_n28364_26907# VDD pmos
Xpmos_1616 a_n58558_27641# VDD a_n58411_27422# VDD pmos
Xpmos_1605 a_n59916_24806# VDD VDD a_n60063_25025# pmos
Xpmos_2339 a_n26151_24108# VDD VDD a_n26495_24108# pmos
Xpmos_1627 OUTP VDD VDD a_n28089_3482# pmos
Xpmos_1649 a_n26151_5414# VDD VDD a_n26495_5414# pmos
Xpmos_1638 OUTP VDD VDD a_n28089_2044# pmos
Xpmos_809 a_n58558_n4050# VDD a_n58411_n3970# VDD pmos
Xnmos$2_5070 a_n35976_27641# VSS a_n35515_27411# SL_30N nmos$2
Xnmos$2_5081 a_n34010_26103# VSS ML_1 m1_n33913_26311# nmos$2
Xnmos$2_5092 WL_2 VSS SL_28N a_n38990_25025# nmos$2
Xnmos$2_4391 a_n41542_11715# VSS ML_12 m1_n41445_11923# nmos$2
Xnmos$2_4380 a_n41856_10418# VSS SL_26 a_n41542_10407# nmos$2
Xnmos$2_3690 a_n67138_27411# VSS ML_0 m1_n67041_27619# nmos$2
Xnmos$3_8 a_n49530_n29051# VSS VSS a_n49383_n28971# nmos$3
Xnmos$2_1017 a_n74661_n13137# VSS ML_31 m1_n74564_n12929# nmos$2
Xnmos$2_1006 WL_27 VSS a_n70456_n7894# SL_7 nmos$2
Xnmos$2_1028 a_n76169_n11829# VSS ML_30 m1_n76072_n11621# nmos$2
Xnmos$2_1039 a_n76483_n10510# VSS SL_3 a_n76169_n10521# nmos$2
Xnmos_340 a_n79497_n46# VSS a_n79644_173# VSS nmos
Xnmos_351 a_n70456_n3970# VSS a_n70603_n4050# VSS nmos
Xnmos_362 a_n71961_n46# VSS a_n72108_173# VSS nmos
Xnmos_373 a_n71961_n2662# VSS a_n72108_n2742# VSS nmos
Xnmos_384 a_n58411_n11818# VSS a_n58558_n11898# VSS nmos
Xnmos_395 a_n56915_n7894# VSS a_n57062_n7974# VSS nmos
Xnmos$2_2241 a_n67138_15639# VSS ML_9 m1_n67041_15847# nmos$2
Xnmos$2_2230 a_n67599_14561# VSS a_n67138_14331# SL_9N nmos$2
Xnmos$3_320 a_n61572_n10590# VSS VSS a_n61425_n10510# nmos$3
Xnmos$3_331 a_n64585_n6666# VSS VSS a_n64438_n6586# nmos$3
Xnmos$3_342 a_n61572_n4050# VSS VSS a_n61425_n3970# nmos$3
Xnmos$2_2274 a_n64585_15869# VSS a_n64124_15639# SL_11N nmos$2
Xnmos$2_2263 a_n62616_14331# VSS ML_10 m1_n62519_14539# nmos$2
Xnmos$2_2252 a_n61425_13034# VSS SL_13 a_n61111_13023# nmos$2
Xnmos$3_353 a_n63077_173# VSS VSS a_n62930_n46# nmos$3
Xnmos$3_375 a_n54048_n1434# VSS VSS a_n53901_n1354# nmos$3
Xnmos$3_364 a_n60063_n5358# VSS VSS a_n59916_n5278# nmos$3
Xnmos$2_2285 WL_9 VSS SL_12N a_n63077_15869# nmos$2
Xnmos$2_2296 WL_14 VSS SL_17N a_n55557_9329# nmos$2
Xnmos$3_397 a_n60063_5405# VSS VSS a_n59916_5186# nmos$3
Xnmos$3_386 a_n55557_4097# VSS VSS a_n55410_3878# nmos$3
Xnmos$2_1573 a_n67599_n13206# VSS a_n67138_n13137# SL_9N nmos$2
Xnmos$2_1562 WL_30 VSS SL_12N a_n63077_n11898# nmos$2
Xnmos$2_1540 a_n64585_n10590# VSS a_n64124_n10521# SL_11N nmos$2
Xnmos$2_1551 WL_29 VSS a_n62930_n10510# SL_12 nmos$2
Xnmos$2_1584 WL_29 VSS SL_9N a_n67599_n10590# nmos$2
Xnmos$2_1595 a_n65629_n10521# VSS ML_29 m1_n65532_n10313# nmos$2
Xpmos_2103 a_n52543_23717# VDD a_n52396_23498# VDD pmos
Xpmos_2136 a_n49530_26333# VDD a_n49383_26114# VDD pmos
Xpmos_1402 a_n76630_23717# VDD a_n76483_23498# VDD pmos
Xpmos_2114 a_n49383_22190# VDD VDD a_n49530_22409# pmos
Xpmos_2125 a_n50888_18266# VDD VDD a_n51035_18485# pmos
Xpmos_1424 a_n81149_27641# VDD a_n81002_27422# VDD pmos
Xpmos_2169 a_n41856_26114# VDD VDD a_n42003_26333# pmos
Xpmos_1413 a_n77988_26114# VDD VDD a_n78135_26333# pmos
Xpmos_2158 a_n50888_24806# VDD VDD a_n51035_25025# pmos
Xpmos_2147 a_n53901_24806# VDD VDD a_n54048_25025# pmos
Xpmos_1435 a_n67599_25025# VDD a_n67452_24806# VDD pmos
Xpmos_1446 a_n67599_27641# VDD a_n67452_27422# VDD pmos
Xpmos_1457 a_n73617_27641# VDD a_n73470_27422# VDD pmos
Xpmos_1468 a_n55557_17177# VDD a_n55410_16958# VDD pmos
Xpmos_617 a_n72108_n4050# VDD a_n71961_n3970# VDD pmos
Xpmos_606 a_n69104_n4050# VDD a_n68957_n3970# VDD pmos
Xpmos_1479 a_n59916_16958# VDD VDD a_n60063_17177# pmos
Xpmos_639 a_n67599_n1434# VDD a_n67452_n1354# VDD pmos
Xpmos_628 a_n73617_n1434# VDD a_n73470_n1354# VDD pmos
Xnmos_1311 a_n46369_1262# VSS a_n46516_1481# VSS nmos
Xnmos_1300 a_n81002_1262# VSS a_n81149_1481# VSS nmos
Xpmos_1980 a_n41856_11726# VDD VDD a_n42003_11945# pmos
Xpmos_1991 a_n43512_11945# VDD a_n43365_11726# VDD pmos
Xnmos$1_5 OUTP VSS m1_n27919_n13268# a_n27274_n13280# nmos$1
Xnmos$5_607 VEVAL VSS m1_n68546_22387# VSS nmos$5
Xnmos$5_618 VEVAL VSS m1_n77577_19771# VSS nmos$5
Xnmos$5_629 VEVAL VSS m1_n80591_21079# VSS nmos$5
Xnmos_50 a_n52396_n11818# VSS a_n52543_n11898# VSS nmos
Xnmos_61 a_n47874_n7894# VSS a_n48021_n7974# VSS nmos
Xnmos_83 a_n49383_n46# VSS a_n49530_173# VSS nmos
Xnmos_94 a_n41856_n5278# VSS a_n42003_n5358# VSS nmos
Xnmos_72 a_n47874_n3970# VSS a_n48021_n4050# VSS nmos
Xnmos_192 a_n34324_n46# VSS a_n34471_173# VSS nmos
Xnmos_170 a_n37338_n6586# VSS a_n37485_n6666# VSS nmos
Xnmos_181 a_n37338_n5278# VSS a_n37485_n5358# VSS nmos
Xnmos$3_150 a_n34471_n1434# VSS VSS a_n34324_n1354# nmos$3
Xnmos$2_2082 WL_16 VSS a_n64438_6494# SL_11 nmos$2
Xnmos$2_2071 a_n65943_3878# VSS SL_10 a_n65629_3867# nmos$2
Xnmos$2_2060 WL_19 VSS a_n64438_2570# SL_11 nmos$2
Xnmos$3_172 a_n78135_n29051# VSS VSS a_n77988_n28971# nmos$3
Xnmos$3_161 a_n66090_n29051# VSS VSS a_n65943_n28971# nmos$3
Xnmos$3_183 a_n69104_n10590# VSS VSS a_n68957_n10510# nmos$3
Xnmos$2_2093 WL_16 VSS SL_9N a_n67599_6713# nmos$2
Xnmos$3_194 a_n72108_n7974# VSS VSS a_n71961_n7894# nmos$3
Xnmos$2_1370 WL_26 VSS SL_2N a_n78135_n6666# nmos$2
Xnmos$2_1381 a_n74661_n6597# VSS ML_26 m1_n74564_n6389# nmos$2
Xnmos$3_17 a_n40498_n11898# VSS VSS a_n40351_n11818# nmos$3
Xnmos$2_1392 a_n77988_n6586# VSS SL_2 a_n77674_n6597# nmos$2
Xnmos$3_28 a_n45017_n6666# VSS VSS a_n44870_n6586# nmos$3
Xnmos$3_39 a_n49530_n10590# VSS VSS a_n49383_n10510# nmos$3
Xpmos_1210 a_n81002_13034# VDD VDD a_n81149_13253# pmos
Xpmos_1232 a_n77988_14342# VDD VDD a_n78135_14561# pmos
Xpmos_1221 a_n78135_14561# VDD a_n77988_14342# VDD pmos
Xpmos_1243 a_n70603_10637# VDD a_n70456_10418# VDD pmos
Xpmos_1276 a_n73470_15650# VDD VDD a_n73617_15869# pmos
Xpmos_1265 a_n72108_13253# VDD a_n71961_13034# VDD pmos
Xpmos_1254 a_n74975_11726# VDD VDD a_n75122_11945# pmos
Xpmos_403 a_n40351_n1354# VDD VDD a_n40498_n1434# pmos
Xpmos_425 a_n68957_n28971# VDD VDD a_n69104_n29051# pmos
Xpmos_414 a_n60063_n29051# VDD a_n59916_n28971# VDD pmos
Xpmos_1298 a_n70456_19574# VDD VDD a_n70603_19793# pmos
Xpmos_1287 a_n69104_14561# VDD a_n68957_14342# VDD pmos
Xpmos_447 a_n70456_n11818# VDD VDD a_n70603_n11898# pmos
Xpmos_458 a_n73617_n11898# VDD a_n73470_n11818# VDD pmos
Xpmos_436 a_n78135_n29051# VDD a_n77988_n28971# VDD pmos
Xpmos_469 a_n74975_n10510# VDD VDD a_n75122_n10590# pmos
Xnmos_1130 a_n43365_24806# VSS a_n43512_25025# VSS nmos
Xnmos_1141 a_n26151_18356# VSS a_n26495_18356# VSS nmos
Xnmos_1163 ML_8 VSS VSS a_n28485_19892# nmos
Xnmos_1152 a_n27274_16918# VSS a_n27618_16918# VSS nmos
Xnmos_1174 OUTP VSS a_n28089_23614# VSS nmos
Xnmos_1185 a_n28485_24206# VSS VSS m1_n28364_24031# nmos
Xnmos_1196 a_n38843_18266# VSS a_n38990_18485# VSS nmos
Xnmos$1_109 OUTP VSS a_n26151_25546# a_n27618_25546# nmos$1
Xpmos_981 a_n66090_15869# VDD a_n65943_15650# VDD pmos
Xpmos_970 a_n65943_11726# VDD VDD a_n66090_11945# pmos
Xnmos$2_4913 a_n43051_27411# VSS ML_0 m1_n42954_27619# nmos$2
Xnmos$2_4924 WL_1 VSS a_n44870_26114# SL_24 nmos$2
Xnmos$2_4902 a_n45017_25025# VSS a_n44556_24795# m2_n44135_352# nmos$2
Xpmos_992 a_n63077_15869# VDD a_n62930_15650# VDD pmos
Xnmos$2_4957 a_n34324_19574# VSS SL_31 a_n34010_19563# nmos$2
Xnmos$2_4935 a_n46369_20882# VSS SL_23 a_n46055_20871# nmos$2
Xnmos$2_4946 a_n34324_18266# VSS SL_31 a_n34010_18255# nmos$2
Xnmos$2_4968 WL_7 VSS a_n37338_18266# SL_29 nmos$2
Xnmos$5_426 VEVAL VSS m1_n61014_9307# VSS nmos$5
Xnmos$5_415 VEVAL VSS m1_n61014_6691# VSS nmos$5
Xnmos$5_404 VEVAL VSS m1_n67041_2767# VSS nmos$5
Xnmos$2_4979 WL_7 VSS SL_28N a_n38990_18485# nmos$2
Xnmos$5_448 VEVAL VSS m1_n62519_15847# VSS nmos$5
Xnmos$5_437 VEVAL VSS m1_n65532_11923# VSS nmos$5
Xnmos$5_459 VEVAL VSS m1_n56504_10615# VSS nmos$5
Xnmos$5_982 VEVAL VSS m1_n44459_26311# VSS nmos$5
Xnmos$5_971 VEVAL VSS m1_n51985_26311# VSS nmos$5
Xnmos$5_960 VEVAL VSS m1_n47463_25003# VSS nmos$5
Xnmos$5_993 VEVAL VSS m1_n36927_17155# VSS nmos$5
Xpmos_1051 a_n54048_14561# VDD a_n53901_14342# VDD pmos
Xpmos_1040 a_n60063_14561# VDD a_n59916_14342# VDD pmos
Xpmos_200 a_n43512_n4050# VDD a_n43365_n3970# VDD pmos
Xpmos_1073 a_n70603_2789# VDD a_n70456_2570# VDD pmos
Xpmos_1095 a_n73470_2570# VDD VDD a_n73617_2789# pmos
Xpmos_1062 a_n61425_1262# VDD VDD a_n61572_1481# pmos
Xpmos_1084 a_n72108_1481# VDD a_n71961_1262# VDD pmos
Xpmos_222 a_n43365_n46# VDD VDD a_n43512_173# pmos
Xpmos_211 a_n45017_173# VDD a_n44870_n46# VDD pmos
Xpmos_233 OUTP VDD VDD a_n28089_n12336# pmos
Xnmos_917 a_n34324_15650# VSS a_n34471_15869# VSS nmos
Xnmos_906 a_n37338_14342# VSS a_n37485_14561# VSS nmos
Xpmos_266 a_n34471_n13206# VDD a_n34324_n13126# VDD pmos
Xpmos_277 a_n37338_n11818# VDD VDD a_n37485_n11898# pmos
Xpmos_255 OUTP VDD VDD a_n28089_n9460# pmos
Xpmos_244 a_n27274_n7528# VDD VDD a_n27618_n7528# pmos
Xnmos_928 a_n27618_11166# VSS m1_n27919_11178# VSS nmos
Xnmos_939 ML_13 VSS VSS a_n28485_12702# nmos
Xnmos$2_4209 WL_16 VSS a_n49383_6494# SL_21 nmos$2
Xpmos_288 a_n38843_n10510# VDD VDD a_n38990_n10590# pmos
Xpmos_299 a_n35829_n10510# VDD VDD a_n35976_n10590# pmos
Xnmos$2_3508 WL_8 VSS a_n61425_16958# SL_13 nmos$2
Xnmos$3_908 a_n40498_18485# VSS VSS a_n40351_18266# nmos$3
Xnmos$2_3519 WL_8 VSS SL_11N a_n64585_17177# nmos$2
Xnmos$2_2807 WL_13 VSS SL_8N a_n69104_10637# nmos$2
Xnmos$3_919 a_n43512_21101# VSS VSS a_n43365_20882# nmos$3
Xnmos$2_2829 a_n68643_11715# VSS ML_12 m1_n68546_11923# nmos$2
Xnmos$2_2818 WL_14 VSS SL_7N a_n70603_9329# nmos$2
Xnmos$2_407 WL_23 VSS SL_21N a_n49530_n2742# nmos$2
Xnmos$2_418 a_n43512_n5358# VSS a_n43051_n5289# SL_25N nmos$2
Xnmos$2_429 WL_24 VSS a_n40351_n3970# SL_27 nmos$2
Xnmos_7 a_n43365_n28971# VSS a_n43512_n29051# VSS nmos
Xnmos$2_4732 WL_4 VSS a_n50888_22190# SL_20 nmos$2
Xnmos$2_4710 a_n52396_19574# VSS SL_19 a_n52082_19563# nmos$2
Xnmos$2_4721 WL_7 VSS SL_19N a_n52543_18485# nmos$2
Xnmos$5_201 VEVAL VSS m1_n77577_n11621# VSS nmos$5
Xnmos$2_4765 a_n48021_21101# VSS a_n47560_20871# SL_22N nmos$2
Xnmos$2_4776 a_n49069_22179# VSS ML_4 m1_n48972_22387# nmos$2
Xnmos$2_4754 WL_5 VSS SL_19N a_n52543_21101# nmos$2
Xnmos$2_4743 a_n52396_20882# VSS SL_19 a_n52082_20871# nmos$2
Xnmos$5_212 VEVAL VSS m1_n79086_n11621# VSS nmos$5
Xnmos$5_223 VEVAL VSS m1_n77577_n6389# VSS nmos$5
Xnmos$5_234 VEVAL VSS m1_n79086_n5081# VSS nmos$5
Xnmos$2_4798 a_n47560_24795# VSS ML_2 m1_n47463_25003# nmos$2
Xnmos$2_4787 a_n48021_23717# VSS a_n47560_23487# SL_22N nmos$2
Xnmos$5_267 VEVAL VSS m1_n70045_151# VSS nmos$5
Xnmos$5_245 VEVAL VSS m1_n77577_151# VSS nmos$5
Xnmos$5_256 VEVAL VSS m1_n68546_n3773# VSS nmos$5
Xnmos$2_930 WL_31 VSS a_n68957_n13126# SL_8 nmos$2
Xnmos$5_278 VEVAL VSS m1_n54999_n10313# VSS nmos$5
Xnmos$5_289 VEVAL VSS m1_n58000_n7697# VSS nmos$5
Xnmos$2_963 a_n71647_n11829# VSS ML_30 m1_n71550_n11621# nmos$2
Xnmos$2_941 a_n73156_n13137# VSS ML_31 m1_n73059_n12929# nmos$2
Xnmos$2_952 a_n73156_n10521# VSS ML_29 m1_n73059_n10313# nmos$2
Xnmos$2_974 WL_28 VSS a_n73470_n9202# SL_5 nmos$2
Xnmos$2_996 a_n69104_n9282# VSS a_n68643_n9213# SL_8N nmos$2
Xnmos$2_985 a_n73617_n7974# VSS a_n73156_n7905# SL_5N nmos$2
Xpmos_20 a_n50888_n28971# VDD VDD a_n51035_n29051# pmos
Xpmos_31 a_n42003_n13206# VDD a_n41856_n13126# VDD pmos
Xpmos_42 a_n43512_n11898# VDD a_n43365_n11818# VDD pmos
Xpmos_53 a_n45017_n7974# VDD a_n44870_n7894# VDD pmos
Xpmos_75 a_n46516_n11898# VDD a_n46369_n11818# VDD pmos
Xpmos_86 a_n51035_n9282# VDD a_n50888_n9202# VDD pmos
Xpmos_64 a_n42003_n7974# VDD a_n41856_n7894# VDD pmos
Xpmos_97 a_n52396_n7894# VDD VDD a_n52543_n7974# pmos
Xnmos$5_790 VEVAL VSS m1_n38432_15847# VSS nmos$5
Xnmos_725 a_n76483_26114# VSS a_n76630_26333# VSS nmos
Xnmos_714 a_n79497_22190# VSS a_n79644_22409# VSS nmos
Xnmos_703 a_n77988_16958# VSS a_n78135_17177# VSS nmos
Xnmos_747 a_n74975_27422# VSS a_n75122_27641# VSS nmos
Xnmos_736 a_n79497_27422# VSS a_n79644_27641# VSS nmos
Xnmos_758 a_n58411_16958# VSS a_n58558_17177# VSS nmos
Xnmos$2_4017 WL_18 VSS a_n40351_3878# SL_27 nmos$2
Xnmos$2_4006 WL_19 VSS SL_25N a_n43512_2789# nmos$2
Xnmos$2_4028 a_n45017_2789# VSS a_n44556_2559# m2_n44135_352# nmos$2
Xnmos$2_3305 WL_0 VSS a_n70456_27422# SL_7 nmos$2
Xnmos$2_3327 WL_1 VSS a_n68957_26114# SL_8 nmos$2
Xnmos$2_3316 WL_1 VSS a_n70456_26114# SL_7 nmos$2
Xnmos_769 a_n58411_23498# VSS a_n58558_23717# VSS nmos
Xnmos$2_4039 WL_18 VSS m2_n44135_352# a_n45017_4097# nmos$2
Xnmos$2_3349 a_n72108_27641# VSS a_n71647_27411# SL_6N nmos$2
Xnmos$5_1015 VEVAL VSS m1_n33913_26311# VSS nmos$5
Xnmos$5_1004 VEVAL VSS m1_n36927_23695# VSS nmos$5
Xnmos$2_3338 a_n73156_24795# VSS ML_2 m1_n73059_25003# nmos$2
Xnmos$3_705 a_n58558_23717# VSS VSS a_n58411_23498# nmos$3
Xnmos$3_716 a_n63077_18485# VSS VSS a_n62930_18266# nmos$3
Xnmos$2_2615 a_n81149_8021# VSS a_n80688_7791# SL_0N nmos$2
Xnmos$2_2604 a_n81149_6713# VSS a_n80688_6483# SL_0N nmos$2
Xnmos$5_1026 VEVAL VSS m1_n53490_n6389# VSS nmos$5
Xnmos$3_749 a_n54048_25025# VSS VSS a_n53901_24806# nmos$3
Xnmos$3_738 a_n61572_25025# VSS VSS a_n61425_24806# nmos$3
Xnmos$5_1048 VEVAL VSS m1_n53490_21079# VSS nmos$5
Xnmos$3_727 a_n66090_22409# VSS VSS a_n65943_22190# nmos$3
Xnmos$2_2626 WL_16 VSS a_n79497_6494# SL_1 nmos$2
Xnmos$2_2637 a_n76630_5405# VSS a_n76169_5175# SL_3N nmos$2
Xnmos$2_2648 a_n78135_5405# VSS a_n77674_5175# SL_2N nmos$2
Xnmos$5_1037 VEVAL VSS m1_n53490_1459# VSS nmos$5
Xnmos$2_215 a_n51035_n13206# VSS a_n50574_n13137# SL_20N nmos$2
Xnmos$2_226 WL_30 VSS a_n52396_n11818# SL_19 nmos$2
Xnmos$2_204 WL_29 VSS a_n47874_n10510# SL_22 nmos$2
Xnmos$2_1903 a_n65943_n6586# VSS SL_10 a_n65629_n6597# nmos$2
Xnmos$2_2659 a_n74661_7791# VSS ML_15 m1_n74564_7999# nmos$2
Xnmos$2_1936 WL_18 VSS SL_17N a_n55557_4097# nmos$2
Xnmos$2_1925 WL_19 VSS a_n55410_2570# SL_17 nmos$2
Xnmos$2_1947 WL_19 VSS SL_15N a_n58558_2789# nmos$2
Xnmos$2_248 a_n52543_n11898# VSS a_n52082_n11829# SL_19N nmos$2
Xnmos$2_237 a_n51035_n10590# VSS a_n50574_n10521# SL_20N nmos$2
Xnmos$2_259 a_n52396_n9202# VSS SL_19 a_n52082_n9213# nmos$2
Xnmos$2_1914 a_n63077_n6666# VSS a_n62616_n6597# SL_12N nmos$2
Xnmos$2_1969 WL_17 VSS SL_15N a_n58558_5405# nmos$2
Xnmos$2_1958 WL_18 VSS a_n56915_3878# SL_16 nmos$2
Xpmos_1809 a_n43365_1262# VDD VDD a_n43512_1481# pmos
Xnmos$2_5230 a_n67452_1262# VSS SL_9 a_n67138_1251# nmos$2
Xnmos$2_5252 a_n70142_1251# VSS ML_20 m1_n70045_1459# nmos$2
Xnmos$2_5241 a_n73617_1481# VSS a_n73156_1251# SL_5N nmos$2
Xnmos$2_4540 WL_6 VSS SL_25N a_n43512_19793# nmos$2
Xnmos$2_4551 a_n42003_17177# VSS a_n41542_16947# SL_26N nmos$2
Xnmos$2_5274 WL_20 VSS SL_21N a_n49530_1481# nmos$2
Xnmos$2_5263 WL_20 VSS a_n71961_1262# SL_6 nmos$2
Xnmos$2_4573 a_n46055_19563# VSS ML_6 m1_n45958_19771# nmos$2
Xnmos$2_4562 WL_8 VSS m2_n44135_352# a_n45017_17177# nmos$2
Xnmos$2_4584 a_n44556_16947# VSS ML_8 m1_n44459_17155# nmos$2
Xnmos$2_4595 WL_5 VSS m2_n44135_352# a_n45017_21101# nmos$2
Xnmos$2_3861 a_n35976_6713# VSS a_n35515_6483# SL_30N nmos$2
Xnmos$2_3872 WL_16 VSS a_n35829_6494# SL_30 nmos$2
Xnmos$2_3850 WL_17 VSS SL_31N a_n34471_5405# nmos$2
Xnmos$2_3883 WL_13 VSS SL_31N a_n34471_10637# nmos$2
Xnmos$2_3894 WL_14 VSS SL_30N a_n35976_9329# nmos$2
Xnmos$2_771 a_n34324_n2662# VSS SL_31 a_n34010_n2673# nmos$2
Xnmos$2_782 a_n35515_n2673# VSS ML_23 m1_n35418_n2465# nmos$2
Xnmos$2_760 a_n35829_n2662# VSS SL_30 a_n35515_n2673# nmos$2
Xnmos$2_793 a_n34471_n6666# VSS a_n34010_n6597# SL_31N nmos$2
Xnmos$1_50 OUTP VSS m1_n27919_3988# a_n27274_3976# nmos$1
Xnmos$1_83 OUTP VSS m1_n27919_15492# a_n27274_15480# nmos$1
Xnmos$1_72 OUTP VSS a_n26151_11166# a_n27618_11166# nmos$1
Xnmos$1_61 OUTP VSS m1_n27919_8302# a_n27274_8290# nmos$1
Xnmos$1_94 OUTP VSS m1_n27919_22682# a_n27274_22670# nmos$1
Xnmos_500 a_n67452_2570# VSS a_n67599_2789# VSS nmos
Xnmos_533 a_n65943_14342# VSS a_n66090_14561# VSS nmos
Xnmos_522 a_n64438_9110# VSS a_n64585_9329# VSS nmos
Xnmos_511 a_n62930_6494# VSS a_n63077_6713# VSS nmos
Xnmos_566 a_n55410_14342# VSS a_n55557_14561# VSS nmos
Xnmos_544 a_n64438_14342# VSS a_n64585_14561# VSS nmos
Xnmos_555 a_n58411_9110# VSS a_n58558_9329# VSS nmos
Xnmos_577 a_n74975_2570# VSS a_n75122_2789# VSS nmos
Xnmos$2_3113 WL_6 VSS a_n76483_19574# SL_3 nmos$2
Xnmos$2_3135 WL_7 VSS SL_0N a_n81149_18485# nmos$2
Xnmos$2_3102 a_n78135_17177# VSS a_n77674_16947# SL_2N nmos$2
Xnmos$2_3124 a_n79497_16958# VSS SL_1 a_n79183_16947# nmos$2
Xnmos_588 a_n73470_7802# VSS a_n73617_8021# VSS nmos
Xnmos_599 a_n77988_3878# VSS a_n78135_4097# VSS nmos
Xnmos$2_3157 a_n79497_20882# VSS SL_1 a_n79183_20871# nmos$2
Xnmos$2_3146 a_n80688_19563# VSS ML_6 m1_n80591_19771# nmos$2
Xnmos$2_3168 a_n80688_20871# VSS ML_5 m1_n80591_21079# nmos$2
Xnmos$2_2412 WL_9 VSS SL_17N a_n55557_15869# nmos$2
Xnmos$2_2401 WL_11 VSS a_n55410_13034# SL_17 nmos$2
Xnmos$2_2423 a_n56915_10418# VSS SL_16 a_n56601_10407# nmos$2
Xnmos$3_524 a_n79644_8021# VSS VSS a_n79497_7802# nmos$3
Xnmos$3_502 a_n70603_5405# VSS VSS a_n70456_5186# nmos$3
Xnmos$3_513 a_n79644_2789# VSS VSS a_n79497_2570# nmos$3
Xnmos$2_3179 a_n81149_23717# VSS a_n80688_23487# SL_0N nmos$2
Xnmos$3_557 a_n75122_14561# VSS VSS a_n74975_14342# nmos$3
Xnmos$3_546 a_n81149_11945# VSS VSS a_n81002_11726# nmos$3
Xnmos$3_535 a_n76630_9329# VSS VSS a_n76483_9110# nmos$3
Xnmos$2_2445 WL_18 VSS a_n67452_3878# SL_9 nmos$2
Xnmos$2_2434 WL_19 VSS a_n70456_2570# SL_7 nmos$2
Xnmos$2_2456 a_n75122_2789# VSS a_n74661_2559# SL_4N nmos$2
Xnmos$2_1711 a_n65629_n57# VSS ML_21 m1_n65532_151# nmos$2
Xnmos$2_1700 a_n67138_n57# VSS ML_21 m1_n67041_151# nmos$2
Xnmos$2_1722 a_n64585_n1434# VSS a_n64124_n1365# SL_11N nmos$2
Xnmos$3_579 a_n72108_14561# VSS VSS a_n71961_14342# nmos$3
Xnmos$3_568 a_n67599_11945# VSS VSS a_n67452_11726# nmos$3
Xnmos$2_2478 WL_17 VSS SL_6N a_n72108_5405# nmos$2
Xnmos$2_2489 a_n73617_5405# VSS a_n73156_5175# SL_5N nmos$2
Xnmos$2_2467 a_n72108_4097# VSS a_n71647_3867# SL_6N nmos$2
Xnmos$2_1733 a_n61572_173# VSS a_n61111_n57# SL_13N nmos$2
Xnmos$2_1744 a_n61425_n2662# VSS SL_13 a_n61111_n2673# nmos$2
Xnmos$2_1755 a_n64438_n2662# VSS SL_11 a_n64124_n2673# nmos$2
Xnmos$2_1788 a_n60063_n5358# VSS a_n59602_n5289# SL_14N nmos$2
Xnmos$2_1766 WL_25 VSS a_n55410_n5278# SL_17 nmos$2
Xnmos$2_1777 WL_24 VSS SL_17N a_n55557_n4050# nmos$2
Xnmos$2_1799 a_n58411_n3970# VSS SL_15 a_n58097_n3981# nmos$2
Xpmos_2329 a_n26151_29860# VDD VDD a_n26495_29860# pmos
Xpmos_2318 a_n27618_29860# VDD VDD m1_n27919_29872# pmos
Xpmos_2307 a_n26151_26984# VDD VDD a_n26495_26984# pmos
Xpmos_1617 a_n58558_26333# VDD a_n58411_26114# VDD pmos
Xpmos_1606 a_n60063_25025# VDD a_n59916_24806# VDD pmos
Xpmos_1628 a_n26151_3976# VDD VDD a_n26495_3976# pmos
Xpmos_1639 a_n26151_2538# VDD VDD a_n26495_2538# pmos
Xnmos$2_5060 a_n34010_24795# VSS ML_2 m1_n33913_25003# nmos$2
Xnmos$2_5071 WL_0 VSS SL_30N a_n35976_27641# nmos$2
Xnmos$2_5082 a_n34471_26333# VSS a_n34010_26103# SL_31N nmos$2
Xnmos$2_5093 a_n38990_25025# VSS a_n38529_24795# SL_28N nmos$2
Xnmos$2_4392 WL_12 VSS a_n41856_11726# SL_26 nmos$2
Xnmos$2_4370 a_n40498_10637# VSS a_n40037_10407# SL_27N nmos$2
Xnmos$2_4381 a_n41542_10407# VSS ML_13 m1_n41445_10615# nmos$2
Xnmos$2_3691 WL_0 VSS SL_9N a_n67599_27641# nmos$2
Xnmos$2_3680 a_n64124_24795# VSS ML_2 m1_n64027_25003# nmos$2
Xnmos$2_2990 a_n73617_18485# VSS a_n73156_18255# SL_5N nmos$2
Xnmos$2_590 a_n35515_n13137# VSS ML_31 m1_n35418_n12929# nmos$2
Xnmos$3_9 a_n48021_n29051# VSS VSS a_n47874_n28971# nmos$3
Xnmos$2_1007 a_n70603_n7974# VSS a_n70142_n7905# SL_7N nmos$2
Xnmos$2_1018 a_n74975_n13126# VSS SL_4 a_n74661_n13137# nmos$2
Xnmos$2_1029 WL_29 VSS SL_2N a_n78135_n10590# nmos$2
Xnmos_341 a_n76483_n1354# VSS a_n76630_n1434# VSS nmos
Xnmos_330 a_n77988_n5278# VSS a_n78135_n5358# VSS nmos
Xnmos_352 a_n68957_n3970# VSS a_n69104_n4050# VSS nmos
Xnmos_363 a_n73470_n1354# VSS a_n73617_n1434# VSS nmos
Xnmos_374 a_n55410_n13126# VSS a_n55557_n13206# VSS nmos
Xnmos_385 a_n58411_n10510# VSS a_n58558_n10590# VSS nmos
Xnmos_396 a_n55410_n6586# VSS a_n55557_n6666# VSS nmos
Xnmos$2_2220 WL_10 VSS SL_10N a_n66090_14561# nmos$2
Xnmos$2_2231 WL_11 VSS a_n65943_13034# SL_10 nmos$2
Xnmos$3_321 a_n64585_n13206# VSS VSS a_n64438_n13126# nmos$3
Xnmos$3_310 a_n55557_n9282# VSS VSS a_n55410_n9202# nmos$3
Xnmos$3_332 a_n64585_n7974# VSS VSS a_n64438_n7894# nmos$3
Xnmos$2_2275 a_n63077_15869# VSS a_n62616_15639# SL_12N nmos$2
Xnmos$2_2242 WL_9 VSS a_n65943_15650# SL_10 nmos$2
Xnmos$2_2253 WL_10 VSS SL_13N a_n61572_14561# nmos$2
Xnmos$2_2264 WL_10 VSS SL_11N a_n64585_14561# nmos$2
Xnmos$3_354 a_n61572_173# VSS VSS a_n61425_n46# nmos$3
Xnmos$3_376 a_n55557_n1434# VSS VSS a_n55410_n1354# nmos$3
Xnmos$2_1530 WL_31 VSS a_n61425_n13126# SL_13 nmos$2
Xnmos$3_343 a_n64585_n5358# VSS VSS a_n64438_n5278# nmos$3
Xnmos$3_365 a_n60063_n4050# VSS VSS a_n59916_n3970# nmos$3
Xnmos$2_2286 WL_11 VSS SL_12N a_n63077_13253# nmos$2
Xnmos$2_2297 WL_13 VSS SL_17N a_n55557_10637# nmos$2
Xnmos$3_398 a_n60063_8021# VSS VSS a_n59916_7802# nmos$3
Xnmos$3_387 a_n54048_4097# VSS VSS a_n53901_3878# nmos$3
Xnmos$2_1563 WL_31 VSS SL_12N a_n63077_n13206# nmos$2
Xnmos$2_1541 WL_29 VSS SL_11N a_n64585_n10590# nmos$2
Xnmos$2_1552 a_n61111_n10521# VSS ML_29 m1_n61014_n10313# nmos$2
Xnmos$2_1574 a_n67138_n13137# VSS ML_31 m1_n67041_n12929# nmos$2
Xnmos$2_1596 a_n65629_n11829# VSS ML_30 m1_n65532_n11621# nmos$2
Xnmos$2_1585 a_n66090_n10590# VSS a_n65629_n10521# SL_10N nmos$2
Xpmos_2104 a_n51035_23717# VDD a_n50888_23498# VDD pmos
Xpmos_2137 a_n47874_27422# VDD VDD a_n48021_27641# pmos
Xpmos_2115 a_n49530_22409# VDD a_n49383_22190# VDD pmos
Xpmos_2126 a_n50888_16958# VDD VDD a_n51035_17177# pmos
Xpmos_1414 a_n77988_27422# VDD VDD a_n78135_27641# pmos
Xpmos_1425 a_n81002_27422# VDD VDD a_n81149_27641# pmos
Xpmos_2148 a_n52543_26333# VDD a_n52396_26114# VDD pmos
Xpmos_2159 a_n41856_24806# VDD VDD a_n42003_25025# pmos
Xpmos_1403 a_n77988_23498# VDD VDD a_n78135_23717# pmos
Xpmos_1458 a_n71961_27422# VDD VDD a_n72108_27641# pmos
Xpmos_1436 a_n68957_24806# VDD VDD a_n69104_25025# pmos
Xpmos_1447 a_n69104_25025# VDD a_n68957_24806# VDD pmos
Xpmos_1469 a_n56915_19574# VDD VDD a_n57062_19793# pmos
Xpmos_607 a_n71961_n5278# VDD VDD a_n72108_n5358# pmos
Xpmos_629 a_n73617_n2742# VDD a_n73470_n2662# VDD pmos
Xpmos_618 a_n71961_n3970# VDD VDD a_n72108_n4050# pmos
Xnmos_1312 a_n44870_1262# VSS a_n45017_1481# VSS nmos
Xnmos_1301 a_n79497_1262# VSS a_n79644_1481# VSS nmos
Xpmos_1970 a_n50888_13034# VDD VDD a_n51035_13253# pmos
Xpmos_1981 a_n43365_10418# VDD VDD a_n43512_10637# pmos
Xpmos_1992 a_n44870_11726# VDD VDD a_n45017_11945# pmos
Xnmos$1_6 OUTP VSS a_n26151_n11842# a_n27618_n11842# nmos$1
Xnmos$5_608 VEVAL VSS m1_n70045_21079# VSS nmos$5
Xnmos$5_619 VEVAL VSS m1_n76072_19771# VSS nmos$5
Xnmos_40 a_n49383_n13126# VSS a_n49530_n13206# VSS nmos
Xnmos_51 a_n52396_n9202# VSS a_n52543_n9282# VSS nmos
Xnmos_62 a_n47874_n6586# VSS a_n48021_n6666# VSS nmos
Xnmos_84 a_n47874_n46# VSS a_n48021_173# VSS nmos
Xnmos_73 a_n52396_n5278# VSS a_n52543_n5358# VSS nmos
Xnmos_95 a_n43365_n5278# VSS a_n43512_n5358# VSS nmos
Xnmos_160 a_n38843_n13126# VSS a_n38990_n13206# VSS nmos
Xnmos_193 a_n37338_n2662# VSS a_n37485_n2742# VSS nmos
Xnmos_171 a_n34324_n9202# VSS a_n34471_n9282# VSS nmos
Xnmos_182 a_n38843_n5278# VSS a_n38990_n5358# VSS nmos
Xnmos$2_2050 a_n62616_3867# VSS ML_18 m1_n62519_4075# nmos$2
Xnmos$3_151 a_n34471_173# VSS VSS a_n34324_n46# nmos$3
Xnmos$3_140 a_n38990_n5358# VSS VSS a_n38843_n5278# nmos$3
Xnmos$2_2083 a_n64438_6494# VSS SL_11 a_n64124_6483# nmos$2
Xnmos$2_2072 WL_18 VSS SL_9N a_n67599_4097# nmos$2
Xnmos$2_2061 a_n64438_2570# VSS SL_11 a_n64124_2559# nmos$2
Xnmos$3_184 a_n72108_n13206# VSS VSS a_n71961_n13126# nmos$3
Xnmos$3_173 a_n81149_n29051# VSS VSS a_n81002_n28971# nmos$3
Xnmos$3_162 a_n63077_n29051# VSS VSS a_n62930_n28971# nmos$3
Xnmos$2_2094 a_n65943_5186# VSS SL_10 a_n65629_5175# nmos$2
Xnmos$2_1360 WL_23 VSS a_n67452_n2662# SL_9 nmos$2
Xnmos$2_1371 a_n78135_n6666# VSS a_n77674_n6597# SL_2N nmos$2
Xnmos$3_195 a_n72108_n6666# VSS VSS a_n71961_n6586# nmos$3
Xnmos$3_18 a_n40498_n10590# VSS VSS a_n40351_n10510# nmos$3
Xnmos$2_1382 WL_26 VSS a_n79497_n6586# SL_1 nmos$2
Xnmos$2_1393 a_n79497_n6586# VSS SL_1 a_n79183_n6597# nmos$2
Xnmos$3_29 a_n43512_n6666# VSS VSS a_n43365_n6586# nmos$3
Xpmos_1200 a_n79644_11945# VDD a_n79497_11726# VDD pmos
Xpmos_1211 a_n81149_15869# VDD a_n81002_15650# VDD pmos
Xpmos_1233 a_n76483_14342# VDD VDD a_n76630_14561# pmos
Xpmos_1222 a_n76483_13034# VDD VDD a_n76630_13253# pmos
Xpmos_1244 a_n69104_10637# VDD a_n68957_10418# VDD pmos
Xpmos_1277 a_n73617_14561# VDD a_n73470_14342# VDD pmos
Xpmos_1266 a_n74975_13034# VDD VDD a_n75122_13253# pmos
Xpmos_1255 a_n71961_11726# VDD VDD a_n72108_11945# pmos
Xpmos_426 a_n74975_n28971# VDD VDD a_n75122_n29051# pmos
Xpmos_415 a_n63077_n29051# VDD a_n62930_n28971# VDD pmos
Xpmos_404 a_n40351_n10510# VDD VDD a_n40498_n10590# pmos
Xpmos_1299 a_n70456_18266# VDD VDD a_n70603_18485# pmos
Xpmos_1288 a_n69104_15869# VDD a_n68957_15650# VDD pmos
Xpmos_448 a_n70603_n11898# VDD a_n70456_n11818# VDD pmos
Xpmos_459 a_n72108_n11898# VDD a_n71961_n11818# VDD pmos
Xpmos_437 a_n79644_n29051# VDD a_n79497_n28971# VDD pmos
Xnmos_1120 a_n52396_26114# VSS a_n52543_26333# VSS nmos
Xnmos_1131 a_n43365_26114# VSS a_n43512_26333# VSS nmos
Xnmos_1153 a_n27618_18356# VSS m1_n27919_18368# VSS nmos
Xnmos_1142 a_n26495_16918# VSS m1_n26796_16930# VSS nmos
Xnmos_1186 a_n26495_24108# VSS VSS COMP5 nmos
Xnmos_1175 a_n28485_22768# VSS VSS m1_n28364_22593# nmos
Xnmos_1164 ML_4 VSS VSS a_n28485_25644# nmos
Xnmos_1197 a_n38843_16958# VSS a_n38990_17177# VSS nmos
Xpmos_971 a_n64585_11945# VDD a_n64438_11726# VDD pmos
Xpmos_960 a_n61572_10637# VDD a_n61425_10418# VDD pmos
Xnmos$2_4914 WL_0 VSS a_n43365_27422# SL_25 nmos$2
Xnmos$2_4925 a_n44870_26114# VSS SL_24 a_n44556_26103# nmos$2
Xnmos$2_4903 WL_2 VSS a_n44870_24806# SL_24 nmos$2
Xpmos_993 a_n61572_15869# VDD a_n61425_15650# VDD pmos
Xpmos_982 a_n64585_15869# VDD a_n64438_15650# VDD pmos
Xnmos$2_4936 a_n46369_22190# VSS SL_23 a_n46055_22179# nmos$2
Xnmos$2_4958 WL_6 VSS a_n34324_19574# SL_31 nmos$2
Xnmos$2_4947 a_n35976_18485# VSS a_n35515_18255# SL_30N nmos$2
Xnmos$5_416 VEVAL VSS m1_n62519_5383# VSS nmos$5
Xnmos$5_405 VEVAL VSS m1_n67041_1459# VSS nmos$5
Xnmos$2_4969 a_n37485_18485# VSS a_n37024_18255# SL_29N nmos$2
Xnmos$5_449 VEVAL VSS m1_n61014_15847# VSS nmos$5
Xnmos$5_438 VEVAL VSS m1_n65532_13231# VSS nmos$5
Xnmos$5_427 VEVAL VSS m1_n61014_10615# VSS nmos$5
Xnmos$5_972 VEVAL VSS m1_n39940_25003# VSS nmos$5
Xnmos$5_961 VEVAL VSS m1_n48972_25003# VSS nmos$5
Xnmos$5_950 VEVAL VSS m1_n51985_22387# VSS nmos$5
Xnmos$5_983 VEVAL VSS m1_n45958_26311# VSS nmos$5
Xnmos$5_994 VEVAL VSS m1_n36927_18463# VSS nmos$5
Xnmos$2_1190 WL_21 VSS a_n81002_n46# SL_0 nmos$2
Xpmos_1052 a_n55557_14561# VDD a_n55410_14342# VDD pmos
Xpmos_1041 a_n58558_13253# VDD a_n58411_13034# VDD pmos
Xpmos_1030 a_n59916_13034# VDD VDD a_n60063_13253# pmos
Xpmos_1063 a_n61425_5186# VDD VDD a_n61572_5405# pmos
Xpmos_1074 a_n70456_3878# VDD VDD a_n70603_4097# pmos
Xpmos_1085 a_n73617_1481# VDD a_n73470_1262# VDD pmos
Xpmos_223 a_n42003_173# VDD a_n41856_n46# VDD pmos
Xpmos_212 a_n44870_n46# VDD VDD a_n45017_173# pmos
Xpmos_234 m2_n30953_n9084# VDD m1_n28364_n11919# VDD pmos
Xpmos_201 a_n44870_n3970# VDD VDD a_n45017_n4050# pmos
Xnmos_907 a_n37338_13034# VSS a_n37485_13253# VSS nmos
Xpmos_1096 a_n71961_6494# VDD VDD a_n72108_6713# pmos
Xpmos_267 a_n35829_n13126# VDD VDD a_n35976_n13206# pmos
Xpmos_256 a_n28485_n7430# VDD m1_n28364_n7605# VDD pmos
Xpmos_245 a_n26495_n7528# VDD COMP27 VDD pmos
Xnmos_929 a_n28485_11264# VSS VSS m1_n28364_11089# nmos
Xnmos_918 OUTP VSS a_n28089_9234# VSS nmos
Xpmos_278 a_n35976_n11898# VDD a_n35829_n11818# VDD pmos
Xpmos_289 a_n38990_n7974# VDD a_n38843_n7894# VDD pmos
Xnmos$2_3509 WL_7 VSS a_n61425_18266# SL_13 nmos$2
Xnmos$3_909 a_n42003_18485# VSS VSS a_n41856_18266# nmos$3
Xnmos$2_2808 a_n68957_10418# VSS SL_8 a_n68643_10407# nmos$2
Xnmos$2_2819 a_n70603_9329# VSS a_n70142_9099# SL_7N nmos$2
Xnmos$2_408 a_n49383_n2662# VSS SL_21 a_n49069_n2673# nmos$2
Xnmos$2_419 a_n41856_n5278# VSS SL_26 a_n41542_n5289# nmos$2
Xnmos_8 a_n41856_n28971# VSS a_n42003_n29051# VSS nmos
Xnmos$2_4700 WL_7 VSS a_n52396_18266# SL_19 nmos$2
Xpmos_790 a_n55557_n5358# VDD a_n55410_n5278# VDD pmos
Xnmos$2_4733 a_n50888_20882# VSS SL_20 a_n50574_20871# nmos$2
Xnmos$2_4722 a_n52543_19793# VSS a_n52082_19563# SL_19N nmos$2
Xnmos$2_4711 WL_6 VSS SL_18N a_n54048_19793# nmos$2
Xnmos$2_4744 WL_3 VSS a_n52396_23498# SL_19 nmos$2
Xnmos$2_4755 WL_4 VSS SL_19N a_n52543_22409# nmos$2
Xnmos$2_4766 a_n47560_20871# VSS ML_5 m1_n47463_21079# nmos$2
Xnmos$5_202 VEVAL VSS m1_n77577_n10313# VSS nmos$5
Xnmos$5_213 VEVAL VSS m1_n79086_n9005# VSS nmos$5
Xnmos$5_224 VEVAL VSS m1_n74564_n6389# VSS nmos$5
Xnmos$5_235 VEVAL VSS m1_n80591_n5081# VSS nmos$5
Xnmos$2_4799 a_n49530_25025# VSS a_n49069_24795# SL_21N nmos$2
Xnmos$2_4788 WL_3 VSS SL_22N a_n48021_23717# nmos$2
Xnmos$2_4777 WL_4 VSS a_n49383_22190# SL_21 nmos$2
Xnmos$5_268 VEVAL VSS m1_n68546_151# VSS nmos$5
Xnmos$5_246 VEVAL VSS m1_n74564_151# VSS nmos$5
Xnmos$5_257 VEVAL VSS m1_n71550_n5081# VSS nmos$5
Xnmos$2_931 WL_30 VSS a_n68957_n11818# SL_8 nmos$2
Xnmos$5_279 VEVAL VSS m1_n58000_n12929# VSS nmos$5
Xnmos$2_920 a_n67452_n10510# VSS SL_9 a_n67138_n10521# nmos$2
Xnmos$2_942 a_n75122_n13206# VSS a_n74661_n13137# SL_4N nmos$2
Xnmos$2_953 a_n73617_n10590# VSS a_n73156_n10521# SL_5N nmos$2
Xnmos$2_964 a_n71647_n10521# VSS ML_29 m1_n71550_n10313# nmos$2
Xnmos$2_975 a_n73156_n9213# VSS ML_28 m1_n73059_n9005# nmos$2
Xnmos$2_997 WL_28 VSS SL_8N a_n69104_n9282# nmos$2
Xnmos$2_986 a_n71647_n7905# VSS ML_27 m1_n71550_n7697# nmos$2
Xpmos_10 a_n41856_n28971# VDD VDD a_n42003_n29051# pmos
Xpmos_21 a_n51035_n29051# VDD a_n50888_n28971# VDD pmos
Xpmos_43 a_n44870_n11818# VDD VDD a_n45017_n11898# pmos
Xpmos_32 a_n43365_n11818# VDD VDD a_n43512_n11898# pmos
Xpmos_54 a_n43512_n7974# VDD a_n43365_n7894# VDD pmos
Xpmos_76 a_n48021_n11898# VDD a_n47874_n11818# VDD pmos
Xpmos_87 a_n51035_n10590# VDD a_n50888_n10510# VDD pmos
Xpmos_65 a_n43365_n7894# VDD VDD a_n43512_n7974# pmos
Xpmos_98 a_n47874_n10510# VDD VDD a_n48021_n10590# pmos
Xnmos$5_780 VEVAL VSS m1_n36927_9307# VSS nmos$5
Xnmos$5_791 VEVAL VSS m1_n36927_15847# VSS nmos$5
Xnmos_726 a_n76483_24806# VSS a_n76630_25025# VSS nmos
Xnmos_715 a_n81002_22190# VSS a_n81149_22409# VSS nmos
Xnmos_704 a_n77988_18266# VSS a_n78135_18485# VSS nmos
Xnmos_748 a_n71961_27422# VSS a_n72108_27641# VSS nmos
Xnmos_737 a_n68957_24806# VSS a_n69104_25025# VSS nmos
Xnmos_759 a_n58411_18266# VSS a_n58558_18485# VSS nmos
Xnmos$2_4018 WL_18 VSS SL_26N a_n42003_4097# nmos$2
Xnmos$2_4007 a_n41856_2570# VSS SL_26 a_n41542_2559# nmos$2
Xnmos$2_4029 WL_19 VSS SL_23N a_n46516_2789# nmos$2
Xnmos$2_3306 WL_0 VSS SL_7N a_n70603_27641# nmos$2
Xnmos$2_3317 a_n70456_26114# VSS SL_7 a_n70142_26103# nmos$2
Xnmos$2_3328 WL_0 VSS a_n68957_27422# SL_8 nmos$2
Xnmos$5_1016 VEVAL VSS m1_n35418_26311# VSS nmos$5
Xnmos$2_3339 a_n73470_24806# VSS SL_5 a_n73156_24795# nmos$2
Xnmos$5_1005 VEVAL VSS m1_n33913_22387# VSS nmos$5
Xnmos$3_706 a_n58558_22409# VSS VSS a_n58411_22190# nmos$3
Xnmos$5_1027 VEVAL VSS m1_n53490_17155# VSS nmos$5
Xnmos$2_2605 a_n81002_5186# VSS SL_0 a_n80688_5175# nmos$2
Xnmos$3_739 a_n63077_25025# VSS VSS a_n62930_24806# nmos$3
Xnmos$3_728 a_n66090_21101# VSS VSS a_n65943_20882# nmos$3
Xnmos$3_717 a_n63077_19793# VSS VSS a_n62930_19574# nmos$3
Xnmos$5_1049 VEVAL VSS m1_n53490_9307# VSS nmos$5
Xnmos$2_2627 WL_15 VSS a_n79497_7802# SL_1 nmos$2
Xnmos$2_2616 WL_15 VSS a_n81002_7802# SL_0 nmos$2
Xnmos$2_2649 a_n76169_6483# VSS ML_16 m1_n76072_6691# nmos$2
Xnmos$2_2638 WL_16 VSS a_n76483_6494# SL_3 nmos$2
Xnmos$5_1038 VEVAL VSS m1_n53490_n2465# VSS nmos$5
Xnmos$2_216 a_n50888_n13126# VSS SL_20 a_n50574_n13137# nmos$2
Xnmos$2_205 WL_29 VSS a_n46369_n10510# SL_23 nmos$2
Xnmos$2_1904 WL_26 VSS a_n65943_n6586# SL_10 nmos$2
Xnmos$2_1937 WL_18 VSS a_n53901_3878# SL_18 nmos$2
Xnmos$2_1926 a_n57062_2789# VSS a_n56601_2559# SL_16N nmos$2
Xnmos$2_227 a_n52082_n11829# VSS ML_30 m1_n51985_n11621# nmos$2
Xnmos$2_249 WL_30 VSS SL_19N a_n52543_n11898# nmos$2
Xnmos$2_238 WL_29 VSS a_n50888_n10510# SL_20 nmos$2
Xnmos$2_1915 a_n62616_n6597# VSS ML_26 m1_n62519_n6389# nmos$2
Xnmos$2_1959 a_n58558_4097# VSS a_n58097_3867# SL_15N nmos$2
Xnmos$2_1948 a_n60063_2789# VSS a_n59602_2559# SL_14N nmos$2
Xnmos$2_5220 a_n59602_1251# VSS ML_20 m1_n59505_1459# nmos$2
Xnmos$2_5253 WL_20 VSS SL_11N a_n64585_1481# nmos$2
Xnmos$2_5231 a_n68957_1262# VSS SL_8 a_n68643_1251# nmos$2
Xnmos$2_5242 WL_20 VSS SL_4N a_n75122_1481# nmos$2
Xnmos$2_4541 a_n43512_19793# VSS a_n43051_19563# SL_25N nmos$2
Xnmos$2_4530 a_n41542_16947# VSS ML_8 m1_n41445_17155# nmos$2
Xnmos$2_5275 a_n49383_1262# VSS SL_21 a_n49069_1251# nmos$2
Xnmos$2_5264 a_n71647_1251# VSS ML_20 m1_n71550_1459# nmos$2
Xnmos$2_4552 a_n42003_19793# VSS a_n41542_19563# SL_26N nmos$2
Xnmos$2_4574 a_n46516_19793# VSS a_n46055_19563# SL_23N nmos$2
Xnmos$2_4563 a_n44870_18266# VSS SL_24 a_n44556_18255# nmos$2
Xnmos$2_3840 a_n38843_7802# VSS SL_28 a_n38529_7791# nmos$2
Xnmos$2_4596 WL_5 VSS SL_23N a_n46516_21101# nmos$2
Xnmos$2_4585 a_n44556_19563# VSS ML_6 m1_n44459_19771# nmos$2
Xnmos$2_3862 WL_15 VSS a_n34324_7802# SL_31 nmos$2
Xnmos$2_3851 a_n34010_6483# VSS ML_16 m1_n33913_6691# nmos$2
Xnmos$2_3873 a_n35829_6494# VSS SL_30 a_n35515_6483# nmos$2
Xnmos$2_3895 a_n35976_10637# VSS a_n35515_10407# SL_30N nmos$2
Xnmos$2_3884 a_n34010_9099# VSS ML_14 m1_n33913_9307# nmos$2
Xnmos$2_750 a_n34324_n46# VSS SL_31 a_n34010_n57# nmos$2
Xnmos$2_761 WL_23 VSS a_n35829_n2662# SL_30 nmos$2
Xnmos$2_772 a_n37024_n2673# VSS ML_23 m1_n36927_n2465# nmos$2
Xnmos$2_783 a_n35976_n2742# VSS a_n35515_n2673# SL_30N nmos$2
Xnmos$2_794 a_n34010_n6597# VSS ML_26 m1_n33913_n6389# nmos$2
Xnmos$1_40 OUTP VSS a_n26151_1100# a_n27618_1100# nmos$1
Xnmos$1_84 OUTP VSS a_n26151_18356# a_n27618_18356# nmos$1
Xnmos$1_73 a_n28089_10672# VSS a_n27274_11166# m1_n28364_11089# nmos$1
Xnmos$1_62 a_n28089_7796# VSS m1_n26796_8302# a_n26151_8290# nmos$1
Xnmos$1_51 OUTP VSS m1_n27919_2550# a_n27274_2538# nmos$1
Xnmos$1_95 a_n28089_22176# VSS m1_n26796_22682# a_n26151_22670# nmos$1
Xnmos_501 a_n67452_3878# VSS a_n67599_4097# VSS nmos
Xnmos_534 a_n65943_13034# VSS a_n66090_13253# VSS nmos
Xnmos_523 a_n64438_10418# VSS a_n64585_10637# VSS nmos
Xnmos_512 a_n62930_5186# VSS a_n63077_5405# VSS nmos
Xnmos_545 a_n64438_15650# VSS a_n64585_15869# VSS nmos
Xnmos_567 a_n55410_13034# VSS a_n55557_13253# VSS nmos
Xnmos_556 a_n59916_10418# VSS a_n60063_10637# VSS nmos
Xnmos$2_3114 a_n78135_19793# VSS a_n77674_19563# SL_2N nmos$2
Xnmos$2_3103 a_n77674_16947# VSS ML_8 m1_n77577_17155# nmos$2
Xnmos$2_3125 WL_8 VSS SL_1N a_n79644_17177# nmos$2
Xnmos_589 a_n73470_5186# VSS a_n73617_5405# VSS nmos
Xnmos_578 a_n74975_3878# VSS a_n75122_4097# VSS nmos
Xnmos$2_3158 a_n79497_22190# VSS SL_1 a_n79183_22179# nmos$2
Xnmos$2_3147 WL_6 VSS a_n77988_19574# SL_2 nmos$2
Xnmos$2_3169 a_n81002_20882# VSS SL_0 a_n80688_20871# nmos$2
Xnmos$2_3136 a_n81149_18485# VSS a_n80688_18255# SL_0N nmos$2
Xnmos$2_2413 a_n55557_15869# VSS a_n55096_15639# SL_17N nmos$2
Xnmos$2_2402 a_n55410_13034# VSS SL_17 a_n55096_13023# nmos$2
Xnmos$2_2424 a_n56915_13034# VSS SL_16 a_n56601_13023# nmos$2
Xnmos$3_503 a_n70603_8021# VSS VSS a_n70456_7802# nmos$3
Xnmos$3_525 a_n81149_8021# VSS VSS a_n81002_7802# nmos$3
Xnmos$3_514 a_n81149_2789# VSS VSS a_n81002_2570# nmos$3
Xnmos$3_558 a_n75122_13253# VSS VSS a_n74975_13034# nmos$3
Xnmos$3_547 a_n78135_11945# VSS VSS a_n77988_11726# nmos$3
Xnmos$3_536 a_n76630_10637# VSS VSS a_n76483_10418# nmos$3
Xnmos$2_2446 a_n69104_4097# VSS a_n68643_3867# SL_8N nmos$2
Xnmos$2_2435 WL_19 VSS SL_7N a_n70603_2789# nmos$2
Xnmos$2_2457 a_n73470_2570# VSS SL_5 a_n73156_2559# nmos$2
Xnmos$2_1701 WL_21 VSS a_n65943_n46# SL_10 nmos$2
Xnmos$2_1712 a_n61425_n1354# VSS SL_13 a_n61111_n1365# nmos$2
Xnmos$3_569 a_n69104_11945# VSS VSS a_n68957_11726# nmos$3
Xnmos$2_2479 a_n72108_5405# VSS a_n71647_5175# SL_6N nmos$2
Xnmos$2_2468 WL_18 VSS a_n71961_3878# SL_6 nmos$2
Xnmos$2_1734 WL_21 VSS SL_12N a_n63077_173# nmos$2
Xnmos$2_1723 WL_21 VSS SL_11N a_n64585_173# nmos$2
Xnmos$2_1745 WL_23 VSS SL_13N a_n61572_n2742# nmos$2
Xnmos$2_1756 WL_23 VSS SL_10N a_n66090_n2742# nmos$2
Xnmos$2_1789 WL_25 VSS SL_14N a_n60063_n5358# nmos$2
Xnmos$2_1767 a_n55410_n5278# VSS SL_17 a_n55096_n5289# nmos$2
Xnmos$2_1778 a_n55557_n4050# VSS a_n55096_n3981# SL_17N nmos$2
Xpmos_2319 a_n27618_28422# VDD VDD m1_n27919_28434# pmos
Xpmos_2308 a_n26495_26984# VDD COMP3 VDD pmos
Xpmos_1607 a_n60063_27641# VDD a_n59916_27422# VDD pmos
Xpmos_1618 a_n61425_27422# VDD VDD a_n61572_27641# pmos
Xpmos_1629 a_n27274_2538# VDD VDD a_n27618_2538# pmos
Xnmos$2_5061 a_n34471_25025# VSS a_n34010_24795# SL_31N nmos$2
Xnmos$2_5050 a_n35829_22190# VSS SL_30 a_n35515_22179# nmos$2
Xnmos$2_5072 a_n34324_27422# VSS SL_31 a_n34010_27411# nmos$2
Xnmos$2_5094 WL_0 VSS SL_28N a_n38990_27641# nmos$2
Xnmos$2_5083 WL_1 VSS SL_31N a_n34471_26333# nmos$2
Xnmos$2_4360 a_n49069_15639# VSS ML_9 m1_n48972_15847# nmos$2
Xnmos$2_4393 a_n41856_11726# VSS SL_26 a_n41542_11715# nmos$2
Xnmos$2_4371 WL_13 VSS SL_26N a_n42003_10637# nmos$2
Xnmos$2_4382 WL_13 VSS SL_25N a_n43512_10637# nmos$2
Xnmos$2_3670 a_n61425_26114# VSS SL_13 a_n61111_26103# nmos$2
Xnmos$2_3681 WL_2 VSS a_n64438_24806# SL_11 nmos$2
Xnmos$2_3692 a_n65943_27422# VSS SL_10 a_n65629_27411# nmos$2
Xnmos$2_2980 a_n72108_18485# VSS a_n71647_18255# SL_6N nmos$2
Xnmos$2_2991 a_n73470_16958# VSS SL_5 a_n73156_16947# nmos$2
Xnmos$2_580 a_n47560_n6597# VSS ML_26 m1_n47463_n6389# nmos$2
Xnmos$2_591 a_n35976_n13206# VSS a_n35515_n13137# SL_30N nmos$2
Xnmos$2_1008 WL_27 VSS SL_7N a_n70603_n7974# nmos$2
Xnmos$2_1019 WL_31 VSS a_n74975_n13126# SL_4 nmos$2
Xnmos_342 a_n77988_n1354# VSS a_n78135_n1434# VSS nmos
Xnmos_320 a_n81002_n7894# VSS a_n81149_n7974# VSS nmos
Xnmos_331 a_n77988_n3970# VSS a_n78135_n4050# VSS nmos
Xnmos_364 a_n73470_n46# VSS a_n73617_173# VSS nmos
Xnmos_375 a_n56915_n13126# VSS a_n57062_n13206# VSS nmos
Xnmos_353 a_n71961_n5278# VSS a_n72108_n5358# VSS nmos
Xnmos_386 a_n58411_n9202# VSS a_n58558_n9282# VSS nmos
Xnmos$3_300 a_n57062_n9282# VSS VSS a_n56915_n9202# nmos$3
Xnmos_397 a_n55410_n7894# VSS a_n55557_n7974# VSS nmos
Xnmos$2_2221 a_n66090_14561# VSS a_n65629_14331# SL_10N nmos$2
Xnmos$2_2232 a_n67138_14331# VSS ML_10 m1_n67041_14539# nmos$2
Xnmos$2_2210 a_n67599_11945# VSS a_n67138_11715# SL_9N nmos$2
Xnmos$3_322 a_n66090_n13206# VSS VSS a_n65943_n13126# nmos$3
Xnmos$3_333 a_n61572_n9282# VSS VSS a_n61425_n9202# nmos$3
Xnmos$3_311 a_n55557_n6666# VSS VSS a_n55410_n6586# nmos$3
Xnmos$2_2243 WL_9 VSS SL_9N a_n67599_15869# nmos$2
Xnmos$2_2254 a_n61572_14561# VSS a_n61111_14331# SL_13N nmos$2
Xnmos$2_2265 a_n64585_14561# VSS a_n64124_14331# SL_11N nmos$2
Xnmos$3_355 a_n61572_n2742# VSS VSS a_n61425_n2662# nmos$3
Xnmos$2_1520 a_n53587_n7905# VSS ML_27 m1_n53490_n7697# nmos$2
Xnmos$3_344 a_n66090_n5358# VSS VSS a_n65943_n5278# nmos$3
Xnmos$3_366 a_n57062_n4050# VSS VSS a_n56915_n3970# nmos$3
Xnmos$2_2276 a_n62616_15639# VSS ML_9 m1_n62519_15847# nmos$2
Xnmos$2_2287 WL_10 VSS SL_12N a_n63077_14561# nmos$2
Xnmos$2_2298 WL_14 VSS a_n55410_9110# SL_17 nmos$2
Xnmos$3_399 a_n57062_8021# VSS VSS a_n56915_7802# nmos$3
Xnmos$3_388 a_n57062_2789# VSS VSS a_n56915_2570# nmos$3
Xnmos$3_377 a_n55557_173# VSS VSS a_n55410_n46# nmos$3
Xnmos$2_1531 a_n61425_n13126# VSS SL_13 a_n61111_n13137# nmos$2
Xnmos$2_1553 a_n61111_n11829# VSS ML_30 m1_n61014_n11621# nmos$2
Xnmos$2_1564 WL_29 VSS SL_12N a_n63077_n10590# nmos$2
Xnmos$2_1542 a_n63077_n10590# VSS a_n62616_n10521# SL_12N nmos$2
Xnmos$2_1597 a_n65629_n13137# VSS ML_31 m1_n65532_n12929# nmos$2
Xnmos$2_1575 WL_30 VSS a_n65943_n11818# SL_10 nmos$2
Xnmos$2_1586 WL_30 VSS a_n64438_n11818# SL_11 nmos$2
Xpmos_2116 a_n46516_23717# VDD a_n46369_23498# VDD pmos
Xpmos_2105 a_n52396_23498# VDD VDD a_n52543_23717# pmos
Xpmos_2127 a_n50888_22190# VDD VDD a_n51035_22409# pmos
Xpmos_2149 a_n53901_27422# VDD VDD a_n54048_27641# pmos
Xpmos_1415 a_n76630_27641# VDD a_n76483_27422# VDD pmos
Xpmos_2138 a_n46516_26333# VDD a_n46369_26114# VDD pmos
Xpmos_1426 a_n81149_26333# VDD a_n81002_26114# VDD pmos
Xpmos_1404 a_n75122_23717# VDD a_n74975_23498# VDD pmos
Xpmos_1448 a_n69104_27641# VDD a_n68957_27422# VDD pmos
Xpmos_1459 a_n72108_27641# VDD a_n71961_27422# VDD pmos
Xpmos_1437 a_n70456_24806# VDD VDD a_n70603_25025# pmos
Xpmos_608 a_n72108_n6666# VDD a_n71961_n6586# VDD pmos
Xpmos_619 a_n73470_n5278# VDD VDD a_n73617_n5358# pmos
Xnmos_1302 a_n77988_1262# VSS a_n78135_1481# VSS nmos
Xnmos_1313 a_n35829_1262# VSS a_n35976_1481# VSS nmos
Xnmos$2_4190 WL_15 VSS a_n50888_7802# SL_20 nmos$2
Xpmos_1960 a_n49383_14342# VDD VDD a_n49530_14561# pmos
Xpmos_1971 a_n50888_14342# VDD VDD a_n51035_14561# pmos
Xpmos_1982 a_n41856_10418# VDD VDD a_n42003_10637# pmos
Xpmos_1993 a_n45017_10637# VDD a_n44870_10418# VDD pmos
Xnmos$1_7 a_n28089_n12336# VSS m1_n26796_n11830# a_n26151_n11842# nmos$1
Xnmos$5_609 VEVAL VSS m1_n70045_22387# VSS nmos$5
Xnmos_41 a_n49383_n10510# VSS a_n49530_n10590# VSS nmos
Xnmos_52 a_n53901_n9202# VSS a_n54048_n9282# VSS nmos
Xnmos_30 a_n46369_n6586# VSS a_n46516_n6666# VSS nmos
Xnmos_63 a_n50888_n6586# VSS a_n51035_n6666# VSS nmos
Xnmos_74 a_n53901_n5278# VSS a_n54048_n5358# VSS nmos
Xnmos_85 a_n50888_n3970# VSS a_n51035_n4050# VSS nmos
Xnmos_96 a_n43365_n3970# VSS a_n43512_n4050# VSS nmos
Xnmos_150 a_n27618_n7528# VSS m1_n27919_n7516# VSS nmos
Xnmos_194 a_n35829_n2662# VSS a_n35976_n2742# VSS nmos
Xnmos_161 a_n38843_n10510# VSS a_n38990_n10590# VSS nmos
Xnmos_172 a_n35829_n9202# VSS a_n35976_n9282# VSS nmos
Xnmos_183 a_n38843_n3970# VSS a_n38990_n4050# VSS nmos
Xnmos$2_2040 a_n62616_2559# VSS ML_19 m1_n62519_2767# nmos$2
Xnmos$3_130 a_n35976_n6666# VSS VSS a_n35829_n6586# nmos$3
Xnmos$3_141 a_n38990_n4050# VSS VSS a_n38843_n3970# nmos$3
Xnmos$2_2051 WL_18 VSS SL_11N a_n64585_4097# nmos$2
Xnmos$2_2073 a_n67138_3867# VSS ML_18 m1_n67041_4075# nmos$2
Xnmos$2_2062 a_n64124_2559# VSS ML_19 m1_n64027_2767# nmos$2
Xnmos$3_152 a_n38990_n2742# VSS VSS a_n38843_n2662# nmos$3
Xnmos$3_174 a_n75122_n29051# VSS VSS a_n74975_n28971# nmos$3
Xnmos$3_163 a_n64585_n29051# VSS VSS a_n64438_n28971# nmos$3
Xnmos$2_2095 a_n65943_6494# VSS SL_10 a_n65629_6483# nmos$2
Xnmos$2_2084 a_n64124_5175# VSS ML_17 m1_n64027_5383# nmos$2
Xnmos$2_1361 WL_23 VSS SL_7N a_n70603_n2742# nmos$2
Xnmos$2_1350 WL_23 VSS SL_5N a_n73617_n2742# nmos$2
Xnmos$3_185 a_n73617_n13206# VSS VSS a_n73470_n13126# nmos$3
Xnmos$3_196 a_n67599_n9282# VSS VSS a_n67452_n9202# nmos$3
Xnmos$2_1372 a_n77674_n6597# VSS ML_26 m1_n77577_n6389# nmos$2
Xnmos$3_19 a_n43512_n13206# VSS VSS a_n43365_n13126# nmos$3
Xnmos$2_1383 a_n81149_n6666# VSS a_n80688_n6597# SL_0N nmos$2
Xnmos$2_1394 a_n70603_n6666# VSS a_n70142_n6597# SL_7N nmos$2
Xpmos_1201 a_n79644_10637# VDD a_n79497_10418# VDD pmos
Xpmos_1212 a_n81002_15650# VDD VDD a_n81149_15869# pmos
Xpmos_1223 a_n75122_13253# VDD a_n74975_13034# VDD pmos
Xpmos_1234 a_n68957_9110# VDD VDD a_n69104_9329# pmos
Xpmos_1267 a_n73617_13253# VDD a_n73470_13034# VDD pmos
Xpmos_1256 a_n72108_11945# VDD a_n71961_11726# VDD pmos
Xpmos_1245 a_n70456_10418# VDD VDD a_n70603_10637# pmos
Xpmos_416 a_n61572_n29051# VDD a_n61425_n28971# VDD pmos
Xpmos_405 a_n40351_n11818# VDD VDD a_n40498_n11898# pmos
Xpmos_1289 a_n70456_14342# VDD VDD a_n70603_14561# pmos
Xpmos_1278 a_n72108_14561# VDD a_n71961_14342# VDD pmos
Xpmos_449 a_n68957_n11818# VDD VDD a_n69104_n11898# pmos
Xpmos_438 a_n76630_n29051# VDD a_n76483_n28971# VDD pmos
Xpmos_427 a_n71961_n28971# VDD VDD a_n72108_n29051# pmos
Xnmos_1110 a_n50888_20882# VSS a_n51035_21101# VSS nmos
Xnmos_1132 a_n43365_27422# VSS a_n43512_27641# VSS nmos
Xnmos_1121 a_n53901_26114# VSS a_n54048_26333# VSS nmos
Xnmos_1154 a_n28485_19892# VSS VSS m1_n28364_19717# nmos
Xnmos_1143 a_n26151_16918# VSS a_n26495_16918# VSS nmos
Xnmos_1187 a_n27618_24108# VSS m1_n27919_24120# VSS nmos
Xnmos_1176 a_n27618_22670# VSS m1_n27919_22682# VSS nmos
Xnmos_1165 ML_5 VSS VSS a_n28485_24206# nmos
Xnmos_1198 a_n38843_19574# VSS a_n38990_19793# VSS nmos
Xpmos_1790 a_n27618_15480# VDD VDD m1_n27919_15492# pmos
Xpmos_961 a_n62930_11726# VDD VDD a_n63077_11945# pmos
Xpmos_972 a_n64585_10637# VDD a_n64438_10418# VDD pmos
Xpmos_950 a_n62930_5186# VDD VDD a_n63077_5405# pmos
Xnmos$2_4915 a_n43365_27422# VSS SL_25 a_n43051_27411# nmos$2
Xnmos$2_4904 a_n44870_24806# VSS SL_24 a_n44556_24795# nmos$2
Xpmos_983 a_n65943_15650# VDD VDD a_n66090_15869# pmos
Xpmos_994 a_n62930_13034# VDD VDD a_n63077_13253# pmos
Xnmos$2_4926 a_n44556_26103# VSS ML_1 m1_n44459_26311# nmos$2
Xnmos$2_4937 a_n46369_23498# VSS SL_23 a_n46055_23487# nmos$2
Xnmos$2_4959 a_n35515_19563# VSS ML_6 m1_n35418_19771# nmos$2
Xnmos$2_4948 a_n35515_18255# VSS ML_7 m1_n35418_18463# nmos$2
Xnmos$5_417 VEVAL VSS m1_n62519_6691# VSS nmos$5
Xnmos$5_406 VEVAL VSS m1_n67041_4075# VSS nmos$5
Xnmos$5_439 VEVAL VSS m1_n65532_14539# VSS nmos$5
Xnmos$5_428 VEVAL VSS m1_n62519_10615# VSS nmos$5
Xnmos$5_962 VEVAL VSS m1_n48972_27619# VSS nmos$5
Xnmos$5_973 VEVAL VSS m1_n41445_25003# VSS nmos$5
Xnmos$5_951 VEVAL VSS m1_n51985_21079# VSS nmos$5
Xnmos$5_940 VEVAL VSS m1_n48972_19771# VSS nmos$5
Xnmos$5_984 VEVAL VSS m1_n42954_26311# VSS nmos$5
Xnmos$5_995 VEVAL VSS m1_n38432_17155# VSS nmos$5
Xnmos$2_1180 a_n79183_n1365# VSS ML_22 m1_n79086_n1157# nmos$2
Xnmos$2_1191 WL_21 VSS SL_0N a_n81149_173# nmos$2
Xpmos_1031 a_n59916_15650# VDD VDD a_n60063_15869# pmos
Xpmos_1042 a_n54048_13253# VDD a_n53901_13034# VDD pmos
Xpmos_1020 a_n59916_10418# VDD VDD a_n60063_10637# pmos
Xpmos_1053 a_n56915_14342# VDD VDD a_n57062_14561# pmos
Xpmos_1064 a_n61425_3878# VDD VDD a_n61572_4097# pmos
Xpmos_1075 a_n70603_4097# VDD a_n70456_3878# VDD pmos
Xpmos_1086 a_n73617_2789# VDD a_n73470_2570# VDD pmos
Xpmos_224 a_n40498_173# VDD a_n40351_n46# VDD pmos
Xpmos_213 a_n43512_173# VDD a_n43365_n46# VDD pmos
Xpmos_202 a_n44870_n1354# VDD VDD a_n45017_n1434# pmos
Xnmos_908 a_n38843_14342# VSS a_n38990_14561# VSS nmos
Xpmos_1097 a_n71961_5186# VDD VDD a_n72108_5405# pmos
Xpmos_235 a_n26495_n13280# VDD VDD m1_n26796_n13268# pmos
Xpmos_268 a_n34471_n11898# VDD a_n34324_n11818# VDD pmos
Xpmos_257 OUTP VDD VDD a_n27990_n9846# pmos
Xpmos_246 OUTP VDD VDD a_n28089_n8022# pmos
Xnmos_919 a_n26495_9728# VSS VSS COMP15 nmos
Xpmos_279 a_n37485_n11898# VDD a_n37338_n11818# VDD pmos
Xnmos$2_2809 a_n69104_10637# VSS a_n68643_10407# SL_8N nmos$2
Xnmos$2_409 WL_23 VSS a_n49383_n2662# SL_21 nmos$2
Xnmos_9 a_n46369_n28971# VSS a_n46516_n29051# VSS nmos
Xpmos_780 a_n63077_173# VDD a_n62930_n46# VDD pmos
Xnmos$2_4723 WL_6 VSS SL_19N a_n52543_19793# nmos$2
Xnmos$2_4712 a_n54048_19793# VSS a_n53587_19563# SL_18N nmos$2
Xnmos$2_4701 a_n54048_18485# VSS a_n53587_18255# SL_18N nmos$2
Xpmos_791 a_n55557_n6666# VDD a_n55410_n6586# VDD pmos
Xnmos$2_4756 a_n52543_23717# VSS a_n52082_23487# SL_19N nmos$2
Xnmos$2_4745 a_n52396_23498# VSS SL_19 a_n52082_23487# nmos$2
Xnmos$2_4734 a_n52396_22190# VSS SL_19 a_n52082_22179# nmos$2
Xnmos$2_4767 WL_5 VSS a_n47874_20882# SL_22 nmos$2
Xnmos$5_203 VEVAL VSS m1_n76072_n11621# VSS nmos$5
Xnmos$5_214 VEVAL VSS m1_n80591_n9005# VSS nmos$5
Xnmos$5_225 VEVAL VSS m1_n74564_n7697# VSS nmos$5
Xnmos$2_4789 a_n47874_23498# VSS SL_22 a_n47560_23487# nmos$2
Xnmos$2_4778 a_n49069_20871# VSS ML_5 m1_n48972_21079# nmos$2
Xnmos$5_247 VEVAL VSS m1_n76072_151# VSS nmos$5
Xnmos$5_258 VEVAL VSS m1_n73059_n5081# VSS nmos$5
Xnmos$5_236 VEVAL VSS m1_n80591_n3773# VSS nmos$5
Xnmos$5_269 VEVAL VSS m1_n73059_n2465# VSS nmos$5
Xnmos$2_910 a_n70456_n10510# VSS SL_7 a_n70142_n10521# nmos$2
Xnmos$2_921 WL_29 VSS a_n67452_n10510# SL_9 nmos$2
Xnmos$2_965 a_n72108_n11898# VSS a_n71647_n11829# SL_6N nmos$2
Xnmos$2_943 a_n73617_n13206# VSS a_n73156_n13137# SL_5N nmos$2
Xnmos$2_954 WL_29 VSS SL_4N a_n75122_n10590# nmos$2
Xnmos$2_932 WL_29 VSS a_n68957_n10510# SL_8 nmos$2
Xnmos$2_976 a_n73617_n9282# VSS a_n73156_n9213# SL_5N nmos$2
Xnmos$2_998 WL_28 VSS a_n67452_n9202# SL_9 nmos$2
Xnmos$2_987 a_n72108_n7974# VSS a_n71647_n7905# SL_6N nmos$2
Xpmos_11 a_n40498_n29051# VDD a_n40351_n28971# VDD pmos
Xpmos_22 a_n47874_n28971# VDD VDD a_n48021_n29051# pmos
Xpmos_33 a_n42003_n11898# VDD a_n41856_n11818# VDD pmos
Xpmos_44 a_n43512_n10590# VDD a_n43365_n10510# VDD pmos
Xpmos_77 a_n48021_n13206# VDD a_n47874_n13126# VDD pmos
Xpmos_55 a_n44870_n7894# VDD VDD a_n45017_n7974# pmos
Xpmos_66 a_n41856_n7894# VDD VDD a_n42003_n7974# pmos
Xpmos_99 a_n46516_n10590# VDD a_n46369_n10510# VDD pmos
Xpmos_88 a_n52396_n9202# VDD VDD a_n52543_n9282# pmos
Xnmos$5_781 VEVAL VSS m1_n36927_10615# VSS nmos$5
Xnmos$5_770 VEVAL VSS m1_n35418_5383# VSS nmos$5
Xnmos$5_792 VEVAL VSS m1_n33913_13231# VSS nmos$5
Xnmos_716 a_n81002_20882# VSS a_n81149_21101# VSS nmos
Xnmos_705 a_n77988_19574# VSS a_n78135_19793# VSS nmos
Xnmos_749 a_n73470_27422# VSS a_n73617_27641# VSS nmos
Xnmos_738 a_n68957_26114# VSS a_n69104_26333# VSS nmos
Xnmos_727 a_n77988_26114# VSS a_n78135_26333# VSS nmos
Xnmos$2_4019 WL_18 VSS SL_27N a_n40498_4097# nmos$2
Xnmos$2_4008 a_n41542_2559# VSS ML_19 m1_n41445_2767# nmos$2
Xnmos$2_3307 a_n70603_27641# VSS a_n70142_27411# SL_7N nmos$2
Xnmos$2_3318 WL_1 VSS SL_7N a_n70603_26333# nmos$2
Xnmos$2_3329 WL_1 VSS a_n67452_26114# SL_9 nmos$2
Xnmos$5_1017 VEVAL VSS m1_n36927_25003# VSS nmos$5
Xnmos$5_1006 VEVAL VSS m1_n33913_21079# VSS nmos$5
Xnmos$3_707 a_n54048_22409# VSS VSS a_n53901_22190# nmos$3
Xnmos$2_2606 WL_16 VSS SL_0N a_n81149_6713# nmos$2
Xnmos$3_729 a_n66090_23717# VSS VSS a_n65943_23498# nmos$3
Xnmos$3_718 a_n61572_19793# VSS VSS a_n61425_19574# nmos$3
Xnmos$5_1028 VEVAL VSS m1_n53490_18463# VSS nmos$5
Xnmos$5_1039 VEVAL VSS m1_n53490_11923# VSS nmos$5
Xnmos$2_2617 a_n80688_7791# VSS ML_15 m1_n80591_7999# nmos$2
Xnmos$2_2639 WL_16 VSS SL_2N a_n78135_6713# nmos$2
Xnmos$2_2628 a_n74661_5175# VSS ML_17 m1_n74564_5383# nmos$2
Xnmos$2_217 a_n50574_n13137# VSS ML_31 m1_n50477_n12929# nmos$2
Xnmos$2_206 a_n48021_n10590# VSS a_n47560_n10521# SL_22N nmos$2
Xnmos$2_1938 a_n53587_3867# VSS ML_18 m1_n53490_4075# nmos$2
Xnmos$2_1927 WL_19 VSS SL_16N a_n57062_2789# nmos$2
Xnmos$2_228 a_n52396_n11818# VSS SL_19 a_n52082_n11829# nmos$2
Xnmos$2_239 a_n51035_n11898# VSS a_n50574_n11829# SL_20N nmos$2
Xnmos$2_1905 a_n67138_n6597# VSS ML_26 m1_n67041_n6389# nmos$2
Xnmos$2_1916 a_n62930_n6586# VSS SL_12 a_n62616_n6597# nmos$2
Xnmos$2_1949 WL_19 VSS SL_14N a_n60063_2789# nmos$2
Xnmos$2_5210 a_n67138_1251# VSS ML_20 m1_n67041_1459# nmos$2
Xnmos$2_5221 a_n59916_1262# VSS SL_14 a_n59602_1251# nmos$2
Xnmos$2_5232 a_n69104_1481# VSS a_n68643_1251# SL_8N nmos$2
Xnmos$2_5243 a_n79644_1481# VSS a_n79183_1251# SL_1N nmos$2
Xnmos$2_4542 a_n41856_19574# VSS SL_26 a_n41542_19563# nmos$2
Xnmos$2_4531 a_n43512_18485# VSS a_n43051_18255# SL_25N nmos$2
Xnmos$2_4520 a_n40037_16947# VSS ML_8 m1_n39940_17155# nmos$2
Xnmos$2_5276 WL_20 VSS a_n47874_1262# SL_22 nmos$2
Xnmos$2_5254 a_n61572_1481# VSS a_n61111_1251# SL_13N nmos$2
Xnmos$2_5265 a_n64585_1481# VSS a_n64124_1251# SL_11N nmos$2
Xnmos$2_4575 WL_6 VSS SL_23N a_n46516_19793# nmos$2
Xnmos$2_4564 WL_7 VSS a_n44870_18266# SL_24 nmos$2
Xnmos$2_4553 a_n45017_17177# VSS a_n44556_16947# m2_n44135_352# nmos$2
Xnmos$2_3830 a_n38990_5405# VSS a_n38529_5175# SL_28N nmos$2
Xnmos$2_4586 a_n45017_22409# VSS a_n44556_22179# m2_n44135_352# nmos$2
Xnmos$2_4597 a_n46516_21101# VSS a_n46055_20871# SL_23N nmos$2
Xnmos$2_3863 a_n35515_7791# VSS ML_15 m1_n35418_7999# nmos$2
Xnmos$2_3841 WL_15 VSS a_n37338_7802# SL_29 nmos$2
Xnmos$2_3852 WL_16 VSS SL_30N a_n35976_6713# nmos$2
Xnmos$2_3896 a_n34324_11726# VSS SL_31 a_n34010_11715# nmos$2
Xnmos$2_3885 a_n34010_10407# VSS ML_13 m1_n33913_10615# nmos$2
Xnmos$2_3874 WL_15 VSS a_n35829_7802# SL_30 nmos$2
Xnmos$2_751 a_n35515_n57# VSS ML_21 m1_n35418_151# nmos$2
Xnmos$2_740 WL_22 VSS SL_31N a_n34471_n1434# nmos$2
Xnmos$2_762 WL_22 VSS a_n35829_n1354# SL_30 nmos$2
Xnmos$2_773 a_n37485_n2742# VSS a_n37024_n2673# SL_29N nmos$2
Xnmos$2_784 a_n37024_n6597# VSS ML_26 m1_n36927_n6389# nmos$2
Xnmos$2_795 a_n35515_n6597# VSS ML_26 m1_n35418_n6389# nmos$2
Xnmos$1_41 a_n27990_220# VSS m1_n26796_n326# a_n26151_n338# nmos$1
Xnmos$1_30 OUTP VSS a_n26151_n3214# a_n27618_n3214# nmos$1
Xnmos$1_74 OUTP VSS m1_n27919_11178# a_n27274_11166# nmos$1
Xnmos$1_63 OUTP VSS a_n26151_8290# a_n27618_8290# nmos$1
Xnmos$1_52 OUTP VSS a_n26151_6852# a_n27618_6852# nmos$1
Xnmos$1_96 OUTP VSS a_n26151_22670# a_n27618_22670# nmos$1
Xnmos$1_85 a_n28089_17862# VSS m1_n26796_18368# a_n26151_18356# nmos$1
Xnmos_524 a_n64438_11726# VSS a_n64585_11945# VSS nmos
Xnmos_513 a_n64438_6494# VSS a_n64585_6713# VSS nmos
Xnmos_502 a_n65943_3878# VSS a_n66090_4097# VSS nmos
Xnmos_546 a_n62930_15650# VSS a_n63077_15869# VSS nmos
Xnmos_535 a_n67452_14342# VSS a_n67599_14561# VSS nmos
Xnmos_568 a_n56915_13034# VSS a_n57062_13253# VSS nmos
Xnmos_557 a_n59916_9110# VSS a_n60063_9329# VSS nmos
Xnmos$2_3115 WL_6 VSS a_n74975_19574# SL_4 nmos$2
Xnmos$2_3104 a_n77674_18255# VSS ML_7 m1_n77577_18463# nmos$2
Xnmos$2_3126 a_n79644_17177# VSS a_n79183_16947# SL_1N nmos$2
Xnmos_579 a_n71961_3878# VSS a_n72108_4097# VSS nmos
Xnmos$2_3148 a_n77988_19574# VSS SL_2 a_n77674_19563# nmos$2
Xnmos$2_3159 WL_5 VSS a_n77988_20882# SL_2 nmos$2
Xnmos$2_3137 a_n80688_18255# VSS ML_7 m1_n80591_18463# nmos$2
Xnmos$2_2414 WL_9 VSS a_n53901_15650# SL_18 nmos$2
Xnmos$2_2403 a_n57062_14561# VSS a_n56601_14331# SL_16N nmos$2
Xnmos$3_504 a_n67599_8021# VSS VSS a_n67452_7802# nmos$3
Xnmos$3_515 a_n79644_4097# VSS VSS a_n79497_3878# nmos$3
Xnmos$2_2425 a_n56915_14342# VSS SL_16 a_n56601_14331# nmos$2
Xnmos$3_548 a_n78135_14561# VSS VSS a_n77988_14342# nmos$3
Xnmos$3_537 a_n76630_11945# VSS VSS a_n76483_11726# nmos$3
Xnmos$3_526 a_n78135_8021# VSS VSS a_n77988_7802# nmos$3
Xnmos$2_2447 a_n68643_3867# VSS ML_18 m1_n68546_4075# nmos$2
Xnmos$2_2436 a_n70603_2789# VSS a_n70142_2559# SL_7N nmos$2
Xnmos$2_1702 a_n65943_n46# VSS SL_10 a_n65629_n57# nmos$2
Xnmos$2_1713 WL_22 VSS SL_13N a_n61572_n1434# nmos$2
Xnmos$3_559 a_n76630_13253# VSS VSS a_n76483_13034# nmos$3
Xnmos$2_2469 a_n71961_3878# VSS SL_6 a_n71647_3867# nmos$2
Xnmos$2_2458 WL_19 VSS a_n73470_2570# SL_5 nmos$2
Xnmos$2_1724 a_n64585_173# VSS a_n64124_n57# SL_11N nmos$2
Xnmos$2_1735 WL_22 VSS SL_12N a_n63077_n1434# nmos$2
Xnmos$2_1746 a_n65629_n2673# VSS ML_23 m1_n65532_n2465# nmos$2
Xnmos$2_1757 a_n66090_n2742# VSS a_n65629_n2673# SL_10N nmos$2
Xnmos$2_1768 WL_25 VSS SL_16N a_n57062_n5358# nmos$2
Xnmos$2_1779 a_n55096_n5289# VSS ML_25 m1_n54999_n5081# nmos$2
Xpmos_2309 a_n27274_26984# VDD VDD a_n27618_26984# pmos
Xpmos_1608 a_n59916_27422# VDD VDD a_n60063_27641# pmos
Xpmos_1619 a_n61425_16958# VDD VDD a_n61572_17177# pmos
Xnmos$2_5040 a_n35515_23487# VSS ML_3 m1_n35418_23695# nmos$2
Xnmos$2_5051 WL_3 VSS a_n35829_23498# SL_30 nmos$2
Xnmos$2_5073 a_n34471_27641# VSS a_n34010_27411# SL_31N nmos$2
Xnmos$2_5095 WL_0 VSS a_n38843_27422# SL_28 nmos$2
Xnmos$2_5062 WL_2 VSS SL_31N a_n34471_25025# nmos$2
Xnmos$2_5084 a_n37024_24795# VSS ML_2 m1_n36927_25003# nmos$2
Xnmos$2_4350 WL_10 VSS SL_21N a_n49530_14561# nmos$2
Xnmos$2_4361 WL_9 VSS a_n49383_15650# SL_21 nmos$2
Xnmos$2_4383 a_n43512_10637# VSS a_n43051_10407# SL_25N nmos$2
Xnmos$2_4372 a_n40351_9110# VSS SL_27 a_n40037_9099# nmos$2
Xnmos$2_3660 a_n61425_27422# VSS SL_13 a_n61111_27411# nmos$2
Xnmos$2_3671 WL_1 VSS a_n61425_26114# SL_13 nmos$2
Xnmos$2_3682 WL_2 VSS SL_10N a_n66090_25025# nmos$2
Xnmos$2_4394 a_n43512_11945# VSS a_n43051_11715# SL_25N nmos$2
Xnmos$2_3693 a_n66090_27641# VSS a_n65629_27411# SL_10N nmos$2
Xnmos$2_2970 a_n68957_19574# VSS SL_8 a_n68643_19563# nmos$2
Xnmos$2_2992 WL_7 VSS a_n73470_18266# SL_5 nmos$2
Xnmos$2_2981 a_n71647_16947# VSS ML_8 m1_n71550_17155# nmos$2
Xnmos$2_581 WL_26 VSS SL_22N a_n48021_n6666# nmos$2
Xnmos$2_570 a_n45017_n6666# VSS a_n44556_n6597# m2_n44135_352# nmos$2
Xnmos$2_592 a_n35515_n10521# VSS ML_29 m1_n35418_n10313# nmos$2
Xnmos$2_1009 a_n67452_n7894# VSS SL_9 a_n67138_n7905# nmos$2
Xnmos_343 a_n77988_n46# VSS a_n78135_173# VSS nmos
Xnmos_310 a_n76483_n11818# VSS a_n76630_n11898# VSS nmos
Xnmos_321 a_n79497_n6586# VSS a_n79644_n6666# VSS nmos
Xnmos_332 a_n76483_n3970# VSS a_n76630_n4050# VSS nmos
Xnmos_365 a_n68957_n1354# VSS a_n69104_n1434# VSS nmos
Xnmos_376 a_n56915_n11818# VSS a_n57062_n11898# VSS nmos
Xnmos_354 a_n74975_n5278# VSS a_n75122_n5358# VSS nmos
Xnmos_398 a_n62930_n13126# VSS a_n63077_n13206# VSS nmos
Xnmos_387 a_n59916_n9202# VSS a_n60063_n9282# VSS nmos
Xnmos$2_2222 a_n64438_13034# VSS SL_11 a_n64124_13023# nmos$2
Xnmos$2_2211 a_n66090_11945# VSS a_n65629_11715# SL_10N nmos$2
Xnmos$2_2200 a_n67138_9099# VSS ML_14 m1_n67041_9307# nmos$2
Xnmos$3_323 a_n66090_n10590# VSS VSS a_n65943_n10510# nmos$3
Xnmos$3_301 a_n60063_n9282# VSS VSS a_n59916_n9202# nmos$3
Xnmos$3_312 a_n55557_n7974# VSS VSS a_n55410_n7894# nmos$3
Xnmos$2_2244 a_n64438_15650# VSS SL_11 a_n64124_15639# nmos$2
Xnmos$2_2266 a_n62930_14342# VSS SL_12 a_n62616_14331# nmos$2
Xnmos$2_2233 WL_10 VSS a_n65943_14342# SL_10 nmos$2
Xnmos$2_2255 WL_11 VSS a_n61425_13034# SL_13 nmos$2
Xnmos$3_356 a_n63077_n2742# VSS VSS a_n62930_n2662# nmos$3
Xnmos$3_334 a_n63077_n9282# VSS VSS a_n62930_n9202# nmos$3
Xnmos$2_1510 WL_28 VSS a_n55410_n9202# SL_17 nmos$2
Xnmos$2_1521 a_n53901_n7894# VSS SL_18 a_n53587_n7905# nmos$2
Xnmos$3_345 a_n66090_n4050# VSS VSS a_n65943_n3970# nmos$3
Xnmos$3_367 a_n58558_n4050# VSS VSS a_n58411_n3970# nmos$3
Xnmos$2_2277 WL_9 VSS a_n62930_15650# SL_12 nmos$2
Xnmos$2_2288 a_n55557_10637# VSS a_n55096_10407# SL_17N nmos$2
Xnmos$2_2299 a_n57062_9329# VSS a_n56601_9099# SL_16N nmos$2
Xnmos$3_389 a_n60063_2789# VSS VSS a_n59916_2570# nmos$3
Xnmos$3_378 a_n54048_173# VSS VSS a_n53901_n46# nmos$3
Xnmos$2_1532 WL_31 VSS SL_13N a_n61572_n13206# nmos$2
Xnmos$2_1554 WL_30 VSS SL_13N a_n61572_n11898# nmos$2
Xnmos$2_1543 a_n62616_n10521# VSS ML_29 m1_n62519_n10313# nmos$2
Xnmos$2_1576 WL_30 VSS SL_9N a_n67599_n11898# nmos$2
Xnmos$2_1565 a_n64438_n13126# VSS SL_11 a_n64124_n13137# nmos$2
Xnmos$2_1587 a_n64438_n11818# VSS SL_11 a_n64124_n11829# nmos$2
Xnmos$2_1598 a_n66090_n9282# VSS a_n65629_n9213# SL_10N nmos$2
Xpmos_2117 a_n47874_23498# VDD VDD a_n48021_23717# pmos
Xpmos_2106 a_n51035_22409# VDD a_n50888_22190# VDD pmos
Xpmos_2128 a_n50888_19574# VDD VDD a_n51035_19793# pmos
Xpmos_2139 a_n46516_27641# VDD a_n46369_27422# VDD pmos
Xpmos_1416 a_n75122_26333# VDD a_n74975_26114# VDD pmos
Xpmos_1405 a_n76483_22190# VDD VDD a_n76630_22409# pmos
Xpmos_1449 a_n69104_26333# VDD a_n68957_26114# VDD pmos
Xpmos_1427 a_n81002_26114# VDD VDD a_n81149_26333# pmos
Xpmos_1438 a_n70603_25025# VDD a_n70456_24806# VDD pmos
Xpmos_609 a_n72108_n5358# VDD a_n71961_n5278# VDD pmos
Xnmos_1303 a_n70456_1262# VSS a_n70603_1481# VSS nmos
Xnmos$2_4191 WL_16 VSS SL_19N a_n52543_6713# nmos$2
Xnmos$2_4180 WL_17 VSS a_n52396_5186# SL_19 nmos$2
Xnmos$2_3490 WL_3 VSS a_n53901_23498# SL_18 nmos$2
Xnmos$3_890 a_n43512_10637# VSS VSS a_n43365_10418# nmos$3
Xpmos_1972 a_n50888_15650# VDD VDD a_n51035_15869# pmos
Xpmos_1961 a_n49530_14561# VDD a_n49383_14342# VDD pmos
Xpmos_1950 a_n52543_14561# VDD a_n52396_14342# VDD pmos
Xpmos_1983 a_n42003_10637# VDD a_n41856_10418# VDD pmos
Xpmos_1994 a_n46369_10418# VDD VDD a_n46516_10637# pmos
Xnmos$1_8 a_n27990_n9846# VSS m1_n26796_n10392# a_n26151_n10404# nmos$1
Xnmos_42 a_n49383_n11818# VSS a_n49530_n11898# VSS nmos
Xnmos_20 a_n41856_n11818# VSS a_n42003_n11898# VSS nmos
Xnmos_53 a_n53901_n7894# VSS a_n54048_n7974# VSS nmos
Xnmos_31 a_n44870_n7894# VSS a_n45017_n7974# VSS nmos
Xnmos_86 a_n47874_n2662# VSS a_n48021_n2742# VSS nmos
Xnmos_64 a_n50888_n13126# VSS a_n51035_n13206# VSS nmos
Xnmos_75 a_n53901_n3970# VSS a_n54048_n4050# VSS nmos
Xnmos_97 a_n41856_n3970# VSS a_n42003_n4050# VSS nmos
Xnmos_151 a_n28485_n7430# VSS VSS m1_n28364_n7605# nmos
Xnmos_140 OUTP VSS a_n28089_n8022# VSS nmos
Xnmos_162 a_n38843_n11818# VSS a_n38990_n11898# VSS nmos
Xnmos_173 a_n35829_n7894# VSS a_n35976_n7974# VSS nmos
Xnmos_184 a_n37338_n3970# VSS a_n37485_n4050# VSS nmos
Xnmos_195 a_n38843_n2662# VSS a_n38990_n2742# VSS nmos
Xnmos$2_2030 a_n56915_6494# VSS SL_16 a_n56601_6483# nmos$2
Xnmos$2_2041 a_n64585_2789# VSS a_n64124_2559# SL_11N nmos$2
Xnmos$3_120 a_n35976_n11898# VSS VSS a_n35829_n11818# nmos$3
Xnmos$3_131 a_n37485_n7974# VSS VSS a_n37338_n7894# nmos$3
Xnmos$3_142 a_n35976_n4050# VSS VSS a_n35829_n3970# nmos$3
Xnmos$2_2052 WL_18 VSS SL_13N a_n61572_4097# nmos$2
Xnmos$2_2074 a_n64438_3878# VSS SL_11 a_n64124_3867# nmos$2
Xnmos$2_2063 WL_19 VSS SL_10N a_n66090_2789# nmos$2
Xnmos$3_153 a_n34471_n2742# VSS VSS a_n34324_n2662# nmos$3
Xnmos$3_175 a_n67599_n13206# VSS VSS a_n67452_n13126# nmos$3
Xnmos$3_164 a_n61572_n29051# VSS VSS a_n61425_n28971# nmos$3
Xnmos$2_2085 a_n64124_6483# VSS ML_16 m1_n64027_6691# nmos$2
Xnmos$2_2096 WL_17 VSS SL_9N a_n67599_5405# nmos$2
Xnmos$2_1340 WL_21 VSS a_n67452_n46# SL_9 nmos$2
Xnmos$2_1362 a_n70603_n2742# VSS a_n70142_n2673# SL_7N nmos$2
Xnmos$2_1351 WL_23 VSS SL_6N a_n72108_n2742# nmos$2
Xnmos$3_186 a_n73617_n11898# VSS VSS a_n73470_n11818# nmos$3
Xnmos$3_197 a_n70603_n9282# VSS VSS a_n70456_n9202# nmos$3
Xnmos$2_1384 WL_26 VSS SL_0N a_n81149_n6666# nmos$2
Xnmos$2_1373 WL_26 VSS a_n74975_n6586# SL_4 nmos$2
Xnmos$2_1395 WL_26 VSS a_n67452_n6586# SL_9 nmos$2
Xpmos_1213 a_n79497_15650# VDD VDD a_n79644_15869# pmos
Xpmos_1224 a_n77988_13034# VDD VDD a_n78135_13253# pmos
Xpmos_1202 a_n79497_10418# VDD VDD a_n79644_10637# pmos
Xpmos_1235 a_n67599_9329# VDD a_n67452_9110# VDD pmos
Xpmos_1268 a_n74975_15650# VDD VDD a_n75122_15869# pmos
Xpmos_1246 a_n69104_11945# VDD a_n68957_11726# VDD pmos
Xpmos_1257 a_n73470_11726# VDD VDD a_n73617_11945# pmos
Xpmos_417 a_n64438_n28971# VDD VDD a_n64585_n29051# pmos
Xpmos_406 a_n57062_n29051# VDD a_n56915_n28971# VDD pmos
Xpmos_1279 a_n68957_13034# VDD VDD a_n69104_13253# pmos
Xpmos_439 a_n77988_n28971# VDD VDD a_n78135_n29051# pmos
Xpmos_428 a_n69104_n29051# VDD a_n68957_n28971# VDD pmos
Xnmos_1100 a_n52396_23498# VSS a_n52543_23717# VSS nmos
Xnmos_1111 a_n50888_19574# VSS a_n51035_19793# VSS nmos
Xnmos_1133 a_n41856_27422# VSS a_n42003_27641# VSS nmos
Xnmos_1122 a_n53901_24806# VSS a_n54048_25025# VSS nmos
Xnmos_1144 a_n26495_18356# VSS VSS COMP9 nmos
Xnmos_1166 ML_3 VSS VSS a_n28485_27082# nmos
Xnmos_1177 a_n27274_22670# VSS a_n27618_22670# VSS nmos
Xnmos_1155 a_n27618_19794# VSS m1_n27919_19806# VSS nmos
Xnmos_1199 a_n37338_19574# VSS a_n37485_19793# VSS nmos
Xnmos_1188 a_n34324_18266# VSS a_n34471_18485# VSS nmos
Xpmos_1780 ML_14 VDD a_n28485_11264# VDD pmos
Xpmos_1791 a_n26495_14042# VDD VDD m1_n26796_14054# pmos
Xpmos_962 a_n62930_9110# VDD VDD a_n63077_9329# pmos
Xpmos_951 a_n62930_7802# VDD VDD a_n63077_8021# pmos
Xpmos_940 a_n61572_5405# VDD a_n61425_5186# VDD pmos
Xnmos$2_4916 a_n45017_27641# VSS a_n44556_27411# m2_n44135_352# nmos$2
Xnmos$2_4905 a_n46055_24795# VSS ML_2 m1_n45958_25003# nmos$2
Xpmos_995 a_n62930_14342# VDD VDD a_n63077_14561# pmos
Xpmos_984 a_n66090_14561# VDD a_n65943_14342# VDD pmos
Xpmos_973 a_n65943_10418# VDD VDD a_n66090_10637# pmos
Xnmos$2_4927 WL_1 VSS SL_23N a_n46516_26333# nmos$2
Xnmos$2_4938 a_n46369_24806# VSS SL_23 a_n46055_24795# nmos$2
Xnmos$2_4949 WL_7 VSS a_n34324_18266# SL_31 nmos$2
Xnmos$5_407 VEVAL VSS m1_n65532_4075# VSS nmos$5
Xnmos$5_429 VEVAL VSS m1_n62519_9307# VSS nmos$5
Xnmos$5_418 VEVAL VSS m1_n62519_7999# VSS nmos$5
Xnmos$5_930 VEVAL VSS m1_n42954_22387# VSS nmos$5
Xnmos$5_963 VEVAL VSS m1_n47463_27619# VSS nmos$5
Xnmos$5_952 VEVAL VSS m1_n51985_23695# VSS nmos$5
Xnmos$5_941 VEVAL VSS m1_n47463_19771# VSS nmos$5
Xnmos$5_974 VEVAL VSS m1_n41445_27619# VSS nmos$5
Xnmos$5_985 VEVAL VSS m1_n42954_27619# VSS nmos$5
Xnmos$5_996 VEVAL VSS m1_n38432_18463# VSS nmos$5
Xnmos$2_1181 a_n79644_n1434# VSS a_n79183_n1365# SL_1N nmos$2
Xnmos$2_1170 a_n79644_n4050# VSS a_n79183_n3981# SL_1N nmos$2
Xnmos$2_1192 a_n80688_n57# VSS ML_21 m1_n80591_151# nmos$2
Xpmos_1032 a_n60063_15869# VDD a_n59916_15650# VDD pmos
Xpmos_1043 a_n55410_13034# VDD VDD a_n55557_13253# pmos
Xpmos_1021 a_n58558_11945# VDD a_n58411_11726# VDD pmos
Xpmos_1010 a_n54048_10637# VDD a_n53901_10418# VDD pmos
Xpmos_1065 a_n61425_13034# VDD VDD a_n61572_13253# pmos
Xpmos_1054 a_n61425_6494# VDD VDD a_n61572_6713# pmos
Xpmos_1076 a_n68957_3878# VDD VDD a_n69104_4097# pmos
Xpmos_225 a_n41856_n46# VDD VDD a_n42003_173# pmos
Xpmos_203 a_n43512_n1434# VDD a_n43365_n1354# VDD pmos
Xpmos_214 a_n41856_n2662# VDD VDD a_n42003_n2742# pmos
Xpmos_1098 a_n72108_5405# VDD a_n71961_5186# VDD pmos
Xpmos_1087 a_n74975_2570# VDD VDD a_n75122_2789# pmos
Xpmos_236 a_n27618_n13280# VDD VDD m1_n27919_n13268# pmos
Xpmos_258 a_n27274_n10404# VDD VDD a_n27618_n10404# pmos
Xpmos_247 a_n26495_n8966# VDD COMP28 VDD pmos
Xnmos_909 a_n38843_13034# VSS a_n38990_13253# VSS nmos
Xpmos_269 a_n35829_n11818# VDD VDD a_n35976_n11898# pmos
Xpmos_781 a_n61572_173# VDD a_n61425_n46# VDD pmos
Xpmos_770 a_n66090_173# VDD a_n65943_n46# VDD pmos
Xnmos$2_4724 a_n50574_22179# VSS ML_4 m1_n50477_22387# nmos$2
Xnmos$2_4713 a_n50888_19574# VSS SL_20 a_n50574_19563# nmos$2
Xnmos$2_4702 WL_7 VSS SL_18N a_n54048_18485# nmos$2
Xpmos_792 a_n56915_n5278# VDD VDD a_n57062_n5358# pmos
Xnmos$2_4757 WL_3 VSS SL_19N a_n52543_23717# nmos$2
Xnmos$2_4746 a_n54048_23717# VSS a_n53587_23487# SL_18N nmos$2
Xnmos$2_4735 a_n52082_22179# VSS ML_4 m1_n51985_22387# nmos$2
Xnmos$5_204 VEVAL VSS m1_n74564_n11621# VSS nmos$5
Xnmos$5_226 VEVAL VSS m1_n76072_n7697# VSS nmos$5
Xnmos$5_215 VEVAL VSS m1_n80591_n6389# VSS nmos$5
Xnmos$2_4768 a_n47874_22190# VSS SL_22 a_n47560_22179# nmos$2
Xnmos$2_4779 a_n49530_21101# VSS a_n49069_20871# SL_21N nmos$2
Xnmos$5_248 VEVAL VSS m1_n79086_n2465# VSS nmos$5
Xnmos$5_237 VEVAL VSS m1_n79086_n3773# VSS nmos$5
Xnmos$5_259 VEVAL VSS m1_n73059_n3773# VSS nmos$5
Xnmos$2_911 WL_30 VSS SL_7N a_n70603_n11898# nmos$2
Xnmos$2_900 WL_31 VSS a_n67452_n13126# SL_9 nmos$2
Xnmos$2_922 a_n68643_n10521# VSS ML_29 m1_n68546_n10313# nmos$2
Xnmos$2_944 a_n73470_n11818# VSS SL_5 a_n73156_n11829# nmos$2
Xnmos$2_933 a_n71647_n13137# VSS ML_31 m1_n71550_n12929# nmos$2
Xnmos$2_955 a_n73470_n10510# VSS SL_5 a_n73156_n10521# nmos$2
Xnmos$2_966 WL_29 VSS SL_5N a_n73617_n10590# nmos$2
Xnmos$2_977 a_n73470_n9202# VSS SL_5 a_n73156_n9213# nmos$2
Xnmos$2_988 WL_27 VSS SL_6N a_n72108_n7974# nmos$2
Xnmos$2_999 a_n70456_n9202# VSS SL_7 a_n70142_n9213# nmos$2
Xpmos_12 a_n46369_n28971# VDD VDD a_n46516_n29051# pmos
Xpmos_23 a_n48021_n29051# VDD a_n47874_n28971# VDD pmos
Xpmos_34 a_n40498_n11898# VDD a_n40351_n11818# VDD pmos
Xpmos_45 a_n43512_n9282# VDD a_n43365_n9202# VDD pmos
Xpmos_78 a_n52396_n13126# VDD VDD a_n52543_n13206# pmos
Xpmos_56 a_n40498_n9282# VDD a_n40351_n9202# VDD pmos
Xpmos_67 a_n40498_n7974# VDD a_n40351_n7894# VDD pmos
Xpmos_89 a_n52396_n10510# VDD VDD a_n52543_n10590# pmos
Xnmos$5_771 VEVAL VSS m1_n35418_6691# VSS nmos$5
Xnmos$5_760 VEVAL VSS m1_n38432_4075# VSS nmos$5
Xnmos$5_793 VEVAL VSS m1_n33913_14539# VSS nmos$5
Xnmos$5_782 VEVAL VSS m1_n38432_10615# VSS nmos$5
Xnmos_717 a_n81002_23498# VSS a_n81149_23717# VSS nmos
Xnmos_706 a_n76483_19574# VSS a_n76630_19793# VSS nmos
Xnmos_739 a_n70456_26114# VSS a_n70603_26333# VSS nmos
Xnmos_728 a_n77988_24806# VSS a_n78135_25025# VSS nmos
Xnmos$2_4009 WL_19 VSS a_n41856_2570# SL_26 nmos$2
Xnmos$2_3308 a_n70456_27422# VSS SL_7 a_n70142_27411# nmos$2
Xnmos$2_3319 a_n67452_26114# VSS SL_9 a_n67138_26103# nmos$2
Xnmos$5_1018 VEVAL VSS m1_n38432_25003# VSS nmos$5
Xnmos$5_1007 VEVAL VSS m1_n35418_21079# VSS nmos$5
Xnmos$3_708 a_n54048_21101# VSS VSS a_n53901_20882# nmos$3
Xnmos$5_1029 VEVAL VSS m1_n53490_19771# VSS nmos$5
Xnmos$3_719 a_n64585_17177# VSS VSS a_n64438_16958# nmos$3
Xnmos$2_2618 a_n81002_7802# VSS SL_0 a_n80688_7791# nmos$2
Xnmos$2_2629 a_n76630_6713# VSS a_n76169_6483# SL_3N nmos$2
Xnmos$2_2607 a_n81002_6494# VSS SL_0 a_n80688_6483# nmos$2
Xnmos$2_207 WL_29 VSS SL_22N a_n48021_n10590# nmos$2
Xnmos$2_1928 a_n56601_2559# VSS ML_19 m1_n56504_2767# nmos$2
Xnmos$2_218 WL_31 VSS SL_20N a_n51035_n13206# nmos$2
Xnmos$2_229 a_n54048_n10590# VSS a_n53587_n10521# SL_18N nmos$2
Xnmos$2_1917 WL_26 VSS a_n62930_n6586# SL_12 nmos$2
Xnmos$2_1906 a_n59916_n6586# VSS SL_14 a_n59602_n6597# nmos$2
Xnmos$2_1939 a_n55557_4097# VSS a_n55096_3867# SL_17N nmos$2
Xnmos$2_5200 WL_20 VSS a_n55410_1262# SL_17 nmos$2
Xnmos$2_5222 WL_20 VSS a_n59916_1262# SL_14 nmos$2
Xnmos$2_5211 WL_20 VSS a_n64438_1262# SL_11 nmos$2
Xnmos$2_5233 a_n68643_1251# VSS ML_20 m1_n68546_1459# nmos$2
Xnmos$2_5244 WL_20 VSS SL_1N a_n79644_1481# nmos$2
Xnmos$2_4532 WL_7 VSS SL_25N a_n43512_18485# nmos$2
Xnmos$2_4521 WL_8 VSS SL_26N a_n42003_17177# nmos$2
Xnmos$2_4510 a_n46369_14342# VSS SL_23 a_n46055_14331# nmos$2
Xnmos$2_5277 WL_20 VSS a_n46369_1262# SL_23 nmos$2
Xnmos$2_5255 WL_20 VSS SL_13N a_n61572_1481# nmos$2
Xnmos$2_5266 WL_20 VSS SL_5N a_n73617_1481# nmos$2
Xnmos$2_4543 a_n41542_19563# VSS ML_6 m1_n41445_19771# nmos$2
Xnmos$2_4565 a_n46516_18485# VSS a_n46055_18255# SL_23N nmos$2
Xnmos$2_4554 a_n43365_16958# VSS SL_25 a_n43051_16947# nmos$2
Xnmos$2_3820 WL_17 VSS SL_29N a_n37485_5405# nmos$2
Xnmos$2_3831 WL_17 VSS SL_28N a_n38990_5405# nmos$2
Xnmos$2_4587 WL_4 VSS m2_n44135_352# a_n45017_22409# nmos$2
Xnmos$2_4576 a_n44870_19574# VSS SL_24 a_n44556_19563# nmos$2
Xnmos$2_4598 a_n46055_20871# VSS ML_5 m1_n45958_21079# nmos$2
Xnmos$2_3864 a_n35976_8021# VSS a_n35515_7791# SL_30N nmos$2
Xnmos$2_3842 a_n37338_7802# VSS SL_29 a_n37024_7791# nmos$2
Xnmos$2_3853 WL_16 VSS a_n34324_6494# SL_31 nmos$2
Xnmos$2_3897 a_n35976_11945# VSS a_n35515_11715# SL_30N nmos$2
Xnmos$2_3886 WL_13 VSS a_n34324_10418# SL_31 nmos$2
Xnmos$2_3875 a_n35829_7802# VSS SL_30 a_n35515_7791# nmos$2
Xnmos$2_730 a_n38990_173# VSS a_n38529_n57# SL_28N nmos$2
Xnmos$2_752 WL_21 VSS SL_30N a_n35976_173# nmos$2
Xnmos$2_763 WL_21 VSS a_n35829_n46# SL_30 nmos$2
Xnmos$2_741 a_n34010_n1365# VSS ML_22 m1_n33913_n1157# nmos$2
Xnmos$2_774 a_n38843_n2662# VSS SL_28 a_n38529_n2673# nmos$2
Xnmos$2_785 WL_26 VSS a_n37338_n6586# SL_29 nmos$2
Xnmos$2_796 WL_26 VSS a_n35829_n6586# SL_30 nmos$2
Xpmos$1_120 a_n28089_23614# VDD a_n26151_24108# a_n27618_24108# pmos$1
Xnmos$5_590 VEVAL VSS m1_n70045_18463# VSS nmos$5
Xnmos$1_20 OUTP VSS a_n26151_n6090# a_n27618_n6090# nmos$1
Xnmos$1_31 a_n28089_n3708# VSS m1_n26796_n3202# a_n26151_n3214# nmos$1
Xnmos$1_75 a_n28089_10672# VSS m1_n26796_11178# a_n26151_11166# nmos$1
Xnmos$1_64 a_n28089_9234# VSS m1_n26796_9740# a_n26151_9728# nmos$1
Xnmos$1_53 a_n28089_4920# VSS m1_n26796_5426# a_n26151_5414# nmos$1
Xnmos$1_42 a_n28089_606# VSS m1_n26796_1112# a_n26151_1100# nmos$1
Xnmos$1_97 OUTP VSS m1_n27919_24120# a_n27274_24108# nmos$1
Xnmos$1_86 a_n28089_17862# VSS a_n27274_18356# m1_n28364_18279# nmos$1
Xnmos_525 a_n61425_11726# VSS a_n61572_11945# VSS nmos
Xnmos_503 a_n65943_6494# VSS a_n66090_6713# VSS nmos
Xnmos_514 a_n64438_5186# VSS a_n64585_5405# VSS nmos
Xnmos_547 a_n61425_15650# VSS a_n61572_15869# VSS nmos
Xnmos_536 a_n67452_13034# VSS a_n67599_13253# VSS nmos
Xnmos_558 a_n59916_11726# VSS a_n60063_11945# VSS nmos
Xnmos$2_3116 a_n74975_19574# VSS SL_4 a_n74661_19563# nmos$2
Xnmos$2_3105 WL_7 VSS a_n76483_18266# SL_3 nmos$2
Xnmos_569 a_n56915_14342# VSS a_n57062_14561# VSS nmos
Xnmos$2_3149 a_n79183_19563# VSS ML_6 m1_n79086_19771# nmos$2
Xnmos$2_3127 WL_7 VSS a_n77988_18266# SL_2 nmos$2
Xnmos$2_3138 a_n80688_16947# VSS ML_8 m1_n80591_17155# nmos$2
Xnmos$2_2415 a_n53901_15650# VSS SL_18 a_n53587_15639# nmos$2
Xnmos$2_2404 a_n56601_14331# VSS ML_10 m1_n56504_14539# nmos$2
Xnmos$3_505 a_n69104_8021# VSS VSS a_n68957_7802# nmos$3
Xnmos$3_516 a_n81149_4097# VSS VSS a_n81002_3878# nmos$3
Xnmos$3_549 a_n78135_13253# VSS VSS a_n77988_13034# nmos$3
Xnmos$3_538 a_n75122_11945# VSS VSS a_n74975_11726# nmos$3
Xnmos$3_527 a_n75122_6713# VSS VSS a_n74975_6494# nmos$3
Xnmos$2_2448 WL_18 VSS a_n68957_3878# SL_8 nmos$2
Xnmos$2_2437 WL_18 VSS a_n70456_3878# SL_7 nmos$2
Xnmos$2_2426 a_n68957_2570# VSS SL_8 a_n68643_2559# nmos$2
Xnmos$2_1703 WL_21 VSS SL_9N a_n67599_173# nmos$2
Xnmos$2_2459 a_n73617_2789# VSS a_n73156_2559# SL_5N nmos$2
Xnmos$2_1725 WL_21 VSS a_n62930_n46# SL_12 nmos$2
Xnmos$2_1714 a_n61572_n1434# VSS a_n61111_n1365# SL_13N nmos$2
Xnmos$2_1736 a_n62616_n2673# VSS ML_23 m1_n62519_n2465# nmos$2
Xnmos$2_1747 WL_23 VSS SL_12N a_n63077_n2742# nmos$2
Xnmos$2_1758 a_n64124_n2673# VSS ML_23 m1_n64027_n2465# nmos$2
Xnmos$2_1769 a_n56601_n3981# VSS ML_24 m1_n56504_n3773# nmos$2
Xpmos_1609 a_n60063_26333# VDD a_n59916_26114# VDD pmos
Xnmos$2_5041 WL_3 VSS a_n34324_23498# SL_31 nmos$2
Xnmos$2_5052 a_n35829_23498# VSS SL_30 a_n35515_23487# nmos$2
Xnmos$2_5030 WL_4 VSS a_n34324_22190# SL_31 nmos$2
Xnmos$2_5074 WL_0 VSS SL_31N a_n34471_27641# nmos$2
Xnmos$2_5063 WL_2 VSS a_n34324_24806# SL_31 nmos$2
Xnmos$2_5085 WL_2 VSS a_n37338_24806# SL_29 nmos$2
Xnmos$2_4340 a_n47560_14331# VSS ML_10 m1_n47463_14539# nmos$2
Xnmos$2_5096 a_n38843_27422# VSS SL_28 a_n38529_27411# nmos$2
Xnmos$2_4362 WL_9 VSS a_n46369_15650# SL_23 nmos$2
Xnmos$2_4351 a_n49530_14561# VSS a_n49069_14331# SL_21N nmos$2
Xnmos$2_4373 WL_14 VSS a_n40351_9110# SL_27 nmos$2
Xnmos$2_4384 a_n41856_9110# VSS SL_26 a_n41542_9099# nmos$2
Xnmos$2_3661 WL_0 VSS SL_13N a_n61572_27641# nmos$2
Xnmos$2_3672 a_n62616_26103# VSS ML_1 m1_n62519_26311# nmos$2
Xnmos$2_3650 WL_2 VSS SL_11N a_n64585_25025# nmos$2
Xnmos$2_4395 a_n40037_11715# VSS ML_12 m1_n39940_11923# nmos$2
Xnmos$2_3694 WL_0 VSS SL_10N a_n66090_27641# nmos$2
Xnmos$2_3683 WL_2 VSS SL_9N a_n67599_25025# nmos$2
Xnmos$2_2971 WL_6 VSS a_n67452_19574# SL_9 nmos$2
Xnmos$2_2960 a_n70142_16947# VSS ML_8 m1_n70045_17155# nmos$2
Xnmos$2_2993 a_n73470_18266# VSS SL_5 a_n73156_18255# nmos$2
Xnmos$2_2982 a_n71961_16958# VSS SL_6 a_n71647_16947# nmos$2
Xnmos$2_560 a_n54048_n6666# VSS a_n53587_n6597# SL_18N nmos$2
Xnmos$2_571 a_n43365_n6586# VSS SL_25 a_n43051_n6597# nmos$2
Xnmos$2_593 a_n35976_n10590# VSS a_n35515_n10521# SL_30N nmos$2
Xnmos$2_582 a_n48021_n6666# VSS a_n47560_n6597# SL_22N nmos$2
Xnmos_300 a_n70456_n9202# VSS a_n70603_n9282# VSS nmos
Xnmos_311 a_n79497_n13126# VSS a_n79644_n13206# VSS nmos
Xnmos_322 a_n79497_n7894# VSS a_n79644_n7974# VSS nmos
Xnmos_333 a_n79497_n5278# VSS a_n79644_n5358# VSS nmos
Xnmos_344 a_n76483_n46# VSS a_n76630_173# VSS nmos
Xnmos_366 a_n70456_n1354# VSS a_n70603_n1434# VSS nmos
Xnmos_355 a_n74975_n3970# VSS a_n75122_n4050# VSS nmos
Xnmos_399 a_n61425_n13126# VSS a_n61572_n13206# VSS nmos
Xnmos_377 a_n56915_n10510# VSS a_n57062_n10590# VSS nmos
Xnmos_388 a_n59916_n7894# VSS a_n60063_n7974# VSS nmos
Xnmos$2_2223 a_n64124_14331# VSS ML_10 m1_n64027_14539# nmos$2
Xnmos$2_2212 WL_12 VSS SL_10N a_n66090_11945# nmos$2
Xnmos$2_2201 WL_14 VSS SL_9N a_n67599_9329# nmos$2
Xnmos$3_324 a_n66090_n11898# VSS VSS a_n65943_n11818# nmos$3
Xnmos$3_302 a_n60063_n7974# VSS VSS a_n59916_n7894# nmos$3
Xnmos$3_313 a_n54048_n6666# VSS VSS a_n53901_n6586# nmos$3
Xnmos$2_2245 WL_9 VSS a_n64438_15650# SL_11 nmos$2
Xnmos$2_2256 a_n61111_14331# VSS ML_10 m1_n61014_14539# nmos$2
Xnmos$2_2234 a_n67599_13253# VSS a_n67138_13023# SL_9N nmos$2
Xnmos$3_357 a_n64585_n2742# VSS VSS a_n64438_n2662# nmos$3
Xnmos$2_1511 a_n57062_n9282# VSS a_n56601_n9213# SL_16N nmos$2
Xnmos$3_335 a_n63077_n7974# VSS VSS a_n62930_n7894# nmos$3
Xnmos$2_1500 WL_27 VSS a_n58411_n7894# SL_15 nmos$2
Xnmos$3_346 a_n64585_n4050# VSS VSS a_n64438_n3970# nmos$3
Xnmos$2_2278 WL_9 VSS SL_11N a_n64585_15869# nmos$2
Xnmos$2_2267 a_n64585_13253# VSS a_n64124_13023# SL_11N nmos$2
Xnmos$2_2289 a_n53587_9099# VSS ML_14 m1_n53490_9307# nmos$2
Xnmos$3_379 a_n58558_n2742# VSS VSS a_n58411_n2662# nmos$3
Xnmos$2_1533 a_n61572_n13206# VSS a_n61111_n13137# SL_13N nmos$2
Xnmos$2_1544 WL_30 VSS SL_11N a_n64585_n11898# nmos$2
Xnmos$2_1555 a_n61572_n11898# VSS a_n61111_n11829# SL_13N nmos$2
Xnmos$2_1522 a_n55096_n7905# VSS ML_27 m1_n54999_n7697# nmos$2
Xnmos$3_368 a_n58558_n5358# VSS VSS a_n58411_n5278# nmos$3
Xnmos$2_1577 a_n67599_n11898# VSS a_n67138_n11829# SL_9N nmos$2
Xnmos$2_1566 a_n64124_n13137# VSS ML_31 m1_n64027_n12929# nmos$2
Xnmos$2_1588 a_n64124_n10521# VSS ML_29 m1_n64027_n10313# nmos$2
Xnmos$2_1599 a_n64438_n9202# VSS SL_11 a_n64124_n9213# nmos$2
Xpmos_2118 a_n46516_22409# VDD a_n46369_22190# VDD pmos
Xpmos_2107 a_n52396_22190# VDD VDD a_n52543_22409# pmos
Xpmos_1417 a_n75122_27641# VDD a_n74975_27422# VDD pmos
Xpmos_2129 a_n47874_24806# VDD VDD a_n48021_25025# pmos
Xpmos_1406 a_n75122_22409# VDD a_n74975_22190# VDD pmos
Xpmos_1439 a_n70603_27641# VDD a_n70456_27422# VDD pmos
Xpmos_1428 a_n79497_27422# VDD VDD a_n79644_27641# pmos
Xnmos_1304 a_n76483_1262# VSS a_n76630_1481# VSS nmos
Xnmos$2_4181 a_n52396_7802# VSS SL_19 a_n52082_7791# nmos$2
Xnmos$2_4192 a_n52543_6713# VSS a_n52082_6483# SL_19N nmos$2
Xnmos$2_4170 a_n50574_5175# VSS ML_17 m1_n50477_5383# nmos$2
Xnmos$2_3480 a_n55410_20882# VSS SL_17 a_n55096_20871# nmos$2
Xnmos$2_3491 a_n53901_23498# VSS SL_18 a_n53587_23487# nmos$2
Xnmos$3_880 a_n48021_13253# VSS VSS a_n47874_13034# nmos$3
Xnmos$2_2790 a_n78135_15869# VSS a_n77674_15639# SL_2N nmos$2
Xnmos$3_891 a_n45017_9329# VSS VSS a_n44870_9110# nmos$3
Xnmos$2_390 WL_23 VSS SL_19N a_n52543_n2742# nmos$2
Xpmos_1962 a_n47874_14342# VDD VDD a_n48021_14561# pmos
Xpmos_1951 a_n53901_14342# VDD VDD a_n54048_14561# pmos
Xpmos_1940 a_n51035_13253# VDD a_n50888_13034# VDD pmos
Xpmos_1973 a_n40498_9329# VDD a_n40351_9110# VDD pmos
Xpmos_1984 a_n40498_10637# VDD a_n40351_10418# VDD pmos
Xpmos_1995 a_n43512_10637# VDD a_n43365_10418# VDD pmos
Xnmos$1_9 a_n28089_n13774# VSS a_n27274_n13280# m1_n28364_n13357# nmos$1
Xnmos_10 a_n49383_n28971# VSS a_n49530_n29051# VSS nmos
Xnmos_21 a_n44870_n13126# VSS a_n45017_n13206# VSS nmos
Xnmos_43 a_n47874_n10510# VSS a_n48021_n10590# VSS nmos
Xnmos_32 a_n44870_n6586# VSS a_n45017_n6666# VSS nmos
Xnmos_65 a_n50888_n11818# VSS a_n51035_n11898# VSS nmos
Xnmos_54 a_n53901_n6586# VSS a_n54048_n6666# VSS nmos
Xnmos_76 a_n52396_n3970# VSS a_n52543_n4050# VSS nmos
Xnmos_87 a_n50888_n46# VSS a_n51035_173# VSS nmos
Xnmos_98 a_n44870_n5278# VSS a_n45017_n5358# VSS nmos
Xnmos_130 a_n27274_n13280# VSS a_n27618_n13280# VSS nmos
Xnmos_141 a_n27274_n7528# VSS a_n27618_n7528# VSS nmos
Xnmos_185 a_n37338_n1354# VSS a_n37485_n1434# VSS nmos
Xnmos_163 a_n37338_n11818# VSS a_n37485_n11898# VSS nmos
Xnmos_152 a_n26151_n8966# VSS a_n26495_n8966# VSS nmos
Xnmos_174 a_n35829_n6586# VSS a_n35976_n6666# VSS nmos
Xnmos_196 a_n34324_n2662# VSS a_n34471_n2742# VSS nmos
Xnmos$2_2020 a_n56601_7791# VSS ML_15 m1_n56504_7999# nmos$2
Xnmos$2_2031 a_n56915_7802# VSS SL_16 a_n56601_7791# nmos$2
Xnmos$3_110 a_n45017_n2742# VSS VSS a_n44870_n2662# nmos$3
Xnmos$3_121 a_n35976_n10590# VSS VSS a_n35829_n10510# nmos$3
Xnmos$3_132 a_n37485_n6666# VSS VSS a_n37338_n6586# nmos$3
Xnmos$2_2053 WL_18 VSS a_n61425_3878# SL_13 nmos$2
Xnmos$2_2042 WL_19 VSS a_n62930_2570# SL_12 nmos$2
Xnmos$2_2064 WL_19 VSS SL_9N a_n67599_2789# nmos$2
Xnmos$2_1330 WL_21 VSS SL_7N a_n70603_173# nmos$2
Xnmos$3_154 a_n37485_n2742# VSS VSS a_n37338_n2662# nmos$3
Xnmos$3_165 a_n70603_n29051# VSS VSS a_n70456_n28971# nmos$3
Xnmos$3_143 a_n37485_n4050# VSS VSS a_n37338_n3970# nmos$3
Xnmos$2_2086 a_n66090_6713# VSS a_n65629_6483# SL_10N nmos$2
Xnmos$2_2097 a_n67599_6713# VSS a_n67138_6483# SL_9N nmos$2
Xnmos$2_2075 a_n66090_4097# VSS a_n65629_3867# SL_10N nmos$2
Xnmos$2_1341 WL_22 VSS a_n68957_n1354# SL_8 nmos$2
Xnmos$2_1363 a_n70142_n2673# VSS ML_23 m1_n70045_n2465# nmos$2
Xnmos$2_1352 WL_23 VSS SL_4N a_n75122_n2742# nmos$2
Xnmos$3_176 a_n70603_n13206# VSS VSS a_n70456_n13126# nmos$3
Xnmos$3_187 a_n73617_n10590# VSS VSS a_n73470_n10510# nmos$3
Xnmos$3_198 a_n70603_n7974# VSS VSS a_n70456_n7894# nmos$3
Xnmos$2_1385 a_n81002_n6586# VSS SL_0 a_n80688_n6597# nmos$2
Xnmos$2_1374 a_n74975_n6586# VSS SL_4 a_n74661_n6597# nmos$2
Xnmos$2_1396 a_n67452_n6586# VSS SL_9 a_n67138_n6597# nmos$2
Xpmos_1214 a_n78135_15869# VDD a_n77988_15650# VDD pmos
Xpmos_1225 a_n76630_13253# VDD a_n76483_13034# VDD pmos
Xpmos_1203 a_n78135_10637# VDD a_n77988_10418# VDD pmos
Xpmos_1247 a_n67599_10637# VDD a_n67452_10418# VDD pmos
Xpmos_1258 a_n71961_10418# VDD VDD a_n72108_10637# pmos
Xpmos_1236 a_n70456_9110# VDD VDD a_n70603_9329# pmos
Xpmos_407 a_n54048_n29051# VDD a_n53901_n28971# VDD pmos
Xpmos_1269 a_n73617_15869# VDD a_n73470_15650# VDD pmos
Xpmos_429 a_n72108_n29051# VDD a_n71961_n28971# VDD pmos
Xpmos_418 a_n65943_n28971# VDD VDD a_n66090_n29051# pmos
Xnmos_1101 a_n47874_22190# VSS a_n48021_22409# VSS nmos
Xnmos_1123 a_n53901_27422# VSS a_n54048_27641# VSS nmos
Xnmos_1134 a_n44870_26114# VSS a_n45017_26333# VSS nmos
Xnmos_1112 a_n50888_23498# VSS a_n51035_23717# VSS nmos
Xnmos_1145 a_n26495_16918# VSS VSS COMP10 nmos
Xnmos_1178 OUTP VSS a_n28089_22176# VSS nmos
Xnmos_1167 OUTP VSS a_n28089_20738# VSS nmos
Xnmos_1156 a_n27274_19794# VSS a_n27618_19794# VSS nmos
Xnmos_1189 a_n34324_16958# VSS a_n34471_17177# VSS nmos
Xpmos_1781 ML_12 VDD a_n28485_14140# VDD pmos
Xpmos_1770 a_n27618_9728# VDD VDD m1_n27919_9740# pmos
Xpmos_930 a_n65943_5186# VDD VDD a_n66090_5405# pmos
Xpmos_1792 a_n27618_14042# VDD VDD m1_n27919_14054# pmos
Xpmos_963 a_n64438_10418# VDD VDD a_n64585_10637# pmos
Xpmos_952 a_n61572_9329# VDD a_n61425_9110# VDD pmos
Xpmos_941 a_n61572_6713# VDD a_n61425_6494# VDD pmos
Xnmos$2_4906 a_n46516_25025# VSS a_n46055_24795# SL_23N nmos$2
Xpmos_996 a_n63077_14561# VDD a_n62930_14342# VDD pmos
Xpmos_985 a_n64585_14561# VDD a_n64438_14342# VDD pmos
Xpmos_974 a_n67452_10418# VDD VDD a_n67599_10637# pmos
Xnmos$2_4917 WL_0 VSS m2_n44135_352# a_n45017_27641# nmos$2
Xnmos$2_4928 WL_1 VSS a_n43365_26114# SL_25 nmos$2
Xnmos$2_4939 a_n46369_26114# VSS SL_23 a_n46055_26103# nmos$2
Xnmos$5_408 VEVAL VSS m1_n65532_6691# VSS nmos$5
Xnmos$5_419 VEVAL VSS m1_n61014_7999# VSS nmos$5
Xnmos$5_920 VEVAL VSS m1_n45958_22387# VSS nmos$5
Xnmos$5_964 VEVAL VSS m1_n47463_26311# VSS nmos$5
Xnmos$5_953 VEVAL VSS m1_n50477_23695# VSS nmos$5
Xnmos$5_931 VEVAL VSS m1_n42954_19771# VSS nmos$5
Xnmos$5_942 VEVAL VSS m1_n50477_18463# VSS nmos$5
Xnmos$5_975 VEVAL VSS m1_n39940_27619# VSS nmos$5
Xnmos$5_986 VEVAL VSS m1_n42954_25003# VSS nmos$5
Xnmos$5_997 VEVAL VSS m1_n38432_19771# VSS nmos$5
Xnmos$2_1160 a_n81149_n5358# VSS a_n80688_n5289# SL_0N nmos$2
Xnmos$2_1171 WL_24 VSS SL_1N a_n79644_n4050# nmos$2
Xnmos$2_1193 a_n81002_n46# VSS SL_0 a_n80688_n57# nmos$2
Xnmos$2_1182 WL_22 VSS SL_1N a_n79644_n1434# nmos$2
Xpmos_1000 a_n55410_9110# VDD VDD a_n55557_9329# pmos
Xpmos_1033 a_n58411_15650# VDD VDD a_n58558_15869# pmos
Xpmos_1011 a_n55557_10637# VDD a_n55410_10418# VDD pmos
Xpmos_1022 a_n58558_10637# VDD a_n58411_10418# VDD pmos
Xpmos_1044 a_n55557_13253# VDD a_n55410_13034# VDD pmos
Xpmos_1055 a_n61425_11726# VDD VDD a_n61572_11945# pmos
Xpmos_1077 a_n67599_4097# VDD a_n67452_3878# VDD pmos
Xpmos_1066 a_n68957_1262# VDD VDD a_n69104_1481# pmos
Xpmos_215 a_n40498_n1434# VDD a_n40351_n1354# VDD pmos
Xpmos_204 a_n43512_n2742# VDD a_n43365_n2662# VDD pmos
Xpmos_1099 a_n72108_6713# VDD a_n71961_6494# VDD pmos
Xpmos_1088 a_n74975_1262# VDD VDD a_n75122_1481# pmos
Xpmos_237 a_n27274_n11842# VDD VDD a_n27618_n11842# pmos
Xpmos_226 a_n26495_n11842# VDD COMP30 VDD pmos
Xpmos_259 ML_31 VDD a_n28485_n13182# VDD pmos
Xpmos_248 a_n26151_n8966# VDD VDD a_n26495_n8966# pmos
Xpmos_2290 a_n37338_27422# VDD VDD a_n37485_27641# pmos
Xpmos_771 a_n65943_n46# VDD VDD a_n66090_173# pmos
Xpmos_760 a_n64585_n4050# VDD a_n64438_n3970# VDD pmos
Xnmos$2_4714 WL_6 VSS a_n50888_19574# SL_20 nmos$2
Xnmos$2_4703 a_n52082_16947# VSS ML_8 m1_n51985_17155# nmos$2
Xpmos_782 a_n62930_n2662# VDD VDD a_n63077_n2742# pmos
Xpmos_793 a_n55557_n4050# VDD a_n55410_n3970# VDD pmos
Xnmos$2_4747 WL_3 VSS SL_18N a_n54048_23717# nmos$2
Xnmos$2_4725 a_n51035_22409# VSS a_n50574_22179# SL_20N nmos$2
Xnmos$2_4758 a_n52543_21101# VSS a_n52082_20871# SL_19N nmos$2
Xnmos$2_4736 a_n54048_22409# VSS a_n53587_22179# SL_18N nmos$2
Xnmos$5_205 VEVAL VSS m1_n76072_n10313# VSS nmos$5
Xnmos$5_216 VEVAL VSS m1_n80591_n7697# VSS nmos$5
Xnmos$2_4769 a_n48021_22409# VSS a_n47560_22179# SL_22N nmos$2
Xnmos$5_238 VEVAL VSS m1_n79086_n1157# VSS nmos$5
Xnmos$5_249 VEVAL VSS m1_n74564_n2465# VSS nmos$5
Xnmos$5_227 VEVAL VSS m1_n76072_n6389# VSS nmos$5
Xnmos$2_912 a_n70456_n11818# VSS SL_7 a_n70142_n11829# nmos$2
Xnmos$2_901 a_n68643_n13137# VSS ML_31 m1_n68546_n12929# nmos$2
Xnmos$2_945 WL_30 VSS a_n73470_n11818# SL_5 nmos$2
Xnmos$2_934 a_n72108_n13206# VSS a_n71647_n13137# SL_6N nmos$2
Xnmos$2_956 a_n72108_n10590# VSS a_n71647_n10521# SL_6N nmos$2
Xnmos$2_923 a_n69104_n10590# VSS a_n68643_n10521# SL_8N nmos$2
Xnmos$2_967 WL_31 VSS SL_5N a_n73617_n13206# nmos$2
Xnmos$2_978 WL_28 VSS SL_4N a_n75122_n9282# nmos$2
Xnmos$2_989 WL_27 VSS a_n71961_n7894# SL_6 nmos$2
Xpmos_13 a_n42003_n29051# VDD a_n41856_n28971# VDD pmos
Xpmos_24 a_n52396_n28971# VDD VDD a_n52543_n29051# pmos
Xpmos_35 a_n41856_n11818# VDD VDD a_n42003_n11898# pmos
Xpmos_68 a_n46516_n13206# VDD a_n46369_n13126# VDD pmos
Xpmos_46 a_n44870_n9202# VDD VDD a_n45017_n9282# pmos
Xpmos_57 a_n41856_n9202# VDD VDD a_n42003_n9282# pmos
Xpmos_79 a_n51035_n13206# VDD a_n50888_n13126# VDD pmos
Xnmos$5_772 VEVAL VSS m1_n35418_7999# VSS nmos$5
Xnmos$5_761 VEVAL VSS m1_n36927_4075# VSS nmos$5
Xnmos$5_750 VEVAL VSS m1_n33913_2767# VSS nmos$5
Xnmos$5_794 VEVAL VSS m1_n35418_13231# VSS nmos$5
Xnmos$5_783 VEVAL VSS m1_n38432_9307# VSS nmos$5
Xnmos_707 a_n79497_18266# VSS a_n79644_18485# VSS nmos
Xnmos_729 a_n77988_27422# VSS a_n78135_27641# VSS nmos
Xnmos_718 a_n79497_23498# VSS a_n79644_23717# VSS nmos
Xnmos$2_3309 a_n70142_27411# VSS ML_0 m1_n70045_27619# nmos$2
Xnmos$5_1008 VEVAL VSS m1_n35418_22387# VSS nmos$5
Xnmos$5_1019 VEVAL VSS m1_n38432_27619# VSS nmos$5
Xnmos$3_709 a_n55557_21101# VSS VSS a_n55410_20882# nmos$3
Xnmos$2_2619 a_n77988_7802# VSS SL_2 a_n77674_7791# nmos$2
Xnmos$2_2608 WL_17 VSS SL_0N a_n81149_5405# nmos$2
Xnmos$2_208 a_n47874_n10510# VSS SL_22 a_n47560_n10521# nmos$2
Xnmos$2_1929 a_n55410_2570# VSS SL_17 a_n55096_2559# nmos$2
Xnmos$2_219 WL_31 VSS a_n50888_n13126# SL_20 nmos$2
Xnmos$2_1918 a_n64585_n6666# VSS a_n64124_n6597# SL_11N nmos$2
Xnmos$2_1907 WL_26 VSS a_n59916_n6586# SL_14 nmos$2
Xnmos$2_5201 a_n55557_1481# VSS a_n55096_1251# SL_17N nmos$2
Xnmos$2_5223 a_n60063_1481# VSS a_n59602_1251# SL_14N nmos$2
Xnmos$2_5212 a_n64438_1262# VSS SL_11 a_n64124_1251# nmos$2
Xnmos$2_5234 WL_20 VSS SL_8N a_n69104_1481# nmos$2
Xnmos$2_4522 WL_8 VSS SL_27N a_n40498_17177# nmos$2
Xnmos$2_4533 a_n43512_17177# VSS a_n43051_16947# SL_25N nmos$2
Xnmos$2_4500 WL_9 VSS SL_27N a_n40498_15869# nmos$2
Xnmos$2_4511 a_n46369_15650# VSS SL_23 a_n46055_15639# nmos$2
Xnmos$2_5256 a_n61425_1262# VSS SL_13 a_n61111_1251# nmos$2
Xnmos$2_5267 a_n62930_1262# VSS SL_12 a_n62616_1251# nmos$2
Xnmos$2_5245 a_n79497_1262# VSS SL_1 a_n79183_1251# nmos$2
Xpmos_590 a_n75122_173# VDD a_n74975_n46# VDD pmos
Xnmos$2_4544 WL_6 VSS a_n40351_19574# SL_27 nmos$2
Xnmos$2_4555 a_n43051_18255# VSS ML_7 m1_n42954_18463# nmos$2
Xnmos$2_4566 a_n46055_18255# VSS ML_7 m1_n45958_18463# nmos$2
Xnmos$2_3821 WL_17 VSS a_n37338_5186# SL_29 nmos$2
Xnmos$2_3810 WL_18 VSS a_n38843_3878# SL_28 nmos$2
Xnmos$2_5278 a_n47560_1251# VSS ML_20 m1_n47463_1459# nmos$2
Xnmos$2_4588 a_n43365_22190# VSS SL_25 a_n43051_22179# nmos$2
Xnmos$2_4599 a_n46055_22179# VSS ML_4 m1_n45958_22387# nmos$2
Xnmos$2_4577 WL_6 VSS a_n44870_19574# SL_24 nmos$2
Xnmos$2_3843 a_n37485_8021# VSS a_n37024_7791# SL_29N nmos$2
Xnmos$2_3854 a_n35515_5175# VSS ML_17 m1_n35418_5383# nmos$2
Xnmos$2_3832 a_n38529_5175# VSS ML_17 m1_n38432_5383# nmos$2
Xnmos$2_3898 WL_12 VSS a_n34324_11726# SL_31 nmos$2
Xnmos$2_3887 WL_13 VSS SL_30N a_n35976_10637# nmos$2
Xnmos$2_3865 WL_15 VSS SL_30N a_n35976_8021# nmos$2
Xnmos$2_3876 a_n35829_2570# VSS SL_30 a_n35515_2559# nmos$2
Xnmos$2_720 WL_22 VSS SL_29N a_n37485_n1434# nmos$2
Xnmos$2_753 a_n34471_173# VSS a_n34010_n57# SL_31N nmos$2
Xnmos$2_764 a_n35829_n46# VSS SL_30 a_n35515_n57# nmos$2
Xnmos$2_731 a_n38529_n57# VSS ML_21 m1_n38432_151# nmos$2
Xnmos$2_742 a_n34471_n1434# VSS a_n34010_n1365# SL_31N nmos$2
Xnmos$2_775 WL_23 VSS a_n38843_n2662# SL_28 nmos$2
Xnmos$2_786 a_n37338_n6586# VSS SL_29 a_n37024_n6597# nmos$2
Xnmos$2_797 a_n35829_n6586# VSS SL_30 a_n35515_n6597# nmos$2
Xpmos$1_110 a_n28089_27928# VDD a_n26151_28422# a_n27618_28422# pmos$1
Xpmos$1_121 OUTP VDD m1_n26796_24120# a_n26151_24108# pmos$1
Xnmos$5_580 VEVAL VSS m1_n73059_15847# VSS nmos$5
Xnmos$5_591 VEVAL VSS m1_n70045_17155# VSS nmos$5
Xnmos$1_32 OUTP VSS a_n26151_n1776# a_n27618_n1776# nmos$1
Xnmos$1_10 OUTP VSS a_n26151_n10404# a_n27618_n10404# nmos$1
Xnmos$1_21 OUTP VSS a_n26151_n4652# a_n27618_n4652# nmos$1
Xnmos$1_65 OUTP VSS a_n26151_9728# a_n27618_9728# nmos$1
Xnmos$1_54 OUTP VSS a_n26151_5414# a_n27618_5414# nmos$1
Xnmos$1_43 OUTP VSS a_n26151_n338# a_n27618_n338# nmos$1
Xnmos$1_98 a_n28089_23614# VSS a_n27274_24108# m1_n28364_24031# nmos$1
Xnmos$1_87 OUTP VSS m1_n27919_18368# a_n27274_18356# nmos$1
Xnmos$1_76 a_n28089_13548# VSS m1_n26796_14054# a_n26151_14042# nmos$1
Xpmos$3_0 PC VDD a_n32313_n28669# VDD pmos$3
Xnmos_515 a_n64438_7802# VSS a_n64585_8021# VSS nmos
Xnmos_504 a_n65943_5186# VSS a_n66090_5405# VSS nmos
Xnmos_537 a_n67452_15650# VSS a_n67599_15869# VSS nmos
Xnmos_559 a_n58411_11726# VSS a_n58558_11945# VSS nmos
Xnmos_526 a_n62930_11726# VSS a_n63077_11945# VSS nmos
Xnmos_548 a_n55410_10418# VSS a_n55557_10637# VSS nmos
Xnmos$2_3117 a_n74661_19563# VSS ML_6 m1_n74564_19771# nmos$2
Xnmos$2_3106 a_n76483_18266# VSS SL_3 a_n76169_18255# nmos$2
Xnmos$2_3128 a_n77988_18266# VSS SL_2 a_n77674_18255# nmos$2
Xnmos$2_3139 WL_8 VSS SL_0N a_n81149_17177# nmos$2
Xnmos$2_2405 WL_10 VSS a_n55410_14342# SL_17 nmos$2
Xnmos$3_506 a_n69104_6713# VSS VSS a_n68957_6494# nmos$3
Xnmos$2_2416 a_n53587_15639# VSS ML_9 m1_n53490_15847# nmos$2
Xnmos$3_539 a_n78135_9329# VSS VSS a_n77988_9110# nmos$3
Xnmos$3_528 a_n75122_5405# VSS VSS a_n74975_5186# nmos$3
Xnmos$2_2438 a_n70456_3878# VSS SL_7 a_n70142_3867# nmos$2
Xnmos$3_517 a_n78135_4097# VSS VSS a_n77988_3878# nmos$3
Xnmos$2_2427 WL_19 VSS SL_8N a_n69104_2789# nmos$2
Xnmos$2_1704 a_n67599_173# VSS a_n67138_n57# SL_9N nmos$2
Xnmos$2_2449 WL_19 VSS a_n68957_2570# SL_8 nmos$2
Xnmos$2_1726 a_n62930_n46# VSS SL_12 a_n62616_n57# nmos$2
Xnmos$2_1715 a_n61111_n1365# VSS ML_22 m1_n61014_n1157# nmos$2
Xnmos$2_1737 WL_23 VSS a_n62930_n2662# SL_12 nmos$2
Xnmos$2_1748 a_n63077_n2742# VSS a_n62616_n2673# SL_12N nmos$2
Xnmos$2_1759 a_n53587_n5289# VSS ML_25 m1_n53490_n5081# nmos$2
Xnmos$2_5042 a_n34324_23498# VSS SL_31 a_n34010_23487# nmos$2
Xnmos$2_5020 WL_3 VSS a_n37338_23498# SL_29 nmos$2
Xnmos$2_5031 WL_4 VSS SL_30N a_n35976_22409# nmos$2
Xnmos$2_5075 a_n34010_27411# VSS ML_0 m1_n33913_27619# nmos$2
Xnmos$2_5064 a_n35515_24795# VSS ML_2 m1_n35418_25003# nmos$2
Xnmos$2_5086 a_n37485_25025# VSS a_n37024_24795# SL_29N nmos$2
Xnmos$2_5053 WL_8 VSS a_n35829_16958# SL_30 nmos$2
Xnmos$2_4341 WL_10 VSS SL_22N a_n48021_14561# nmos$2
Xnmos$2_4330 a_n52543_14561# VSS a_n52082_14331# SL_19N nmos$2
Xnmos$2_5097 a_n38529_27411# VSS ML_0 m1_n38432_27619# nmos$2
Xnmos$2_4363 WL_9 VSS a_n47874_15650# SL_22 nmos$2
Xnmos$2_4352 a_n49383_13034# VSS SL_21 a_n49069_13023# nmos$2
Xnmos$2_4374 WL_13 VSS SL_27N a_n40498_10637# nmos$2
Xnmos$2_3662 WL_0 VSS a_n61425_27422# SL_13 nmos$2
Xnmos$2_3673 a_n63077_26333# VSS a_n62616_26103# SL_12N nmos$2
Xnmos$2_3651 a_n62616_24795# VSS ML_2 m1_n62519_25003# nmos$2
Xnmos$2_3640 WL_3 VSS SL_12N a_n63077_23717# nmos$2
Xnmos$2_4396 WL_12 VSS a_n40351_11726# SL_27 nmos$2
Xnmos$2_4385 a_n41542_9099# VSS ML_14 m1_n41445_9307# nmos$2
Xnmos$2_3695 WL_0 VSS a_n64438_27422# SL_11 nmos$2
Xnmos$2_3684 a_n67138_24795# VSS ML_2 m1_n67041_25003# nmos$2
Xnmos$2_2961 a_n70142_18255# VSS ML_7 m1_n70045_18463# nmos$2
Xnmos$2_2950 a_n68957_16958# VSS SL_8 a_n68643_16947# nmos$2
Xnmos$2_2972 a_n67452_19574# VSS SL_9 a_n67138_19563# nmos$2
Xnmos$2_2983 a_n71647_18255# VSS ML_7 m1_n71550_18463# nmos$2
Xnmos$2_2994 WL_8 VSS SL_4N a_n75122_17177# nmos$2
Xnmos$2_561 WL_26 VSS SL_18N a_n54048_n6666# nmos$2
Xnmos$2_550 a_n51035_n6666# VSS a_n50574_n6597# SL_20N nmos$2
Xnmos$2_572 a_n43051_n6597# VSS ML_26 m1_n42954_n6389# nmos$2
Xnmos$2_594 WL_29 VSS a_n34324_n10510# SL_31 nmos$2
Xnmos$2_583 a_n44556_n6597# VSS ML_26 m1_n44459_n6389# nmos$2
Xnmos_312 a_n81002_n13126# VSS a_n81149_n13206# VSS nmos
Xnmos_323 a_n76483_n9202# VSS a_n76630_n9282# VSS nmos
Xnmos_301 a_n70456_n6586# VSS a_n70603_n6666# VSS nmos
Xnmos_334 a_n81002_n5278# VSS a_n81149_n5358# VSS nmos
Xnmos_367 a_n70456_n46# VSS a_n70603_173# VSS nmos
Xnmos_345 a_n81002_n2662# VSS a_n81149_n2742# VSS nmos
Xnmos_356 a_n71961_n3970# VSS a_n72108_n4050# VSS nmos
Xnmos_378 a_n55410_n10510# VSS a_n55557_n10590# VSS nmos
Xnmos_389 a_n59916_n6586# VSS a_n60063_n6666# VSS nmos
Xnmos$2_2213 a_n64124_11715# VSS ML_12 m1_n64027_11923# nmos$2
Xnmos$2_2202 a_n67599_9329# VSS a_n67138_9099# SL_9N nmos$2
Xnmos$3_314 a_n54048_n7974# VSS VSS a_n53901_n7894# nmos$3
Xnmos$3_303 a_n60063_n6666# VSS VSS a_n59916_n6586# nmos$3
Xnmos$2_2246 WL_9 VSS SL_10N a_n66090_15869# nmos$2
Xnmos$2_2257 a_n61425_14342# VSS SL_13 a_n61111_14331# nmos$2
Xnmos$2_2224 WL_11 VSS SL_10N a_n66090_13253# nmos$2
Xnmos$2_2235 a_n67138_13023# VSS ML_11 m1_n67041_13231# nmos$2
Xnmos$3_347 a_n64585_n1434# VSS VSS a_n64438_n1354# nmos$3
Xnmos$3_358 a_n66090_n2742# VSS VSS a_n65943_n2662# nmos$3
Xnmos$3_325 a_n64585_n11898# VSS VSS a_n64438_n11818# nmos$3
Xnmos$2_1501 a_n58411_n7894# VSS SL_15 a_n58097_n7905# nmos$2
Xnmos$2_1512 a_n56601_n7905# VSS ML_27 m1_n56504_n7697# nmos$2
Xnmos$3_336 a_n63077_n6666# VSS VSS a_n62930_n6586# nmos$3
Xnmos$2_2279 a_n62930_15650# VSS SL_12 a_n62616_15639# nmos$2
Xnmos$2_2268 WL_11 VSS a_n62930_13034# SL_12 nmos$2
Xnmos$3_369 a_n57062_n1434# VSS VSS a_n56915_n1354# nmos$3
Xnmos$2_1534 a_n63077_n13206# VSS a_n62616_n13137# SL_12N nmos$2
Xnmos$2_1545 a_n64585_n11898# VSS a_n64124_n11829# SL_11N nmos$2
Xnmos$2_1523 a_n55096_n9213# VSS ML_28 m1_n54999_n9005# nmos$2
Xnmos$2_1578 a_n67138_n11829# VSS ML_30 m1_n67041_n11621# nmos$2
Xnmos$2_1567 WL_31 VSS SL_10N a_n66090_n13206# nmos$2
Xnmos$2_1556 WL_30 VSS a_n61425_n11818# SL_13 nmos$2
Xnmos$2_1589 a_n64124_n11829# VSS ML_30 m1_n64027_n11621# nmos$2
Xpmos_2119 a_n47874_22190# VDD VDD a_n48021_22409# pmos
Xpmos_2108 a_n47874_20882# VDD VDD a_n48021_21101# pmos
Xpmos_1407 a_n76483_23498# VDD VDD a_n76630_23717# pmos
Xpmos_1418 a_n76483_27422# VDD VDD a_n76630_27641# pmos
Xpmos_1429 a_n79497_26114# VDD VDD a_n79644_26333# pmos
Xnmos_1305 a_n43365_1262# VSS a_n43512_1481# VSS nmos
Xnmos$2_4182 WL_15 VSS SL_18N a_n54048_8021# nmos$2
Xnmos$2_4171 WL_16 VSS a_n52396_6494# SL_19 nmos$2
Xnmos_890 a_n35829_5186# VSS a_n35976_5405# VSS nmos
Xnmos$2_4160 a_n52543_2789# VSS a_n52082_2559# SL_19N nmos$2
Xnmos$2_3470 a_n53587_20871# VSS ML_5 m1_n53490_21079# nmos$2
Xnmos$2_3481 a_n56601_20871# VSS ML_5 m1_n56504_21079# nmos$2
Xnmos$2_4193 WL_15 VSS SL_19N a_n52543_8021# nmos$2
Xnmos$2_3492 a_n53587_23487# VSS ML_3 m1_n53490_23695# nmos$2
Xnmos$3_870 a_n52543_14561# VSS VSS a_n52396_14342# nmos$3
Xnmos$2_2791 a_n76483_15650# VSS SL_3 a_n76169_15639# nmos$2
Xnmos$3_881 a_n48021_14561# VSS VSS a_n47874_14342# nmos$3
Xnmos$2_2780 a_n76483_13034# VSS SL_3 a_n76169_13023# nmos$2
Xnmos$3_892 a_n45017_10637# VSS VSS a_n44870_10418# nmos$3
Xnmos$2_380 a_n49383_n46# VSS SL_21 a_n49069_n57# nmos$2
Xnmos$2_391 WL_23 VSS a_n46369_n2662# SL_23 nmos$2
Xpmos_1930 a_n53901_9110# VDD VDD a_n54048_9329# pmos
Xpmos_1963 a_n46516_14561# VDD a_n46369_14342# VDD pmos
Xpmos_1952 a_n46516_13253# VDD a_n46369_13034# VDD pmos
Xpmos_1941 a_n52396_13034# VDD VDD a_n52543_13253# pmos
Xpmos_1996 a_n44870_10418# VDD VDD a_n45017_10637# pmos
Xpmos_1974 a_n41856_9110# VDD VDD a_n42003_9329# pmos
Xpmos_1985 a_n43512_9329# VDD a_n43365_9110# VDD pmos
Xnmos_22 a_n46369_n13126# VSS a_n46516_n13206# VSS nmos
Xnmos_11 a_n53901_n28971# VSS a_n54048_n29051# VSS nmos
Xnmos_44 a_n47874_n11818# VSS a_n48021_n11898# VSS nmos
Xnmos_33 a_n41856_n9202# VSS a_n42003_n9282# VSS nmos
Xnmos_77 a_n52396_n1354# VSS a_n52543_n1434# VSS nmos
Xnmos_66 a_n50888_n9202# VSS a_n51035_n9282# VSS nmos
Xnmos_55 a_n52396_n7894# VSS a_n52543_n7974# VSS nmos
Xnmos_88 a_n50888_n2662# VSS a_n51035_n2742# VSS nmos
Xnmos_99 a_n46369_n5278# VSS a_n46516_n5358# VSS nmos
Xnmos_131 a_n27618_n11842# VSS m1_n27919_n11830# VSS nmos
Xnmos_120 m2_n30953_n7856# VSS VSS m1_n28364_n10481# nmos
Xnmos_142 a_n27274_n8966# VSS a_n27618_n8966# VSS nmos
Xnmos_153 a_n34324_n13126# VSS a_n34471_n13206# VSS nmos
Xnmos_164 a_n37338_n10510# VSS a_n37485_n10590# VSS nmos
Xnmos_175 a_n34324_n7894# VSS a_n34471_n7974# VSS nmos
Xnmos_186 a_n38843_n1354# VSS a_n38990_n1434# VSS nmos
Xnmos_197 a_n26495_n4652# VSS VSS COMP25 nmos
Xnmos$2_2021 a_n55410_7802# VSS SL_17 a_n55096_7791# nmos$2
Xnmos$2_2010 a_n55410_6494# VSS SL_17 a_n55096_6483# nmos$2
Xnmos$2_2032 a_n56915_5186# VSS SL_16 a_n56601_5175# nmos$2
Xnmos$3_100 a_n43512_n1434# VSS VSS a_n43365_n1354# nmos$3
Xnmos$3_111 a_n40498_n2742# VSS VSS a_n40351_n2662# nmos$3
Xnmos$3_122 a_n37485_n11898# VSS VSS a_n37338_n11818# nmos$3
Xnmos$3_133 a_n34471_n9282# VSS VSS a_n34324_n9202# nmos$3
Xnmos$2_2054 a_n61111_3867# VSS ML_18 m1_n61014_4075# nmos$2
Xnmos$2_2043 a_n63077_2789# VSS a_n62616_2559# SL_12N nmos$2
Xnmos$2_2065 a_n67599_2789# VSS a_n67138_2559# SL_9N nmos$2
Xnmos$3_144 a_n35976_n1434# VSS VSS a_n35829_n1354# nmos$3
Xnmos$2_1320 WL_22 VSS a_n67452_n1354# SL_9 nmos$2
Xnmos$3_155 a_n35976_n2742# VSS VSS a_n35829_n2662# nmos$3
Xnmos$3_166 a_n72108_n29051# VSS VSS a_n71961_n28971# nmos$3
Xnmos$2_2098 WL_16 VSS a_n65943_6494# SL_10 nmos$2
Xnmos$2_2087 WL_17 VSS SL_10N a_n66090_5405# nmos$2
Xnmos$2_2076 WL_18 VSS a_n64438_3878# SL_11 nmos$2
Xnmos$2_1342 WL_21 VSS a_n68957_n46# SL_8 nmos$2
Xnmos$2_1331 a_n70603_173# VSS a_n70142_n57# SL_7N nmos$2
Xnmos$2_1353 a_n75122_n2742# VSS a_n74661_n2673# SL_4N nmos$2
Xnmos$3_177 a_n70603_n11898# VSS VSS a_n70456_n11818# nmos$3
Xnmos$3_188 a_n72108_n10590# VSS VSS a_n71961_n10510# nmos$3
Xnmos$3_199 a_n70603_n6666# VSS VSS a_n70456_n6586# nmos$3
Xnmos$2_1364 WL_23 VSS a_n70456_n2662# SL_7 nmos$2
Xnmos$2_1386 a_n80688_n6597# VSS ML_26 m1_n80591_n6389# nmos$2
Xnmos$2_1375 WL_26 VSS SL_3N a_n76630_n6666# nmos$2
Xnmos$2_1397 a_n68643_n6597# VSS ML_26 m1_n68546_n6389# nmos$2
Xpmos_1226 a_n76630_15869# VDD a_n76483_15650# VDD pmos
Xpmos_1215 a_n79644_15869# VDD a_n79497_15650# VDD pmos
Xpmos_1204 a_n79644_9329# VDD a_n79497_9110# VDD pmos
Xpmos_1248 a_n68957_10418# VDD VDD a_n69104_10637# pmos
Xpmos_1259 a_n73470_10418# VDD VDD a_n73617_10637# pmos
Xpmos_1237 a_n70603_9329# VDD a_n70456_9110# VDD pmos
Xpmos_408 a_n56915_n28971# VDD VDD a_n57062_n29051# pmos
Xpmos_419 a_n67452_n28971# VDD VDD a_n67599_n29051# pmos
Xnmos_1102 a_n47874_20882# VSS a_n48021_21101# VSS nmos
Xnmos_1124 a_n52396_27422# VSS a_n52543_27641# VSS nmos
Xnmos_1113 a_n47874_26114# VSS a_n48021_26333# VSS nmos
Xnmos_1135 a_n44870_24806# VSS a_n45017_25025# VSS nmos
Xnmos_1168 a_n26495_21232# VSS m1_n26796_21244# VSS nmos
Xnmos_1157 a_n26495_19794# VSS m1_n26796_19806# VSS nmos
Xnmos_1146 OUTP VSS a_n28089_17862# VSS nmos
Xnmos_1179 a_n26495_22670# VSS VSS COMP6 nmos
Xpmos_1760 a_n34324_15650# VDD VDD a_n34471_15869# pmos
Xpmos_1771 a_n27274_11166# VDD VDD a_n27618_11166# pmos
Xpmos_920 a_n66090_2789# VDD a_n65943_2570# VDD pmos
Xpmos_1782 ML_10 VDD a_n28485_17016# VDD pmos
Xpmos_1793 a_n27274_14042# VDD VDD a_n27618_14042# pmos
Xpmos_953 a_n63077_9329# VDD a_n62930_9110# VDD pmos
Xpmos_931 a_n65943_6494# VDD VDD a_n66090_6713# pmos
Xpmos_942 a_n63077_5405# VDD a_n62930_5186# VDD pmos
Xnmos$2_4907 WL_2 VSS SL_23N a_n46516_25025# nmos$2
Xpmos_997 a_n64438_14342# VDD VDD a_n64585_14561# pmos
Xpmos_986 a_n67452_14342# VDD VDD a_n67599_14561# pmos
Xpmos_975 a_n66090_10637# VDD a_n65943_10418# VDD pmos
Xpmos_964 a_n64585_9329# VDD a_n64438_9110# VDD pmos
Xnmos$2_4918 a_n44556_27411# VSS ML_0 m1_n44459_27619# nmos$2
Xnmos$2_4929 a_n43051_26103# VSS ML_1 m1_n42954_26311# nmos$2
Xnmos$5_409 VEVAL VSS m1_n65532_5383# VSS nmos$5
Xnmos$5_921 VEVAL VSS m1_n45958_21079# VSS nmos$5
Xnmos$5_910 VEVAL VSS m1_n41445_19771# VSS nmos$5
Xnmos$5_932 VEVAL VSS m1_n42954_21079# VSS nmos$5
Xnmos$5_954 VEVAL VSS m1_n47463_21079# VSS nmos$5
Xnmos$5_943 VEVAL VSS m1_n50477_17155# VSS nmos$5
Xnmos$5_976 VEVAL VSS m1_n39940_26311# VSS nmos$5
Xnmos$5_965 VEVAL VSS m1_n48972_26311# VSS nmos$5
Xnmos$5_987 VEVAL VSS m1_n33913_17155# VSS nmos$5
Xnmos$5_998 VEVAL VSS m1_n36927_19771# VSS nmos$5
Xnmos$2_1161 a_n81002_n5278# VSS SL_0 a_n80688_n5289# nmos$2
Xnmos$2_1172 a_n79497_n3970# VSS SL_1 a_n79183_n3981# nmos$2
Xnmos$2_1150 WL_24 VSS SL_3N a_n76630_n4050# nmos$2
Xnmos$2_1194 a_n79497_n46# VSS SL_1 a_n79183_n57# nmos$2
Xnmos$2_1183 a_n79497_n1354# VSS SL_1 a_n79183_n1365# nmos$2
Xpmos_1034 a_n57062_15869# VDD a_n56915_15650# VDD pmos
Xpmos_1023 a_n57062_10637# VDD a_n56915_10418# VDD pmos
Xpmos_1001 a_n54048_9329# VDD a_n53901_9110# VDD pmos
Xpmos_1012 a_n57062_9329# VDD a_n56915_9110# VDD pmos
Xpmos_1056 a_n61425_15650# VDD VDD a_n61572_15869# pmos
Xpmos_1045 a_n56915_13034# VDD VDD a_n57062_13253# pmos
Xpmos_1067 a_n68957_2570# VDD VDD a_n69104_2789# pmos
Xpmos_216 a_n41856_n1354# VDD VDD a_n42003_n1434# pmos
Xpmos_205 a_n44870_n2662# VDD VDD a_n45017_n2742# pmos
Xpmos_1089 a_n73617_4097# VDD a_n73470_3878# VDD pmos
Xpmos_1078 a_n69104_2789# VDD a_n68957_2570# VDD pmos
Xpmos_227 a_n26151_n13280# VDD VDD a_n26495_n13280# pmos
Xpmos_238 a_n28485_n13182# VDD m1_n28364_n13357# VDD pmos
Xpmos_249 a_n27618_n7528# VDD VDD m1_n27919_n7516# pmos
Xpmos_2280 a_n34324_27422# VDD VDD a_n34471_27641# pmos
Xpmos_2291 a_n35976_27641# VDD a_n35829_27422# VDD pmos
Xpmos_1590 a_n65943_26114# VDD VDD a_n66090_26333# pmos
Xpmos_772 a_n64585_173# VDD a_n64438_n46# VDD pmos
Xpmos_761 a_n64585_n2742# VDD a_n64438_n2662# VDD pmos
Xpmos_750 a_n64585_n5358# VDD a_n64438_n5278# VDD pmos
Xnmos$2_4715 a_n50574_19563# VSS ML_6 m1_n50477_19771# nmos$2
Xnmos$2_4704 WL_8 VSS a_n52396_16958# SL_19 nmos$2
Xpmos_783 a_n62930_n1354# VDD VDD a_n63077_n1434# pmos
Xpmos_794 a_n56915_n3970# VDD VDD a_n57062_n4050# pmos
Xnmos$2_4748 a_n52082_23487# VSS ML_3 m1_n51985_23695# nmos$2
Xnmos$2_4726 a_n50888_22190# VSS SL_20 a_n50574_22179# nmos$2
Xnmos$2_4737 WL_4 VSS SL_18N a_n54048_22409# nmos$2
Xnmos$5_206 VEVAL VSS m1_n74564_n10313# VSS nmos$5
Xnmos$2_4759 a_n52543_22409# VSS a_n52082_22179# SL_19N nmos$2
Xnmos$5_239 VEVAL VSS m1_n80591_n1157# VSS nmos$5
Xnmos$5_217 VEVAL VSS m1_n79086_n7697# VSS nmos$5
Xnmos$5_228 VEVAL VSS m1_n76072_n5081# VSS nmos$5
Xnmos$2_902 a_n68957_n13126# VSS SL_8 a_n68643_n13137# nmos$2
Xnmos$2_913 WL_29 VSS a_n70456_n10510# SL_7 nmos$2
Xnmos$2_946 a_n75122_n11898# VSS a_n74661_n11829# SL_4N nmos$2
Xnmos$2_935 WL_31 VSS SL_6N a_n72108_n13206# nmos$2
Xnmos$2_924 WL_29 VSS SL_8N a_n69104_n10590# nmos$2
Xnmos$2_968 WL_30 VSS SL_5N a_n73617_n11898# nmos$2
Xnmos$2_957 a_n71961_n10510# VSS SL_6 a_n71647_n10521# nmos$2
Xnmos$2_979 a_n75122_n9282# VSS a_n74661_n9213# SL_4N nmos$2
Xpmos_36 a_n43512_n13206# VDD a_n43365_n13126# VDD pmos
Xpmos_14 a_n44870_n28971# VDD VDD a_n45017_n29051# pmos
Xpmos_25 a_n53901_n28971# VDD VDD a_n54048_n29051# pmos
Xpmos_69 a_n47874_n13126# VDD VDD a_n48021_n13206# pmos
Xpmos_47 a_n44870_n10510# VDD VDD a_n45017_n10590# pmos
Xpmos_58 a_n40498_n10590# VDD a_n40351_n10510# VDD pmos
Xnmos$5_740 VEVAL VSS m1_n56504_27619# VSS nmos$5
Xnmos$5_762 VEVAL VSS m1_n36927_6691# VSS nmos$5
Xnmos$5_751 VEVAL VSS m1_n33913_1459# VSS nmos$5
Xnmos$5_795 VEVAL VSS m1_n35418_14539# VSS nmos$5
Xnmos$5_784 VEVAL VSS m1_n38432_11923# VSS nmos$5
Xnmos$5_773 VEVAL VSS m1_n33913_7999# VSS nmos$5
Xnmos_708 a_n79497_16958# VSS a_n79644_17177# VSS nmos
Xnmos_719 a_n76483_20882# VSS a_n76630_21101# VSS nmos
Xnmos$5_1009 VEVAL VSS m1_n35418_23695# VSS nmos$5
Xnmos$2_2609 WL_16 VSS a_n81002_6494# SL_0 nmos$2
Xnmos$2_209 a_n47560_n11829# VSS ML_30 m1_n47463_n11621# nmos$2
Xnmos$2_1919 WL_26 VSS SL_11N a_n64585_n6666# nmos$2
Xnmos$2_1908 a_n56915_n6586# VSS SL_16 a_n56601_n6597# nmos$2
Xnmos$2_5202 WL_20 VSS SL_17N a_n55557_1481# nmos$2
Xnmos$2_5224 a_n58411_1262# VSS SL_15 a_n58097_1251# nmos$2
Xnmos$2_5213 a_n64124_1251# VSS ML_20 m1_n64027_1459# nmos$2
Xnmos$2_5235 WL_20 VSS a_n68957_1262# SL_8 nmos$2
Xpmos_580 a_n75122_n2742# VDD a_n74975_n2662# VDD pmos
Xnmos$2_4523 WL_7 VSS a_n40351_18266# SL_27 nmos$2
Xnmos$2_4501 a_n40351_15650# VSS SL_27 a_n40037_15639# nmos$2
Xnmos$2_4512 a_n46369_6494# VSS SL_23 a_n46055_6483# nmos$2
Xnmos$2_5257 a_n61111_1251# VSS ML_20 m1_n61014_1459# nmos$2
Xnmos$2_5268 WL_20 VSS a_n62930_1262# SL_12 nmos$2
Xnmos$2_5246 a_n79183_1251# VSS ML_20 m1_n79086_1459# nmos$2
Xpmos_591 a_n76483_n46# VDD VDD a_n76630_173# pmos
Xnmos$2_4545 a_n40351_19574# VSS SL_27 a_n40037_19563# nmos$2
Xnmos$2_4556 a_n43365_18266# VSS SL_25 a_n43051_18255# nmos$2
Xnmos$2_4534 WL_8 VSS SL_25N a_n43512_17177# nmos$2
Xnmos$2_3822 a_n37024_5175# VSS ML_17 m1_n36927_5383# nmos$2
Xnmos$2_3811 WL_18 VSS a_n37338_3878# SL_29 nmos$2
Xnmos$2_3800 WL_19 VSS SL_29N a_n37485_2789# nmos$2
Xnmos$2_5279 a_n48021_1481# VSS a_n47560_1251# SL_22N nmos$2
Xnmos$2_4589 WL_4 VSS a_n43365_22190# SL_25 nmos$2
Xnmos$2_4578 WL_6 VSS a_n43365_19574# SL_25 nmos$2
Xnmos$2_4567 WL_7 VSS SL_23N a_n46516_18485# nmos$2
Xnmos$2_3844 WL_15 VSS SL_29N a_n37485_8021# nmos$2
Xnmos$2_3855 a_n34324_6494# VSS SL_31 a_n34010_6483# nmos$2
Xnmos$2_3833 a_n38843_5186# VSS SL_28 a_n38529_5175# nmos$2
Xnmos$2_3888 a_n34324_10418# VSS SL_31 a_n34010_10407# nmos$2
Xnmos$2_3866 a_n34324_7802# VSS SL_31 a_n34010_7791# nmos$2
Xnmos$2_3877 WL_19 VSS a_n35829_2570# SL_30 nmos$2
Xnmos$2_721 a_n37485_n1434# VSS a_n37024_n1365# SL_29N nmos$2
Xnmos$2_710 WL_24 VSS a_n38843_n3970# SL_28 nmos$2
Xnmos$2_3899 WL_12 VSS SL_30N a_n35976_11945# nmos$2
Xnmos$2_754 WL_21 VSS SL_31N a_n34471_173# nmos$2
Xnmos$2_732 WL_21 VSS a_n38843_n46# SL_28 nmos$2
Xnmos$2_743 WL_22 VSS SL_30N a_n35976_n1434# nmos$2
Xnmos$2_765 WL_23 VSS SL_29N a_n37485_n2742# nmos$2
Xnmos$2_776 a_n38529_n2673# VSS ML_23 m1_n38432_n2465# nmos$2
Xnmos$2_798 a_n38843_n6586# VSS SL_28 a_n38529_n6597# nmos$2
Xnmos$2_787 WL_26 VSS SL_29N a_n37485_n6666# nmos$2
Xpmos$1_111 OUTP VDD a_n27274_29860# m1_n28364_29783# pmos$1
Xpmos$1_100 OUTP VDD a_n27274_25546# m1_n28364_25469# pmos$1
Xpmos$1_122 a_n28089_23614# VDD m1_n27919_24120# a_n27274_24108# pmos$1
Xnmos$5_581 VEVAL VSS m1_n71550_15847# VSS nmos$5
Xnmos$5_570 VEVAL VSS m1_n71550_9307# VSS nmos$5
Xnmos$5_592 VEVAL VSS m1_n70045_19771# VSS nmos$5
Xnmos$1_11 a_n27990_n9846# VSS a_n27274_n10404# m1_n28364_n10481# nmos$1
Xnmos$1_22 a_n28089_n6584# VSS m1_n26796_n6078# a_n26151_n6090# nmos$1
Xnmos$1_66 a_n28089_9234# VSS a_n27274_9728# m1_n28364_9651# nmos$1
Xnmos$1_55 a_n28089_6358# VSS m1_n26796_6864# a_n26151_6852# nmos$1
Xnmos$1_44 a_n28089_3482# VSS a_n27274_3976# m1_n28364_3899# nmos$1
Xnmos$1_33 a_n28089_n2270# VSS m1_n26796_n1764# a_n26151_n1776# nmos$1
Xnmos$1_99 a_n28089_23614# VSS m1_n26796_24120# a_n26151_24108# nmos$1
Xnmos$1_88 OUTP VSS m1_n27919_19806# a_n27274_19794# nmos$1
Xnmos$1_77 OUTP VSS a_n26151_15480# a_n27618_15480# nmos$1
Xpmos$3_1 PC VDD ML_31 VDD pmos$3
Xnmos_516 a_n61425_7802# VSS a_n61572_8021# VSS nmos
Xnmos_505 a_n67452_5186# VSS a_n67599_5405# VSS nmos
Xnmos_538 a_n65943_15650# VSS a_n66090_15869# VSS nmos
Xnmos_527 a_n65943_10418# VSS a_n66090_10637# VSS nmos
Xnmos_549 a_n55410_9110# VSS a_n55557_9329# VSS nmos
Xnmos$2_3107 WL_7 VSS SL_2N a_n78135_18485# nmos$2
Xnmos$2_3118 WL_6 VSS SL_3N a_n76630_19793# nmos$2
Xnmos$2_3129 WL_7 VSS SL_1N a_n79644_18485# nmos$2
Xnmos$2_2406 a_n55410_14342# VSS SL_17 a_n55096_14331# nmos$2
Xnmos$3_507 a_n69104_5405# VSS VSS a_n68957_5186# nmos$3
Xnmos$2_2417 a_n55096_13023# VSS ML_11 m1_n54999_13231# nmos$2
Xnmos$3_529 a_n76630_5405# VSS VSS a_n76483_5186# nmos$3
Xnmos$3_518 a_n78135_5405# VSS VSS a_n77988_5186# nmos$3
Xnmos$2_2439 a_n70603_4097# VSS a_n70142_3867# SL_7N nmos$2
Xnmos$2_2428 a_n69104_2789# VSS a_n68643_2559# SL_8N nmos$2
Xnmos$2_1727 a_n63077_173# VSS a_n62616_n57# SL_12N nmos$2
Xnmos$2_1705 WL_21 VSS a_n64438_n46# SL_11 nmos$2
Xnmos$2_1716 WL_22 VSS a_n61425_n1354# SL_13 nmos$2
Xnmos$2_1738 a_n62930_n2662# VSS SL_12 a_n62616_n2673# nmos$2
Xnmos$2_1749 a_n67138_n2673# VSS ML_23 m1_n67041_n2465# nmos$2
Xnmos$2_5010 WL_5 VSS a_n38843_20882# SL_28 nmos$2
Xnmos$2_5043 a_n35976_23717# VSS a_n35515_23487# SL_30N nmos$2
Xnmos$2_5021 a_n37338_23498# VSS SL_29 a_n37024_23487# nmos$2
Xnmos$2_5032 a_n35515_22179# VSS ML_4 m1_n35418_22387# nmos$2
Xnmos$2_5076 WL_1 VSS SL_30N a_n35976_26333# nmos$2
Xnmos$2_5065 a_n35976_25025# VSS a_n35515_24795# SL_30N nmos$2
Xnmos$2_5054 a_n35829_16958# VSS SL_30 a_n35515_16947# nmos$2
Xnmos$2_4320 a_n52396_15650# VSS SL_19 a_n52082_15639# nmos$2
Xnmos$2_4331 WL_11 VSS SL_19N a_n52543_13253# nmos$2
Xnmos$2_5098 a_n38990_27641# VSS a_n38529_27411# SL_28N nmos$2
Xnmos$2_5087 WL_2 VSS SL_29N a_n37485_25025# nmos$2
Xnmos$2_3630 a_n62616_23487# VSS ML_3 m1_n62519_23695# nmos$2
Xnmos$2_4364 a_n47874_15650# VSS SL_22 a_n47560_15639# nmos$2
Xnmos$2_4342 WL_11 VSS a_n46369_13034# SL_23 nmos$2
Xnmos$2_4353 WL_11 VSS a_n49383_13034# SL_21 nmos$2
Xnmos$2_4375 WL_14 VSS SL_27N a_n40498_9329# nmos$2
Xnmos$2_3663 a_n61111_27411# VSS ML_0 m1_n61014_27619# nmos$2
Xnmos$2_3652 a_n63077_25025# VSS a_n62616_24795# SL_12N nmos$2
Xnmos$2_3641 WL_4 VSS SL_12N a_n63077_22409# nmos$2
Xnmos$2_4397 a_n40351_11726# VSS SL_27 a_n40037_11715# nmos$2
Xnmos$2_4386 a_n43512_9329# VSS a_n43051_9099# SL_25N nmos$2
Xnmos$2_3696 a_n64124_27411# VSS ML_0 m1_n64027_27619# nmos$2
Xnmos$2_3674 a_n62930_26114# VSS SL_12 a_n62616_26103# nmos$2
Xnmos$2_3685 a_n65943_24806# VSS SL_10 a_n65629_24795# nmos$2
Xnmos$2_2951 a_n69104_18485# VSS a_n68643_18255# SL_8N nmos$2
Xnmos$2_2940 WL_10 VSS a_n68957_14342# SL_8 nmos$2
Xnmos$2_2973 WL_6 VSS SL_8N a_n69104_19793# nmos$2
Xnmos$2_2962 WL_8 VSS SL_7N a_n70603_17177# nmos$2
Xnmos$2_2984 WL_8 VSS a_n71961_16958# SL_6 nmos$2
Xnmos$2_2995 a_n73156_16947# VSS ML_8 m1_n73059_17155# nmos$2
Xnmos$2_551 a_n50574_n6597# VSS ML_26 m1_n50477_n6389# nmos$2
Xnmos$2_562 a_n49383_n6586# VSS SL_21 a_n49069_n6597# nmos$2
Xnmos$2_540 a_n41856_n6586# VSS SL_26 a_n41542_n6597# nmos$2
Xnmos$2_584 WL_31 VSS SL_31N a_n34471_n13206# nmos$2
Xnmos$2_595 WL_30 VSS SL_30N a_n35976_n11898# nmos$2
Xnmos$2_573 WL_26 VSS SL_21N a_n49530_n6666# nmos$2
Xnmos_313 a_n81002_n10510# VSS a_n81149_n10590# VSS nmos
Xnmos_324 a_n77988_n9202# VSS a_n78135_n9282# VSS nmos
Xnmos_302 a_n70456_n7894# VSS a_n70603_n7974# VSS nmos
Xnmos_346 a_n76483_n2662# VSS a_n76630_n2742# VSS nmos
Xnmos_357 a_n73470_n5278# VSS a_n73617_n5358# VSS nmos
Xnmos_335 a_n81002_n3970# VSS a_n81149_n4050# VSS nmos
Xnmos_368 a_n68957_n46# VSS a_n69104_173# VSS nmos
Xnmos_379 a_n55410_n11818# VSS a_n55557_n11898# VSS nmos
Xnmos$2_2214 a_n64438_11726# VSS SL_11 a_n64124_11715# nmos$2
Xnmos$2_2203 WL_13 VSS a_n65943_10418# SL_10 nmos$2
Xnmos$3_315 a_n61572_n13206# VSS VSS a_n61425_n13126# nmos$3
Xnmos$3_304 a_n57062_n6666# VSS VSS a_n56915_n6586# nmos$3
Xnmos$2_2247 a_n66090_15869# VSS a_n65629_15639# SL_10N nmos$2
Xnmos$2_2225 WL_10 VSS a_n64438_14342# SL_11 nmos$2
Xnmos$2_2236 a_n65943_13034# VSS SL_10 a_n65629_13023# nmos$2
Xnmos$3_348 a_n66090_n1434# VSS VSS a_n65943_n1354# nmos$3
Xnmos$3_326 a_n64585_n10590# VSS VSS a_n64438_n10510# nmos$3
Xnmos$2_1502 a_n53587_n9213# VSS ML_28 m1_n53490_n9005# nmos$2
Xnmos$3_337 a_n61572_n7974# VSS VSS a_n61425_n7894# nmos$3
Xnmos$2_2258 WL_11 VSS SL_13N a_n61572_13253# nmos$2
Xnmos$2_2269 a_n62930_13034# VSS SL_12 a_n62616_13023# nmos$2
Xnmos$2_1535 a_n64585_n13206# VSS a_n64124_n13137# SL_11N nmos$2
Xnmos$2_1546 a_n62930_n10510# VSS SL_12 a_n62616_n10521# nmos$2
Xnmos$2_1524 a_n56915_n7894# VSS SL_16 a_n56601_n7905# nmos$2
Xnmos$2_1513 WL_27 VSS SL_16N a_n57062_n7974# nmos$2
Xnmos$3_359 a_n54048_n5358# VSS VSS a_n53901_n5278# nmos$3
Xnmos$2_1568 a_n66090_n13206# VSS a_n65629_n13137# SL_10N nmos$2
Xnmos$2_1579 a_n65943_n11818# VSS SL_10 a_n65629_n11829# nmos$2
Xnmos$2_1557 WL_29 VSS a_n61425_n10510# SL_13 nmos$2
Xpmos_2109 a_n46516_21101# VDD a_n46369_20882# VDD pmos
Xpmos_1408 a_n76483_24806# VDD VDD a_n76630_25025# pmos
Xpmos_1419 a_n76483_26114# VDD VDD a_n76630_26333# pmos
Xnmos_1306 a_n41856_1262# VSS a_n42003_1481# VSS nmos
Xnmos_880 a_n38843_3878# VSS a_n38990_4097# VSS nmos
Xnmos$2_4150 a_n52082_3867# VSS ML_18 m1_n51985_4075# nmos$2
Xnmos$2_4183 a_n52082_7791# VSS ML_15 m1_n51985_7999# nmos$2
Xnmos_891 a_n35829_6494# VSS a_n35976_6713# VSS nmos
Xnmos$2_4172 WL_16 VSS SL_18N a_n54048_6713# nmos$2
Xnmos$2_4161 a_n51035_5405# VSS a_n50574_5175# SL_20N nmos$2
Xnmos$2_3460 WL_3 VSS SL_15N a_n58558_23717# nmos$2
Xnmos$2_3471 a_n53587_22179# VSS ML_4 m1_n53490_22387# nmos$2
Xnmos$2_4194 WL_17 VSS SL_19N a_n52543_5405# nmos$2
Xnmos$2_3493 a_n55557_23717# VSS a_n55096_23487# SL_17N nmos$2
Xnmos$2_3482 a_n57062_22409# VSS a_n56601_22179# SL_16N nmos$2
Xnmos$2_2770 a_n76630_14561# VSS a_n76169_14331# SL_3N nmos$2
Xnmos$3_871 a_n52543_13253# VSS VSS a_n52396_13034# nmos$3
Xnmos$3_860 a_n48021_11945# VSS VSS a_n47874_11726# nmos$3
Xnmos$3_882 a_n48021_15869# VSS VSS a_n47874_15650# nmos$3
Xnmos$2_2792 WL_9 VSS SL_2N a_n78135_15869# nmos$2
Xnmos$2_2781 WL_11 VSS SL_2N a_n78135_13253# nmos$2
Xnmos$3_893 a_n45017_11945# VSS VSS a_n44870_11726# nmos$3
Xnmos$2_381 a_n49530_173# VSS a_n49069_n57# SL_21N nmos$2
Xnmos$2_370 WL_22 VSS a_n47874_n1354# SL_22 nmos$2
Xnmos$2_392 a_n47560_n2673# VSS ML_23 m1_n47463_n2465# nmos$2
Xpmos_1920 a_n46516_11945# VDD a_n46369_11726# VDD pmos
Xpmos_1964 a_n48021_14561# VDD a_n47874_14342# VDD pmos
Xpmos_1953 a_n47874_13034# VDD VDD a_n48021_13253# pmos
Xpmos_1942 a_n52543_13253# VDD a_n52396_13034# VDD pmos
Xpmos_1931 a_n52543_9329# VDD a_n52396_9110# VDD pmos
Xpmos_1997 a_n43512_13253# VDD a_n43365_13034# VDD pmos
Xpmos_1975 a_n42003_9329# VDD a_n41856_9110# VDD pmos
Xpmos_1986 a_n44870_9110# VDD VDD a_n45017_9329# pmos
Xnmos_12 a_n47874_n28971# VSS a_n48021_n29051# VSS nmos
Xnmos_23 a_n46369_n10510# VSS a_n46516_n10590# VSS nmos
Xnmos_34 a_n43365_n9202# VSS a_n43512_n9282# VSS nmos
Xnmos_45 a_n52396_n13126# VSS a_n52543_n13206# VSS nmos
Xnmos_67 a_n50888_n7894# VSS a_n51035_n7974# VSS nmos
Xnmos_56 a_n52396_n6586# VSS a_n52543_n6666# VSS nmos
Xnmos_89 a_n50888_n1354# VSS a_n51035_n1434# VSS nmos
Xnmos_78 a_n53901_n1354# VSS a_n54048_n1434# VSS nmos
Xnmos_110 a_n44870_n2662# VSS a_n45017_n2742# VSS nmos
Xnmos_132 a_n26495_n13280# VSS VSS COMP31 nmos
Xnmos_121 a_n26495_n10404# VSS m1_n26796_n10392# VSS nmos
Xnmos_154 a_n35829_n13126# VSS a_n35976_n13206# VSS nmos
Xnmos_165 a_n37338_n9202# VSS a_n37485_n9282# VSS nmos
Xnmos_143 OUTP VSS a_n28089_n9460# VSS nmos
Xnmos_176 a_n34324_n6586# VSS a_n34471_n6666# VSS nmos
Xnmos_187 a_n38843_n46# VSS a_n38990_173# VSS nmos
Xnmos_198 OUTP VSS a_n28089_n6584# VSS nmos
Xnmos$2_2022 WL_15 VSS SL_17N a_n55557_8021# nmos$2
Xnmos$2_2000 WL_16 VSS a_n53901_6494# SL_18 nmos$2
Xnmos$2_2011 WL_16 VSS a_n55410_6494# SL_17 nmos$2
Xnmos$3_101 a_n45017_n1434# VSS VSS a_n44870_n1354# nmos$3
Xnmos$3_112 a_n34471_n13206# VSS VSS a_n34324_n13126# nmos$3
Xnmos$3_123 a_n37485_n10590# VSS VSS a_n37338_n10510# nmos$3
Xnmos$2_2033 a_n56915_3878# VSS SL_16 a_n56601_3867# nmos$2
Xnmos$2_2055 a_n61572_4097# VSS a_n61111_3867# SL_13N nmos$2
Xnmos$2_2044 a_n62930_2570# VSS SL_12 a_n62616_2559# nmos$2
Xnmos$2_1310 a_n73470_n46# VSS SL_5 a_n73156_n57# nmos$2
Xnmos$3_145 a_n37485_n1434# VSS VSS a_n37338_n1354# nmos$3
Xnmos$2_1321 a_n68957_n1354# VSS SL_8 a_n68643_n1365# nmos$2
Xnmos$3_156 a_n58558_n29051# VSS VSS a_n58411_n28971# nmos$3
Xnmos$3_134 a_n34471_n6666# VSS VSS a_n34324_n6586# nmos$3
Xnmos$2_2099 a_n67138_6483# VSS ML_16 m1_n67041_6691# nmos$2
Xnmos$2_2088 WL_17 VSS a_n64438_5186# SL_11 nmos$2
Xnmos$2_2077 a_n64124_3867# VSS ML_18 m1_n64027_4075# nmos$2
Xnmos$2_2066 a_n67138_2559# VSS ML_19 m1_n67041_2767# nmos$2
Xnmos$2_1332 a_n70142_n57# VSS ML_21 m1_n70045_151# nmos$2
Xnmos$2_1343 a_n72108_n2742# VSS a_n71647_n2673# SL_6N nmos$2
Xnmos$2_1354 a_n73470_n2662# VSS SL_5 a_n73156_n2673# nmos$2
Xnmos$3_189 a_n72108_n11898# VSS VSS a_n71961_n11818# nmos$3
Xnmos$3_167 a_n69104_n29051# VSS VSS a_n68957_n28971# nmos$3
Xnmos$3_178 a_n70603_n10590# VSS VSS a_n70456_n10510# nmos$3
Xnmos$2_1365 a_n70456_n2662# VSS SL_7 a_n70142_n2673# nmos$2
Xnmos$2_1387 WL_26 VSS a_n81002_n6586# SL_0 nmos$2
Xnmos$2_1376 a_n76630_n6666# VSS a_n76169_n6597# SL_3N nmos$2
Xnmos$2_1398 a_n69104_n6666# VSS a_n68643_n6597# SL_8N nmos$2
Xpmos_1216 a_n79497_14342# VDD VDD a_n79644_14561# pmos
Xpmos_1205 a_n81002_10418# VDD VDD a_n81149_10637# pmos
Xpmos_1227 a_n77988_15650# VDD VDD a_n78135_15869# pmos
Xpmos_1238 a_n70603_11945# VDD a_n70456_11726# VDD pmos
Xpmos_1249 a_n72108_9329# VDD a_n71961_9110# VDD pmos
Xpmos_409 a_n58558_n29051# VDD a_n58411_n28971# VDD pmos
Xnmos_1125 a_n50888_27422# VSS a_n51035_27641# VSS nmos
Xnmos_1136 a_n46369_26114# VSS a_n46516_26333# VSS nmos
Xnmos_1114 a_n47874_24806# VSS a_n48021_25025# VSS nmos
Xnmos_1103 a_n49383_22190# VSS a_n49530_22409# VSS nmos
Xnmos_1169 a_n27274_21232# VSS a_n27618_21232# VSS nmos
Xnmos_1158 a_n26151_19794# VSS a_n26495_19794# VSS nmos
Xnmos_1147 OUTP VSS a_n28089_16424# VSS nmos
Xnmos$2_3290 WL_1 VSS a_n77988_26114# SL_2 nmos$2
Xnmos$3_690 a_n57062_17177# VSS VSS a_n56915_16958# nmos$3
Xpmos_1761 a_n35829_14342# VDD VDD a_n35976_14561# pmos
Xpmos_1750 a_n38990_14561# VDD a_n38843_14342# VDD pmos
Xpmos_1772 a_n27618_11166# VDD VDD m1_n27919_11178# pmos
Xpmos_910 a_n64438_3878# VDD VDD a_n64585_4097# pmos
Xpmos_921 a_n67452_2570# VDD VDD a_n67599_2789# pmos
Xpmos_1794 OUTP VDD VDD a_n28089_14986# pmos
Xpmos_1783 ML_11 VDD a_n28485_15578# VDD pmos
Xpmos_954 a_n64438_9110# VDD VDD a_n64585_9329# pmos
Xpmos_943 a_n63077_6713# VDD a_n62930_6494# VDD pmos
Xpmos_932 a_n67452_6494# VDD VDD a_n67599_6713# pmos
Xpmos_987 a_n65943_14342# VDD VDD a_n66090_14561# pmos
Xpmos_976 a_n65943_13034# VDD VDD a_n66090_13253# pmos
Xpmos_965 a_n65943_9110# VDD VDD a_n66090_9329# pmos
Xnmos$2_4908 WL_0 VSS a_n44870_27422# SL_24 nmos$2
Xnmos$2_4919 a_n44556_24795# VSS ML_2 m1_n44459_25003# nmos$2
Xpmos_998 a_n61572_14561# VDD a_n61425_14342# VDD pmos
Xnmos$5_911 VEVAL VSS m1_n39940_19771# VSS nmos$5
Xnmos$5_900 VEVAL VSS m1_n42954_10615# VSS nmos$5
Xnmos$5_933 VEVAL VSS m1_n42954_23695# VSS nmos$5
Xnmos$5_922 VEVAL VSS m1_n45958_23695# VSS nmos$5
Xnmos$5_955 VEVAL VSS m1_n47463_22387# VSS nmos$5
Xnmos$5_944 VEVAL VSS m1_n51985_17155# VSS nmos$5
Xnmos$5_977 VEVAL VSS m1_n41445_26311# VSS nmos$5
Xnmos$5_966 VEVAL VSS m1_n50477_25003# VSS nmos$5
Xnmos$5_988 VEVAL VSS m1_n33913_18463# VSS nmos$5
Xnmos$5_999 VEVAL VSS m1_n36927_22387# VSS nmos$5
Xnmos$2_1162 WL_25 VSS SL_0N a_n81149_n5358# nmos$2
Xnmos$2_1140 a_n78135_n5358# VSS a_n77674_n5289# SL_2N nmos$2
Xnmos$2_1151 a_n74975_n3970# VSS SL_4 a_n74661_n3981# nmos$2
Xnmos$2_1195 a_n79644_173# VSS a_n79183_n57# SL_1N nmos$2
Xnmos$2_1184 a_n80688_n1365# VSS ML_22 m1_n80591_n1157# nmos$2
Xnmos$2_1173 a_n77988_n3970# VSS SL_2 a_n77674_n3981# nmos$2
Xpmos_1002 a_n56915_9110# VDD VDD a_n57062_9329# pmos
Xpmos_1013 a_n58411_9110# VDD VDD a_n58558_9329# pmos
Xpmos_1024 a_n58558_9329# VDD a_n58411_9110# VDD pmos
Xpmos_1046 a_n56915_15650# VDD VDD a_n57062_15869# pmos
Xpmos_1035 a_n58558_15869# VDD a_n58411_15650# VDD pmos
Xpmos_1057 a_n61425_14342# VDD VDD a_n61572_14561# pmos
Xpmos_1068 a_n67599_1481# VDD a_n67452_1262# VDD pmos
Xpmos_206 a_n45017_n2742# VDD a_n44870_n2662# VDD pmos
Xpmos_1079 a_n69104_1481# VDD a_n68957_1262# VDD pmos
Xpmos_217 a_n40498_n2742# VDD a_n40351_n2662# VDD pmos
Xpmos_228 a_n26495_n13280# VDD COMP31 VDD pmos
Xpmos_239 a_n26151_n11842# VDD VDD a_n26495_n11842# pmos
Xpmos_2281 a_n34324_26114# VDD VDD a_n34471_26333# pmos
Xpmos_2292 a_n37338_26114# VDD VDD a_n37485_26333# pmos
Xpmos_2270 a_n34471_23717# VDD a_n34324_23498# VDD pmos
Xpmos_1580 a_n64585_25025# VDD a_n64438_24806# VDD pmos
Xpmos_1591 a_n54048_25025# VDD a_n53901_24806# VDD pmos
Xpmos_762 a_n65943_n2662# VDD VDD a_n66090_n2742# pmos
Xpmos_751 a_n65943_n6586# VDD VDD a_n66090_n6666# pmos
Xpmos_740 a_n63077_n5358# VDD a_n62930_n5278# VDD pmos
Xnmos$2_4705 a_n52396_16958# VSS SL_19 a_n52082_16947# nmos$2
Xpmos_784 a_n62930_n46# VDD VDD a_n63077_173# pmos
Xpmos_773 a_n61572_n2742# VDD a_n61425_n2662# VDD pmos
Xpmos_795 a_n54048_n4050# VDD a_n53901_n3970# VDD pmos
Xnmos$2_4749 WL_3 VSS a_n50888_23498# SL_20 nmos$2
Xnmos$2_4727 a_n51035_21101# VSS a_n50574_20871# SL_20N nmos$2
Xnmos$2_4716 a_n51035_19793# VSS a_n50574_19563# SL_20N nmos$2
Xnmos$2_4738 a_n52082_20871# VSS ML_5 m1_n51985_21079# nmos$2
Xnmos$5_207 VEVAL VSS m1_n79086_n12929# VSS nmos$5
Xnmos$5_218 VEVAL VSS m1_n79086_n6389# VSS nmos$5
Xnmos$5_229 VEVAL VSS m1_n74564_n5081# VSS nmos$5
Xnmos$2_903 WL_31 VSS SL_7N a_n70603_n13206# nmos$2
Xnmos$2_914 WL_30 VSS a_n70456_n11818# SL_7 nmos$2
Xnmos$2_936 a_n71961_n13126# VSS SL_6 a_n71647_n13137# nmos$2
Xnmos$2_947 WL_29 VSS a_n73470_n10510# SL_5 nmos$2
Xnmos$2_925 a_n68957_n10510# VSS SL_8 a_n68643_n10521# nmos$2
Xnmos$2_958 WL_30 VSS a_n71961_n11818# SL_6 nmos$2
Xnmos$2_969 a_n71961_n9202# VSS SL_6 a_n71647_n9213# nmos$2
Xpmos_15 a_n45017_n29051# VDD a_n44870_n28971# VDD pmos
Xpmos_26 a_n49383_n28971# VDD VDD a_n49530_n29051# pmos
Xpmos_37 a_n44870_n13126# VDD VDD a_n45017_n13206# pmos
Xpmos_59 a_n41856_n10510# VDD VDD a_n42003_n10590# pmos
Xpmos_48 a_n46369_n9202# VDD VDD a_n46516_n9282# pmos
Xnmos$5_730 VEVAL VSS m1_n67041_25003# VSS nmos$5
Xnmos$5_741 VEVAL VSS m1_n54999_27619# VSS nmos$5
Xnmos$5_763 VEVAL VSS m1_n36927_5383# VSS nmos$5
Xnmos$5_752 VEVAL VSS m1_n35418_1459# VSS nmos$5
Xnmos$5_796 VEVAL VSS m1_n35418_15847# VSS nmos$5
Xnmos$5_785 VEVAL VSS m1_n36927_11923# VSS nmos$5
Xnmos$5_774 VEVAL VSS m1_n33913_10615# VSS nmos$5
Xnmos_709 a_n81002_18266# VSS a_n81149_18485# VSS nmos
Xnmos$2_1909 a_n61111_n6597# VSS ML_26 m1_n61014_n6389# nmos$2
Xnmos$2_5203 a_n53901_1262# VSS SL_18 a_n53587_1251# nmos$2
Xnmos$2_5225 a_n58097_1251# VSS ML_20 m1_n58000_1459# nmos$2
Xnmos$2_5214 WL_20 VSS SL_10N a_n66090_1481# nmos$2
Xpmos_570 a_n81149_n2742# VDD a_n81002_n2662# VDD pmos
Xnmos$2_4524 WL_7 VSS SL_26N a_n42003_18485# nmos$2
Xnmos$2_4502 WL_9 VSS a_n40351_15650# SL_27 nmos$2
Xnmos$2_4513 a_n46369_7802# VSS SL_23 a_n46055_7791# nmos$2
Xnmos$2_5258 WL_20 VSS a_n61425_1262# SL_13 nmos$2
Xnmos$2_5236 a_n75122_1481# VSS a_n74661_1251# SL_4N nmos$2
Xnmos$2_5247 WL_20 VSS a_n79497_1262# SL_1 nmos$2
Xpmos_581 a_n76483_n2662# VDD VDD a_n76630_n2742# pmos
Xpmos_592 a_n68957_n6586# VDD VDD a_n69104_n6666# pmos
Xnmos$2_4546 a_n40037_19563# VSS ML_6 m1_n39940_19771# nmos$2
Xnmos$2_4535 a_n41542_18255# VSS ML_7 m1_n41445_18463# nmos$2
Xnmos$2_4557 a_n43051_16947# VSS ML_8 m1_n42954_17155# nmos$2
Xnmos$2_3812 a_n37338_3878# VSS SL_29 a_n37024_3867# nmos$2
Xnmos$2_3801 WL_19 VSS a_n38843_2570# SL_28 nmos$2
Xnmos$2_5269 a_n63077_1481# VSS a_n62616_1251# SL_12N nmos$2
Xnmos$2_4579 a_n43051_19563# VSS ML_6 m1_n42954_19771# nmos$2
Xnmos$2_4568 a_n44870_16958# VSS SL_24 a_n44556_16947# nmos$2
Xnmos$2_3845 a_n37024_7791# VSS ML_15 m1_n36927_7999# nmos$2
Xnmos$2_3834 WL_16 VSS SL_28N a_n38990_6713# nmos$2
Xnmos$2_3823 a_n37338_5186# VSS SL_29 a_n37024_5175# nmos$2
Xnmos$2_3889 a_n35515_10407# VSS ML_13 m1_n35418_10615# nmos$2
Xnmos$2_3867 WL_15 VSS SL_31N a_n34471_8021# nmos$2
Xnmos$2_3856 WL_17 VSS SL_30N a_n35976_5405# nmos$2
Xnmos$2_3878 WL_18 VSS a_n35829_3878# SL_30 nmos$2
Xnmos$2_700 WL_25 VSS a_n37338_n5278# SL_29 nmos$2
Xnmos$2_711 a_n38529_n3981# VSS ML_24 m1_n38432_n3773# nmos$2
Xnmos$2_755 a_n34010_n57# VSS ML_21 m1_n33913_151# nmos$2
Xnmos$2_733 WL_21 VSS SL_28N a_n38990_173# nmos$2
Xnmos$2_744 a_n34324_n1354# VSS SL_31 a_n34010_n1365# nmos$2
Xnmos$2_722 a_n37338_n1354# VSS SL_29 a_n37024_n1365# nmos$2
Xnmos$2_766 WL_23 VSS a_n37338_n2662# SL_29 nmos$2
Xnmos$2_777 a_n38990_n2742# VSS a_n38529_n2673# SL_28N nmos$2
Xnmos$2_788 WL_26 VSS a_n34324_n6586# SL_31 nmos$2
Xnmos$2_799 WL_26 VSS a_n38843_n6586# SL_28 nmos$2
Xpmos$1_112 a_n28089_29366# VDD m1_n27919_29872# a_n27274_29860# pmos$1
Xpmos$1_101 OUTP VDD m1_n26796_25558# a_n26151_25546# pmos$1
Xpmos$1_123 OUTP VDD a_n27274_24108# m1_n28364_24031# pmos$1
Xnmos$5_560 VEVAL VSS m1_n77577_13231# VSS nmos$5
Xnmos$5_571 VEVAL VSS m1_n71550_10615# VSS nmos$5
Xnmos$5_593 VEVAL VSS m1_n68546_19771# VSS nmos$5
Xnmos$5_582 VEVAL VSS m1_n68546_14539# VSS nmos$5
Xnmos$1_12 OUTP VSS a_n26151_n7528# a_n27618_n7528# nmos$1
Xnmos$1_23 a_n28089_n5146# VSS m1_n26796_n4640# a_n26151_n4652# nmos$1
Xnmos$1_56 OUTP VSS m1_n27919_5426# a_n27274_5414# nmos$1
Xnmos$1_45 a_n28089_2044# VSS m1_n26796_2550# a_n26151_2538# nmos$1
Xnmos$1_34 OUTP VSS m1_n27919_n1764# a_n27274_n1776# nmos$1
Xnmos$1_89 a_n28089_19300# VSS a_n27274_19794# m1_n28364_19717# nmos$1
Xnmos$1_78 a_n28089_14986# VSS m1_n26796_15492# a_n26151_15480# nmos$1
Xnmos$1_67 OUTP VSS m1_n27919_9740# a_n27274_9728# nmos$1
Xpmos$3_2 PC VDD ML_30 VDD pmos$3
Xnmos_506 a_n67452_6494# VSS a_n67599_6713# VSS nmos
Xnmos_539 a_n61425_14342# VSS a_n61572_14561# VSS nmos
Xnmos_528 a_n65943_9110# VSS a_n66090_9329# VSS nmos
Xnmos_517 a_n62930_7802# VSS a_n63077_8021# VSS nmos
Xnmos$2_3108 a_n78135_18485# VSS a_n77674_18255# SL_2N nmos$2
Xnmos$2_3119 a_n76630_19793# VSS a_n76169_19563# SL_3N nmos$2
Xnmos$2_2418 a_n55096_15639# VSS ML_9 m1_n54999_15847# nmos$2
Xnmos$2_2407 a_n56601_15639# VSS ML_9 m1_n56504_15847# nmos$2
Xnmos$3_519 a_n78135_6713# VSS VSS a_n77988_6494# nmos$3
Xnmos$2_2429 a_n68643_2559# VSS ML_19 m1_n68546_2767# nmos$2
Xnmos$3_508 a_n75122_2789# VSS VSS a_n74975_2570# nmos$3
Xnmos$2_1728 a_n62616_n57# VSS ML_21 m1_n62519_151# nmos$2
Xnmos$2_1706 a_n66090_173# VSS a_n65629_n57# SL_10N nmos$2
Xnmos$2_1717 a_n62616_n1365# VSS ML_22 m1_n62519_n1157# nmos$2
Xnmos$2_1739 WL_23 VSS SL_11N a_n64585_n2742# nmos$2
Xnmos$2_5000 a_n37485_22409# VSS a_n37024_22179# SL_29N nmos$2
Xnmos$2_5022 a_n37024_23487# VSS ML_3 m1_n36927_23695# nmos$2
Xnmos$2_5033 a_n34324_22190# VSS SL_31 a_n34010_22179# nmos$2
Xnmos$2_5011 a_n38843_20882# VSS SL_28 a_n38529_20871# nmos$2
Xnmos$2_5077 a_n35515_26103# VSS ML_1 m1_n35418_26311# nmos$2
Xnmos$2_5066 a_n34324_24806# VSS SL_31 a_n34010_24795# nmos$2
Xnmos$2_5044 WL_3 VSS SL_30N a_n35976_23717# nmos$2
Xnmos$2_5055 WL_7 VSS a_n35829_18266# SL_30 nmos$2
Xnmos$2_4321 a_n54048_15869# VSS a_n53587_15639# SL_18N nmos$2
Xnmos$2_4332 a_n52543_13253# VSS a_n52082_13023# SL_19N nmos$2
Xnmos$2_4310 a_n52396_13034# VSS SL_19 a_n52082_13023# nmos$2
Xnmos$2_5099 a_n37338_27422# VSS SL_29 a_n37024_27411# nmos$2
Xnmos$2_5088 a_n37338_24806# VSS SL_29 a_n37024_24795# nmos$2
Xnmos$2_3620 WL_4 VSS SL_11N a_n64585_22409# nmos$2
Xnmos$2_4365 WL_9 VSS SL_22N a_n48021_15869# nmos$2
Xnmos$2_4343 WL_11 VSS a_n47874_13034# SL_22 nmos$2
Xnmos$2_4354 WL_11 VSS SL_21N a_n49530_13253# nmos$2
Xnmos$2_3653 WL_0 VSS a_n62930_27422# SL_12 nmos$2
Xnmos$2_3664 WL_1 VSS SL_12N a_n63077_26333# nmos$2
Xnmos$2_3642 WL_2 VSS SL_13N a_n61572_25025# nmos$2
Xnmos$2_3631 a_n63077_23717# VSS a_n62616_23487# SL_12N nmos$2
Xnmos$2_4398 WL_12 VSS SL_27N a_n40498_11945# nmos$2
Xnmos$2_4376 a_n40037_10407# VSS ML_13 m1_n39940_10615# nmos$2
Xnmos$2_4387 WL_14 VSS SL_25N a_n43512_9329# nmos$2
Xnmos$2_3697 a_n64438_27422# VSS SL_11 a_n64124_27411# nmos$2
Xnmos$2_3675 WL_1 VSS a_n62930_26114# SL_12 nmos$2
Xnmos$2_3686 WL_2 VSS a_n65943_24806# SL_10 nmos$2
Xnmos$2_2952 a_n67452_18266# VSS SL_9 a_n67138_18255# nmos$2
Xnmos$2_2941 WL_9 VSS a_n68957_15650# SL_8 nmos$2
Xnmos$2_2930 a_n70142_15639# VSS ML_9 m1_n70045_15847# nmos$2
Xnmos$2_530 a_n46369_n11818# VSS SL_23 a_n46055_n11829# nmos$2
Xnmos$2_2974 a_n68643_19563# VSS ML_6 m1_n68546_19771# nmos$2
Xnmos$2_2963 WL_8 VSS a_n70456_16958# SL_7 nmos$2
Xnmos$2_2985 WL_8 VSS SL_6N a_n72108_17177# nmos$2
Xnmos$2_552 WL_26 VSS a_n50888_n6586# SL_20 nmos$2
Xnmos$2_563 WL_26 VSS a_n49383_n6586# SL_21 nmos$2
Xnmos$2_541 a_n41542_n6597# VSS ML_26 m1_n41445_n6389# nmos$2
Xnmos$2_2996 WL_8 VSS a_n73470_16958# SL_5 nmos$2
Xnmos$2_585 a_n34471_n13206# VSS a_n34010_n13137# SL_31N nmos$2
Xnmos$2_596 a_n34324_n11818# VSS SL_31 a_n34010_n11829# nmos$2
Xnmos$2_574 a_n49530_n6666# VSS a_n49069_n6597# SL_21N nmos$2
Xnmos$5_390 VEVAL VSS m1_n54999_6691# VSS nmos$5
Xnmos_314 a_n81002_n11818# VSS a_n81149_n11898# VSS nmos
Xnmos_325 a_n77988_n7894# VSS a_n78135_n7974# VSS nmos
Xnmos_303 a_n68957_n7894# VSS a_n69104_n7974# VSS nmos
Xnmos_347 a_n79497_n2662# VSS a_n79644_n2742# VSS nmos
Xnmos_336 a_n79497_n3970# VSS a_n79644_n4050# VSS nmos
Xnmos_358 a_n73470_n3970# VSS a_n73617_n4050# VSS nmos
Xnmos_369 a_n73470_n2662# VSS a_n73617_n2742# VSS nmos
Xnmos$2_2204 WL_14 VSS a_n65943_9110# SL_10 nmos$2
Xnmos$3_305 a_n57062_n7974# VSS VSS a_n56915_n7894# nmos$3
Xnmos$2_2248 a_n64124_15639# VSS ML_9 m1_n64027_15847# nmos$2
Xnmos$2_2237 a_n65943_14342# VSS SL_10 a_n65629_14331# nmos$2
Xnmos$2_2226 a_n64124_13023# VSS ML_11 m1_n64027_13231# nmos$2
Xnmos$2_2215 WL_12 VSS a_n64438_11726# SL_11 nmos$2
Xnmos$3_349 a_n66090_173# VSS VSS a_n65943_n46# nmos$3
Xnmos$3_316 a_n63077_n13206# VSS VSS a_n62930_n13126# nmos$3
Xnmos$3_327 a_n64585_n9282# VSS VSS a_n64438_n9202# nmos$3
Xnmos$2_1503 WL_28 VSS SL_17N a_n55557_n9282# nmos$2
Xnmos$3_338 a_n61572_n6666# VSS VSS a_n61425_n6586# nmos$3
Xnmos$2_2259 a_n61572_13253# VSS a_n61111_13023# SL_13N nmos$2
Xnmos$2_1536 a_n62616_n13137# VSS ML_31 m1_n62519_n12929# nmos$2
Xnmos$2_1525 a_n56915_n9202# VSS SL_16 a_n56601_n9213# nmos$2
Xnmos$2_1514 a_n55410_n7894# VSS SL_17 a_n55096_n7905# nmos$2
Xnmos$2_1569 WL_31 VSS a_n64438_n13126# SL_11 nmos$2
Xnmos$2_1547 a_n62616_n11829# VSS ML_30 m1_n62519_n11621# nmos$2
Xnmos$2_1558 a_n61425_n11818# VSS SL_13 a_n61111_n11829# nmos$2
Xpmos_1409 a_n75122_25025# VDD a_n74975_24806# VDD pmos
Xnmos_1307 a_n52396_1262# VSS a_n52543_1481# VSS nmos
Xnmos_870 a_n26151_8290# VSS a_n26495_8290# VSS nmos
Xnmos$2_4140 WL_19 VSS a_n50888_2570# SL_20 nmos$2
Xnmos_892 a_n35829_7802# VSS a_n35976_8021# VSS nmos
Xnmos$2_4162 WL_17 VSS a_n50888_5186# SL_20 nmos$2
Xnmos$2_4173 a_n52082_5175# VSS ML_17 m1_n51985_5383# nmos$2
Xnmos_881 a_n37338_3878# VSS a_n37485_4097# VSS nmos
Xnmos$2_4151 WL_18 VSS a_n52396_3878# SL_19 nmos$2
Xnmos$2_3461 WL_3 VSS a_n56915_23498# SL_16 nmos$2
Xnmos$2_3472 a_n55557_22409# VSS a_n55096_22179# SL_17N nmos$2
Xnmos$2_3450 a_n59916_20882# VSS SL_14 a_n59602_20871# nmos$2
Xnmos$2_4184 a_n54048_8021# VSS a_n53587_7791# SL_18N nmos$2
Xnmos$2_4195 a_n52543_5405# VSS a_n52082_5175# SL_19N nmos$2
Xnmos$2_3494 WL_3 VSS SL_17N a_n55557_23717# nmos$2
Xnmos$2_3483 WL_5 VSS a_n55410_20882# SL_17 nmos$2
Xnmos$2_2760 WL_9 VSS a_n77988_15650# SL_2 nmos$2
Xnmos$3_861 a_n48021_10637# VSS VSS a_n47874_10418# nmos$3
Xnmos$3_850 a_n48021_6713# VSS VSS a_n47874_6494# nmos$3
Xnmos$3_872 a_n52543_15869# VSS VSS a_n52396_15650# nmos$3
Xnmos$2_2793 a_n76169_15639# VSS ML_9 m1_n76072_15847# nmos$2
Xnmos$2_2771 WL_11 VSS a_n74975_13034# SL_4 nmos$2
Xnmos$2_2782 a_n78135_13253# VSS a_n77674_13023# SL_2N nmos$2
Xnmos$3_894 a_n43512_11945# VSS VSS a_n43365_11726# nmos$3
Xnmos$3_883 a_n40498_10637# VSS VSS a_n40351_10418# nmos$3
Xnmos$2_360 a_n50574_n57# VSS ML_21 m1_n50477_151# nmos$2
Xnmos$2_371 a_n47874_n1354# VSS SL_22 a_n47560_n1365# nmos$2
Xnmos$2_382 WL_21 VSS a_n49383_n46# SL_21 nmos$2
Xnmos$2_393 a_n51035_n2742# VSS a_n50574_n2673# SL_20N nmos$2
Xpmos_1921 a_n48021_9329# VDD a_n47874_9110# VDD pmos
Xpmos_1910 a_n50888_5186# VDD VDD a_n51035_5405# pmos
Xpmos_1954 a_n49383_13034# VDD VDD a_n49530_13253# pmos
Xpmos_1943 a_n53901_13034# VDD VDD a_n54048_13253# pmos
Xpmos_1932 a_n53901_11726# VDD VDD a_n54048_11945# pmos
Xpmos_1965 a_n48021_13253# VDD a_n47874_13034# VDD pmos
Xpmos_1976 a_n43365_9110# VDD VDD a_n43512_9329# pmos
Xpmos_1987 a_n45017_9329# VDD a_n44870_9110# VDD pmos
Xpmos_1998 a_n44870_13034# VDD VDD a_n45017_13253# pmos
Xnmos_13 a_n50888_n28971# VSS a_n51035_n29051# VSS nmos
Xnmos_24 a_n46369_n11818# VSS a_n46516_n11898# VSS nmos
Xnmos_35 a_n43365_n6586# VSS a_n43512_n6666# VSS nmos
Xnmos_46 a_n53901_n13126# VSS a_n54048_n13206# VSS nmos
Xnmos_68 a_n50888_n10510# VSS a_n51035_n10590# VSS nmos
Xnmos_57 a_n47874_n9202# VSS a_n48021_n9282# VSS nmos
Xnmos_79 a_n53901_n46# VSS a_n54048_173# VSS nmos
Xnmos_111 a_n43365_n2662# VSS a_n43512_n2742# VSS nmos
Xnmos_133 a_n27274_n10404# VSS a_n27618_n10404# VSS nmos
Xnmos_122 OUTP VSS a_n27990_n9846# VSS nmos
Xnmos_100 a_n46369_n3970# VSS a_n46516_n4050# VSS nmos
Xnmos_155 a_n35829_n10510# VSS a_n35976_n10590# VSS nmos
Xnmos_166 a_n38843_n9202# VSS a_n38990_n9282# VSS nmos
Xnmos_144 a_n28485_n8868# VSS VSS m1_n28364_n9043# nmos
Xnmos_188 a_n37338_n46# VSS a_n37485_173# VSS nmos
Xnmos_177 a_n34324_n5278# VSS a_n34471_n5358# VSS nmos
Xnmos_199 OUTP VSS a_n28089_n5146# VSS nmos
Xnmos$2_2023 a_n55557_8021# VSS a_n55096_7791# SL_17N nmos$2
Xnmos$2_2001 WL_16 VSS SL_17N a_n55557_6713# nmos$2
Xnmos$2_2012 a_n57062_6713# VSS a_n56601_6483# SL_16N nmos$2
Xnmos$3_102 a_n45017_173# VSS VSS a_n44870_n46# nmos$3
Xnmos$3_113 a_n34471_n10590# VSS VSS a_n34324_n10510# nmos$3
Xnmos$3_124 a_n35976_n9282# VSS VSS a_n35829_n9202# nmos$3
Xnmos$2_2056 a_n61425_3878# VSS SL_13 a_n61111_3867# nmos$2
Xnmos$2_2034 a_n56915_2570# VSS SL_16 a_n56601_2559# nmos$2
Xnmos$2_2045 WL_19 VSS SL_11N a_n64585_2789# nmos$2
Xnmos$2_1311 a_n73156_n57# VSS ML_21 m1_n73059_151# nmos$2
Xnmos$3_146 a_n38990_n1434# VSS VSS a_n38843_n1354# nmos$3
Xnmos$2_1300 WL_22 VSS SL_4N a_n75122_n1434# nmos$2
Xnmos$3_157 a_n60063_n29051# VSS VSS a_n59916_n28971# nmos$3
Xnmos$3_135 a_n34471_n7974# VSS VSS a_n34324_n7894# nmos$3
Xnmos$2_2089 a_n64438_5186# VSS SL_11 a_n64124_5175# nmos$2
Xnmos$2_2078 WL_18 VSS SL_10N a_n66090_4097# nmos$2
Xnmos$2_2067 WL_19 VSS a_n65943_2570# SL_10 nmos$2
Xnmos$2_1333 WL_21 VSS a_n70456_n46# SL_7 nmos$2
Xnmos$2_1322 a_n67452_n1354# VSS SL_9 a_n67138_n1365# nmos$2
Xnmos$2_1344 a_n71647_n2673# VSS ML_23 m1_n71550_n2465# nmos$2
Xnmos$3_179 a_n67599_n11898# VSS VSS a_n67452_n11818# nmos$3
Xnmos$3_168 a_n73617_n29051# VSS VSS a_n73470_n28971# nmos$3
Xnmos$2_1366 a_n68957_n2662# VSS SL_8 a_n68643_n2673# nmos$2
Xnmos$2_1355 a_n73156_n2673# VSS ML_23 m1_n73059_n2465# nmos$2
Xnmos$2_1388 a_n79644_n6666# VSS a_n79183_n6597# SL_1N nmos$2
Xnmos$2_1377 WL_26 VSS SL_5N a_n73617_n6666# nmos$2
Xnmos$2_1399 WL_26 VSS SL_8N a_n69104_n6666# nmos$2
Xpmos_1217 a_n81002_14342# VDD VDD a_n81149_14561# pmos
Xpmos_1206 a_n81149_10637# VDD a_n81002_10418# VDD pmos
Xpmos_1228 a_n75122_15869# VDD a_n74975_15650# VDD pmos
Xpmos_1239 a_n70456_11726# VDD VDD a_n70603_11945# pmos
Xnmos_1126 a_n50888_26114# VSS a_n51035_26333# VSS nmos
Xnmos_1115 a_n49383_24806# VSS a_n49530_25025# VSS nmos
Xnmos_1104 a_n49383_20882# VSS a_n49530_21101# VSS nmos
Xnmos_1137 a_n46369_24806# VSS a_n46516_25025# VSS nmos
Xnmos_1159 a_n26495_19794# VSS VSS COMP8 nmos
Xnmos_1148 a_n27274_18356# VSS a_n27618_18356# VSS nmos
Xnmos$2_3280 WL_2 VSS a_n79497_24806# SL_1 nmos$2
Xnmos$2_3291 a_n77988_26114# VSS SL_2 a_n77674_26103# nmos$2
Xnmos$3_680 a_n73617_25025# VSS VSS a_n73470_24806# nmos$3
Xnmos$3_691 a_n60063_17177# VSS VSS a_n59916_16958# nmos$3
Xnmos$2_2590 WL_18 VSS a_n79497_3878# SL_1 nmos$2
Xpmos_0 a_n38843_n28971# VDD VDD a_n38990_n29051# pmos
Xnmos$2_190 a_n49530_n13206# VSS a_n49069_n13137# SL_21N nmos$2
Xpmos_1751 a_n37485_15869# VDD a_n37338_15650# VDD pmos
Xpmos_1762 a_n34471_14561# VDD a_n34324_14342# VDD pmos
Xpmos_1740 a_n35976_13253# VDD a_n35829_13034# VDD pmos
Xpmos_900 a_n55557_8021# VDD a_n55410_7802# VDD pmos
Xpmos_911 a_n63077_4097# VDD a_n62930_3878# VDD pmos
Xpmos_1784 a_n26151_15480# VDD VDD a_n26495_15480# pmos
Xpmos_1795 a_n28485_15578# VDD m1_n28364_15403# VDD pmos
Xpmos_1773 a_n28485_11264# VDD m1_n28364_11089# VDD pmos
Xpmos_944 a_n64438_6494# VDD VDD a_n64585_6713# pmos
Xpmos_933 a_n66090_5405# VDD a_n65943_5186# VDD pmos
Xpmos_922 a_n67452_1262# VDD VDD a_n67599_1481# pmos
Xpmos_988 a_n61572_13253# VDD a_n61425_13034# VDD pmos
Xpmos_977 a_n64585_13253# VDD a_n64438_13034# VDD pmos
Xpmos_955 a_n64438_11726# VDD VDD a_n64585_11945# pmos
Xpmos_966 a_n66090_9329# VDD a_n65943_9110# VDD pmos
Xnmos$2_4909 a_n46055_27411# VSS ML_0 m1_n45958_27619# nmos$2
Xpmos_999 a_n62930_15650# VDD VDD a_n63077_15869# pmos
Xnmos$5_912 VEVAL VSS m1_n44459_17155# VSS nmos$5
Xnmos$5_901 VEVAL VSS m1_n42954_13231# VSS nmos$5
Xnmos$5_923 VEVAL VSS m1_n44459_23695# VSS nmos$5
Xnmos$5_934 VEVAL VSS m1_n42954_18463# VSS nmos$5
Xnmos$5_945 VEVAL VSS m1_n51985_18463# VSS nmos$5
Xnmos$5_978 VEVAL VSS m1_n44459_25003# VSS nmos$5
Xnmos$5_967 VEVAL VSS m1_n51985_25003# VSS nmos$5
Xnmos$5_956 VEVAL VSS m1_n48972_21079# VSS nmos$5
Xnmos$5_989 VEVAL VSS m1_n35418_17155# VSS nmos$5
Xnmos$2_1130 WL_27 VSS SL_3N a_n76630_n7974# nmos$2
Xnmos$2_1163 WL_25 VSS a_n81002_n5278# SL_0 nmos$2
Xnmos$2_1141 a_n76483_n5278# VSS SL_3 a_n76169_n5289# nmos$2
Xnmos$2_1152 WL_24 VSS a_n74975_n3970# SL_4 nmos$2
Xnmos$2_1196 WL_21 VSS SL_1N a_n79644_173# nmos$2
Xnmos$2_1185 WL_22 VSS a_n81002_n1354# SL_0 nmos$2
Xnmos$2_1174 WL_24 VSS a_n77988_n3970# SL_2 nmos$2
Xpmos_1025 a_n60063_10637# VDD a_n59916_10418# VDD pmos
Xpmos_1003 a_n55557_9329# VDD a_n55410_9110# VDD pmos
Xpmos_1014 a_n60063_9329# VDD a_n59916_9110# VDD pmos
Xpmos_1047 a_n55557_15869# VDD a_n55410_15650# VDD pmos
Xpmos_1036 a_n58558_14561# VDD a_n58411_14342# VDD pmos
Xpmos_1058 a_n61425_2570# VDD VDD a_n61572_2789# pmos
Xpmos_207 a_n46369_n1354# VDD VDD a_n46516_n1434# pmos
Xpmos_1069 a_n67599_2789# VDD a_n67452_2570# VDD pmos
Xpmos_218 a_n43365_n2662# VDD VDD a_n43512_n2742# pmos
Xpmos_229 a_n26495_n11842# VDD VDD m1_n26796_n11830# pmos
Xpmos_2282 a_n37338_24806# VDD VDD a_n37485_25025# pmos
Xpmos_2271 a_n34324_22190# VDD VDD a_n34471_22409# pmos
Xpmos_2260 a_n35976_22409# VDD a_n35829_22190# VDD pmos
Xpmos_1570 a_n64438_27422# VDD VDD a_n64585_27641# pmos
Xpmos_2293 a_n35976_26333# VDD a_n35829_26114# VDD pmos
Xpmos_1581 a_n67452_24806# VDD VDD a_n67599_25025# pmos
Xpmos_1592 a_n55410_24806# VDD VDD a_n55557_25025# pmos
Xpmos_763 a_n65943_n1354# VDD VDD a_n66090_n1434# pmos
Xpmos_730 a_n63077_n9282# VDD a_n62930_n9202# VDD pmos
Xpmos_752 a_n64585_n6666# VDD a_n64438_n6586# VDD pmos
Xpmos_741 a_n64438_n6586# VDD VDD a_n64585_n6666# pmos
Xnmos$2_4706 WL_8 VSS SL_18N a_n54048_17177# nmos$2
Xpmos_774 a_n61572_n1434# VDD a_n61425_n1354# VDD pmos
Xpmos_785 a_n55410_n5278# VDD VDD a_n55557_n5358# pmos
Xpmos_796 a_n55410_n3970# VDD VDD a_n55557_n4050# pmos
Xnmos$2_4728 WL_5 VSS SL_20N a_n51035_21101# nmos$2
Xnmos$2_4717 WL_6 VSS SL_20N a_n51035_19793# nmos$2
Xnmos$2_4739 WL_5 VSS a_n52396_20882# SL_19 nmos$2
Xnmos$5_208 VEVAL VSS m1_n80591_n12929# VSS nmos$5
Xnmos$5_219 VEVAL VSS m1_n74564_n9005# VSS nmos$5
Xnmos$2_904 a_n70456_n13126# VSS SL_7 a_n70142_n13137# nmos$2
Xnmos$2_926 a_n68957_n11818# VSS SL_8 a_n68643_n11829# nmos$2
Xnmos$2_915 a_n70142_n11829# VSS ML_30 m1_n70045_n11621# nmos$2
Xnmos$2_937 WL_31 VSS a_n71961_n13126# SL_6 nmos$2
Xnmos$2_959 WL_30 VSS SL_6N a_n72108_n11898# nmos$2
Xnmos$2_948 a_n73617_n11898# VSS a_n73156_n11829# SL_5N nmos$2
Xpmos_16 a_n43512_n29051# VDD a_n43365_n28971# VDD pmos
Xpmos_27 a_n49530_n29051# VDD a_n49383_n28971# VDD pmos
Xpmos_38 a_n45017_n13206# VDD a_n44870_n13126# VDD pmos
Xpmos_49 a_n45017_n9282# VDD a_n44870_n9202# VDD pmos
Xnmos$5_720 VEVAL VSS m1_n64027_22387# VSS nmos$5
Xnmos$5_731 VEVAL VSS m1_n67041_27619# VSS nmos$5
Xnmos$5_742 VEVAL VSS m1_n54999_26311# VSS nmos$5
Xnmos$5_753 VEVAL VSS m1_n35418_2767# VSS nmos$5
Xnmos$5_797 VEVAL VSS m1_n33913_15847# VSS nmos$5
Xnmos$5_786 VEVAL VSS m1_n36927_14539# VSS nmos$5
Xnmos$5_775 VEVAL VSS m1_n33913_9307# VSS nmos$5
Xnmos$5_764 VEVAL VSS m1_n38432_6691# VSS nmos$5
Xpmos_2090 a_n53901_18266# VDD VDD a_n54048_18485# pmos
Xnmos$2_5204 a_n53587_1251# VSS ML_20 m1_n53490_1459# nmos$2
Xnmos$2_5226 a_n58558_1481# VSS a_n58097_1251# SL_15N nmos$2
Xnmos$2_5215 a_n65629_1251# VSS ML_20 m1_n65532_1459# nmos$2
Xpmos_571 a_n81002_n2662# VDD VDD a_n81149_n2742# pmos
Xpmos_560 a_n79497_n3970# VDD VDD a_n79644_n4050# pmos
Xnmos$2_4503 a_n42003_15869# VSS a_n41542_15639# SL_26N nmos$2
Xnmos$2_4514 a_n46369_9110# VSS SL_23 a_n46055_9099# nmos$2
Xnmos$2_5259 WL_20 VSS SL_12N a_n63077_1481# nmos$2
Xnmos$2_5237 a_n65943_1262# VSS SL_10 a_n65629_1251# nmos$2
Xnmos$2_5248 a_n70456_1262# VSS SL_7 a_n70142_1251# nmos$2
Xpmos_582 a_n75122_n1434# VDD a_n74975_n1354# VDD pmos
Xpmos_593 a_n67599_n6666# VDD a_n67452_n6586# VDD pmos
Xnmos$2_4547 WL_6 VSS SL_26N a_n42003_19793# nmos$2
Xnmos$2_4525 a_n40351_18266# VSS SL_27 a_n40037_18255# nmos$2
Xnmos$2_4536 a_n41856_18266# VSS SL_26 a_n41542_18255# nmos$2
Xnmos$2_3813 a_n37024_3867# VSS ML_18 m1_n36927_4075# nmos$2
Xnmos$2_3802 a_n38843_2570# VSS SL_28 a_n38529_2559# nmos$2
Xnmos$2_4558 WL_7 VSS a_n43365_18266# SL_25 nmos$2
Xnmos$2_4569 WL_8 VSS a_n44870_16958# SL_24 nmos$2
Xnmos$2_3846 a_n34471_6713# VSS a_n34010_6483# SL_31N nmos$2
Xnmos$2_3824 a_n37338_6494# VSS SL_29 a_n37024_6483# nmos$2
Xnmos$2_3835 a_n38843_6494# VSS SL_28 a_n38529_6483# nmos$2
Xnmos$2_3868 a_n34471_8021# VSS a_n34010_7791# SL_31N nmos$2
Xnmos$2_3857 a_n35515_6483# VSS ML_16 m1_n35418_6691# nmos$2
Xnmos$2_3879 a_n35829_3878# VSS SL_30 a_n35515_3867# nmos$2
Xnmos$2_701 a_n37024_n5289# VSS ML_25 m1_n36927_n5081# nmos$2
Xnmos$2_712 a_n38843_n3970# VSS SL_28 a_n38529_n3981# nmos$2
Xnmos$2_734 a_n38843_n46# VSS SL_28 a_n38529_n57# nmos$2
Xnmos$2_745 a_n35515_n1365# VSS ML_22 m1_n35418_n1157# nmos$2
Xnmos$2_723 WL_22 VSS a_n37338_n1354# SL_29 nmos$2
Xnmos$2_767 a_n37338_n2662# VSS SL_29 a_n37024_n2673# nmos$2
Xnmos$2_778 WL_23 VSS SL_28N a_n38990_n2742# nmos$2
Xnmos$2_789 a_n35976_n6666# VSS a_n35515_n6597# SL_30N nmos$2
Xnmos$2_756 WL_25 VSS a_n35829_n5278# SL_30 nmos$2
Xpmos$1_113 OUTP VDD m1_n26796_28434# a_n26151_28422# pmos$1
Xpmos$1_102 a_n28089_25052# VDD a_n26151_25546# a_n27618_25546# pmos$1
Xpmos$1_124 a_n28089_606# VDD a_n26151_1100# a_n27618_1100# pmos$1
Xnmos$5_561 VEVAL VSS m1_n77577_15847# VSS nmos$5
Xnmos$5_550 VEVAL VSS m1_n79086_13231# VSS nmos$5
Xnmos$5_572 VEVAL VSS m1_n73059_10615# VSS nmos$5
Xnmos$5_594 VEVAL VSS m1_n71550_18463# VSS nmos$5
Xnmos$5_583 VEVAL VSS m1_n68546_13231# VSS nmos$5
Xnmos$1_13 a_n28089_n9460# VSS a_n27274_n8966# m1_n28364_n9043# nmos$1
Xnmos$1_57 a_n28089_6358# VSS a_n27274_6852# m1_n28364_6775# nmos$1
Xnmos$1_46 OUTP VSS a_n26151_3976# a_n27618_3976# nmos$1
Xnmos$1_35 a_n28089_n2270# VSS a_n27274_n1776# m1_n28364_n1853# nmos$1
Xnmos$1_24 a_n28089_n6584# VSS a_n27274_n6090# m1_n28364_n6167# nmos$1
Xnmos$1_79 OUTP VSS m1_n27919_14054# a_n27274_14042# nmos$1
Xnmos$1_68 OUTP VSS m1_n27919_12616# a_n27274_12604# nmos$1
Xpmos$3_3 PC VDD ML_29 VDD pmos$3
Xnmos_507 a_n67452_7802# VSS a_n67599_8021# VSS nmos
Xnmos_518 a_n61425_9110# VSS a_n61572_9329# VSS nmos
Xnmos_529 a_n67452_9110# VSS a_n67599_9329# VSS nmos
Xnmos$2_3109 a_n77674_19563# VSS ML_6 m1_n77577_19771# nmos$2
Xnmos$2_2408 WL_9 VSS a_n55410_15650# SL_17 nmos$2
Xnmos$2_2419 a_n55096_14331# VSS ML_10 m1_n54999_14539# nmos$2
Xnmos$3_509 a_n76630_2789# VSS VSS a_n76483_2570# nmos$3
Xnmos$2_1707 a_n64438_n46# VSS SL_11 a_n64124_n57# nmos$2
Xnmos$2_1718 a_n63077_n1434# VSS a_n62616_n1365# SL_12N nmos$2
Xnmos$2_1729 a_n61111_n57# VSS ML_21 m1_n61014_151# nmos$2
Xnmos$2_5001 WL_4 VSS SL_29N a_n37485_22409# nmos$2
Xnmos$2_5023 a_n37485_23717# VSS a_n37024_23487# SL_29N nmos$2
Xnmos$2_5034 a_n35976_21101# VSS a_n35515_20871# SL_30N nmos$2
Xnmos$2_5012 a_n38990_22409# VSS a_n38529_22179# SL_28N nmos$2
Xnmos$2_5067 WL_2 VSS SL_30N a_n35976_25025# nmos$2
Xnmos$2_5045 a_n34010_23487# VSS ML_3 m1_n33913_23695# nmos$2
Xnmos$2_5056 a_n35829_18266# VSS SL_30 a_n35515_18255# nmos$2
Xnmos$2_4322 a_n52082_15639# VSS ML_9 m1_n51985_15847# nmos$2
Xnmos$2_4300 a_n51035_14561# VSS a_n50574_14331# SL_20N nmos$2
Xnmos$2_4311 WL_11 VSS SL_18N a_n54048_13253# nmos$2
Xpmos_390 a_n26151_n338# VDD VDD a_n26495_n338# pmos
Xnmos$2_5078 a_n34324_26114# VSS SL_31 a_n34010_26103# nmos$2
Xnmos$2_5089 WL_2 VSS a_n38843_24806# SL_28 nmos$2
Xnmos$2_3621 a_n64585_22409# VSS a_n64124_22179# SL_11N nmos$2
Xnmos$2_3610 a_n61111_20871# VSS ML_5 m1_n61014_21079# nmos$2
Xnmos$2_4366 a_n48021_15869# VSS a_n47560_15639# SL_22N nmos$2
Xnmos$2_4333 WL_9 VSS SL_19N a_n52543_15869# nmos$2
Xnmos$2_4344 a_n48021_13253# VSS a_n47560_13023# SL_22N nmos$2
Xnmos$2_4355 a_n49530_13253# VSS a_n49069_13023# SL_21N nmos$2
Xnmos$2_3654 a_n62616_27411# VSS ML_0 m1_n62519_27619# nmos$2
Xnmos$2_3643 a_n61425_24806# VSS SL_13 a_n61111_24795# nmos$2
Xnmos$2_3632 a_n62930_23498# VSS SL_12 a_n62616_23487# nmos$2
Xnmos$2_4399 a_n40498_11945# VSS a_n40037_11715# SL_27N nmos$2
Xnmos$2_4377 WL_14 VSS SL_26N a_n42003_9329# nmos$2
Xnmos$2_4388 WL_14 VSS a_n41856_9110# SL_26 nmos$2
Xnmos$2_3665 WL_0 VSS SL_12N a_n63077_27641# nmos$2
Xnmos$2_3676 a_n64585_26333# VSS a_n64124_26103# SL_11N nmos$2
Xnmos$2_3687 a_n67599_25025# VSS a_n67138_24795# SL_9N nmos$2
Xnmos$2_2931 WL_9 VSS SL_7N a_n70603_15869# nmos$2
Xnmos$2_2942 WL_11 VSS a_n68957_13034# SL_8 nmos$2
Xnmos$2_2920 a_n70142_13023# VSS ML_11 m1_n70045_13231# nmos$2
Xnmos$2_520 a_n46516_n2742# VSS a_n46055_n2673# SL_23N nmos$2
Xnmos$2_3698 WL_1 VSS SL_10N a_n66090_26333# nmos$2
Xnmos$2_2975 a_n69104_19793# VSS a_n68643_19563# SL_8N nmos$2
Xnmos$2_2986 WL_7 VSS a_n71961_18266# SL_6 nmos$2
Xnmos$2_2953 a_n69104_17177# VSS a_n68643_16947# SL_8N nmos$2
Xnmos$2_2964 a_n70603_17177# VSS a_n70142_16947# SL_7N nmos$2
Xnmos$2_531 a_n46369_n46# VSS SL_23 a_n46055_n57# nmos$2
Xnmos$2_542 WL_26 VSS SL_27N a_n40498_n6666# nmos$2
Xnmos$2_553 a_n46369_n5278# VSS SL_23 a_n46055_n5289# nmos$2
Xnmos$2_2997 a_n75122_18485# VSS a_n74661_18255# SL_4N nmos$2
Xnmos$2_586 a_n34010_n13137# VSS ML_31 m1_n33913_n12929# nmos$2
Xnmos$2_597 a_n35976_n11898# VSS a_n35515_n11829# SL_30N nmos$2
Xnmos$2_575 a_n49069_n6597# VSS ML_26 m1_n48972_n6389# nmos$2
Xnmos$2_564 a_n46055_n6597# VSS ML_26 m1_n45958_n6389# nmos$2
Xnmos$5_380 VEVAL VSS m1_n59505_2767# VSS nmos$5
Xnmos$5_391 VEVAL VSS m1_n54999_5383# VSS nmos$5
Xpmos$1_0 OUTP VDD a_n27274_n11842# m1_n28364_n11919# pmos$1
Xnmos_315 a_n79497_n10510# VSS a_n79644_n10590# VSS nmos
Xnmos_304 a_n68957_n6586# VSS a_n69104_n6666# VSS nmos
Xnmos_337 a_n79497_n1354# VSS a_n79644_n1434# VSS nmos
Xnmos_348 a_n77988_n2662# VSS a_n78135_n2742# VSS nmos
Xnmos_326 a_n77988_n6586# VSS a_n78135_n6666# VSS nmos
Xnmos_359 a_n71961_n1354# VSS a_n72108_n1434# VSS nmos
Xnmos$2_2205 a_n65943_9110# VSS SL_10 a_n65629_9099# nmos$2
Xnmos$3_306 a_n58558_n7974# VSS VSS a_n58411_n7894# nmos$3
Xnmos$2_2227 a_n66090_13253# VSS a_n65629_13023# SL_10N nmos$2
Xnmos$2_2238 WL_11 VSS SL_9N a_n67599_13253# nmos$2
Xnmos$2_2216 a_n65629_11715# VSS ML_12 m1_n65532_11923# nmos$2
Xnmos$3_317 a_n63077_n10590# VSS VSS a_n62930_n10510# nmos$3
Xnmos$3_328 a_n66090_n9282# VSS VSS a_n65943_n9202# nmos$3
Xnmos$3_339 a_n61572_n5358# VSS VSS a_n61425_n5278# nmos$3
Xnmos$2_2249 a_n65629_15639# VSS ML_9 m1_n65532_15847# nmos$2
Xnmos$2_1537 WL_31 VSS a_n62930_n13126# SL_12 nmos$2
Xnmos$2_1526 a_n56915_n11818# VSS SL_16 a_n56601_n11829# nmos$2
Xnmos$2_1504 a_n55557_n9282# VSS a_n55096_n9213# SL_17N nmos$2
Xnmos$2_1515 WL_27 VSS a_n55410_n7894# SL_17 nmos$2
Xnmos$2_1548 a_n63077_n11898# VSS a_n62616_n11829# SL_12N nmos$2
Xnmos$2_1559 a_n61425_n10510# VSS SL_13 a_n61111_n10521# nmos$2
Xnmos_1308 a_n50888_1262# VSS a_n51035_1481# VSS nmos
Xnmos_871 a_n26495_8290# VSS VSS COMP16 nmos
Xnmos_860 OUTP VSS a_n28089_6358# VSS nmos
Xnmos$2_4130 a_n49069_3867# VSS ML_18 m1_n48972_4075# nmos$2
Xnmos$2_4141 WL_19 VSS SL_20N a_n51035_2789# nmos$2
Xnmos_893 a_n34324_7802# VSS a_n34471_8021# VSS nmos
Xnmos_882 a_n37338_5186# VSS a_n37485_5405# VSS nmos
Xnmos$2_4163 a_n50888_5186# VSS SL_20 a_n50574_5175# nmos$2
Xnmos$2_4174 WL_17 VSS SL_18N a_n54048_5405# nmos$2
Xnmos$2_4152 WL_18 VSS SL_20N a_n51035_4097# nmos$2
Xnmos$2_3462 a_n58411_23498# VSS SL_15 a_n58097_23487# nmos$2
Xnmos$2_3440 a_n58097_22179# VSS ML_4 m1_n58000_22387# nmos$2
Xnmos$2_3451 a_n59602_22179# VSS ML_4 m1_n59505_22387# nmos$2
Xnmos$2_4196 a_n52543_8021# VSS a_n52082_7791# SL_19N nmos$2
Xnmos$2_4185 WL_15 VSS a_n52396_7802# SL_19 nmos$2
Xnmos$2_3495 a_n55096_23487# VSS ML_3 m1_n54999_23695# nmos$2
Xnmos$2_3473 WL_4 VSS SL_17N a_n55557_22409# nmos$2
Xnmos$2_3484 a_n55410_22190# VSS SL_17 a_n55096_22179# nmos$2
Xnmos$2_2761 a_n77988_15650# VSS SL_2 a_n77674_15639# nmos$2
Xnmos$2_2750 WL_10 VSS a_n81002_14342# SL_0 nmos$2
Xnmos$3_862 a_n51035_10637# VSS VSS a_n50888_10418# nmos$3
Xnmos$3_851 a_n48021_8021# VSS VSS a_n47874_7802# nmos$3
Xnmos$3_840 a_n52543_6713# VSS VSS a_n52396_6494# nmos$3
Xnmos$3_873 a_n51035_15869# VSS VSS a_n50888_15650# nmos$3
Xnmos$2_2794 WL_9 VSS a_n74975_15650# SL_4 nmos$2
Xnmos$3_895 a_n43512_13253# VSS VSS a_n43365_13034# nmos$3
Xnmos$2_2772 a_n74975_13034# VSS SL_4 a_n74661_13023# nmos$2
Xnmos$2_2783 a_n77674_13023# VSS ML_11 m1_n77577_13231# nmos$2
Xnmos$3_884 a_n40498_9329# VSS VSS a_n40351_9110# nmos$3
Xnmos$2_361 WL_21 VSS a_n50888_n46# SL_20 nmos$2
Xnmos$2_372 a_n48021_n1434# VSS a_n47560_n1365# SL_22N nmos$2
Xnmos$2_350 WL_22 VSS a_n52396_n1354# SL_19 nmos$2
Xnmos$2_383 a_n47560_n57# VSS ML_21 m1_n47463_151# nmos$2
Xnmos$2_394 WL_23 VSS SL_20N a_n51035_n2742# nmos$2
Xpmos_1900 a_n49383_7802# VDD VDD a_n49530_8021# pmos
Xpmos_1911 a_n50888_6494# VDD VDD a_n51035_6713# pmos
Xpmos_1944 a_n53901_15650# VDD VDD a_n54048_15869# pmos
Xpmos_1955 a_n49530_13253# VDD a_n49383_13034# VDD pmos
Xpmos_1933 a_n52543_11945# VDD a_n52396_11726# VDD pmos
Xpmos_1922 a_n49383_10418# VDD VDD a_n49530_10637# pmos
Xpmos_1966 a_n48021_15869# VDD a_n47874_15650# VDD pmos
Xpmos_1977 a_n43365_11726# VDD VDD a_n43512_11945# pmos
Xpmos_1988 a_n46369_9110# VDD VDD a_n46516_9329# pmos
Xpmos_1999 a_n45017_13253# VDD a_n44870_13034# VDD pmos
Xnmos_14 a_n52396_n28971# VSS a_n52543_n29051# VSS nmos
Xnmos_25 a_n44870_n10510# VSS a_n45017_n10590# VSS nmos
Xnmos_47 a_n53901_n10510# VSS a_n54048_n10590# VSS nmos
Xnmos_58 a_n49383_n9202# VSS a_n49530_n9282# VSS nmos
Xnmos_36 a_n43365_n7894# VSS a_n43512_n7974# VSS nmos
Xnmos_69 a_n47874_n5278# VSS a_n48021_n5358# VSS nmos
Xnmos_112 a_n41856_n2662# VSS a_n42003_n2742# VSS nmos
Xnmos_123 a_n27274_n11842# VSS a_n27618_n11842# VSS nmos
Xnmos_101 a_n44870_n3970# VSS a_n45017_n4050# VSS nmos
Xnmos_156 a_n35829_n11818# VSS a_n35976_n11898# VSS nmos
Xnmos_134 m2_n30953_n9084# VSS VSS m1_n28364_n11919# nmos
Xnmos_145 a_n27618_n8966# VSS m1_n27919_n8954# VSS nmos
Xnmos_167 a_n38843_n7894# VSS a_n38990_n7974# VSS nmos
Xnmos_189 a_n34324_n1354# VSS a_n34471_n1434# VSS nmos
Xnmos_178 a_n35829_n5278# VSS a_n35976_n5358# VSS nmos
Xnmos$2_2002 a_n53901_5186# VSS SL_18 a_n53587_5175# nmos$2
Xnmos$2_2013 a_n57062_5405# VSS a_n56601_5175# SL_16N nmos$2
Xnmos$3_103 a_n43512_173# VSS VSS a_n43365_n46# nmos$3
Xnmos$3_114 a_n34471_n11898# VSS VSS a_n34324_n11818# nmos$3
Xnmos$2_2024 WL_15 VSS a_n53901_7802# SL_18 nmos$2
Xnmos$2_2046 a_n62930_3878# VSS SL_12 a_n62616_3867# nmos$2
Xnmos$2_2035 WL_19 VSS a_n61425_2570# SL_13 nmos$2
Xnmos$3_147 a_n38990_173# VSS VSS a_n38843_n46# nmos$3
Xnmos$2_1312 a_n71647_n57# VSS ML_21 m1_n71550_151# nmos$2
Xnmos$2_1301 a_n73156_n1365# VSS ML_22 m1_n73059_n1157# nmos$2
Xnmos$3_125 a_n37485_n9282# VSS VSS a_n37338_n9202# nmos$3
Xnmos$3_136 a_n34471_n5358# VSS VSS a_n34324_n5278# nmos$3
Xnmos$2_2057 WL_18 VSS SL_12N a_n63077_4097# nmos$2
Xnmos$2_2079 a_n65629_3867# VSS ML_18 m1_n65532_4075# nmos$2
Xnmos$2_2068 a_n65943_2570# VSS SL_10 a_n65629_2559# nmos$2
Xnmos$2_1334 a_n70456_n46# VSS SL_7 a_n70142_n57# nmos$2
Xnmos$2_1323 a_n69104_n1434# VSS a_n68643_n1365# SL_8N nmos$2
Xnmos$2_1345 WL_23 VSS a_n68957_n2662# SL_8 nmos$2
Xnmos$3_169 a_n67599_n29051# VSS VSS a_n67452_n28971# nmos$3
Xnmos$3_158 a_n55557_n29051# VSS VSS a_n55410_n28971# nmos$3
Xnmos$2_1356 WL_23 VSS a_n73470_n2662# SL_5 nmos$2
Xnmos$2_1367 WL_26 VSS a_n76483_n6586# SL_3 nmos$2
Xnmos$2_1378 a_n73617_n6666# VSS a_n73156_n6597# SL_5N nmos$2
Xnmos$2_1389 a_n79183_n6597# VSS ML_26 m1_n79086_n6389# nmos$2
Xpmos_1207 a_n78135_13253# VDD a_n77988_13034# VDD pmos
Xpmos_1229 a_n76483_15650# VDD VDD a_n76630_15869# pmos
Xpmos_1218 a_n81149_14561# VDD a_n81002_14342# VDD pmos
Xnmos_1116 a_n49383_26114# VSS a_n49530_26333# VSS nmos
Xnmos_1127 a_n50888_24806# VSS a_n51035_25025# VSS nmos
Xnmos_1105 a_n49383_23498# VSS a_n49530_23717# VSS nmos
Xnmos_1138 a_n46369_27422# VSS a_n46516_27641# VSS nmos
Xnmos_1149 a_n28485_17016# VSS VSS m1_n28364_16841# nmos
Xnmos_690 a_n74975_23498# VSS a_n75122_23717# VSS nmos
Xnmos$2_3270 a_n81002_27422# VSS SL_0 a_n80688_27411# nmos$2
Xnmos$2_3281 WL_0 VSS a_n79497_27422# SL_1 nmos$2
Xnmos$2_3292 a_n79497_26114# VSS SL_1 a_n79183_26103# nmos$2
Xnmos$3_670 a_n70603_25025# VSS VSS a_n70456_24806# nmos$3
Xnmos$3_681 a_n73617_27641# VSS VSS a_n73470_27422# nmos$3
Xnmos$3_692 a_n60063_18485# VSS VSS a_n59916_18266# nmos$3
Xnmos$2_2580 a_n81002_3878# VSS SL_0 a_n80688_3867# nmos$2
Xnmos$2_2591 WL_19 VSS a_n79497_2570# SL_1 nmos$2
Xpmos_1 a_n37485_n29051# VDD a_n37338_n28971# VDD pmos
Xnmos$2_180 a_n42003_n7974# VSS a_n41542_n7905# SL_26N nmos$2
Xnmos$2_191 a_n49069_n13137# VSS ML_31 m1_n48972_n12929# nmos$2
Xnmos$2_1890 a_n58558_n6666# VSS a_n58097_n6597# SL_15N nmos$2
Xpmos_1730 a_n38843_11726# VDD VDD a_n38990_11945# pmos
Xpmos_1763 a_n34324_14342# VDD VDD a_n34471_14561# pmos
Xpmos_1752 a_n35976_14561# VDD a_n35829_14342# VDD pmos
Xpmos_1741 a_n37338_13034# VDD VDD a_n37485_13253# pmos
Xpmos_901 a_n56915_7802# VDD VDD a_n57062_8021# pmos
Xpmos_912 a_n61572_4097# VDD a_n61425_3878# VDD pmos
Xpmos_1785 a_n26495_15480# VDD COMP11 VDD pmos
Xpmos_1796 a_n27274_15480# VDD VDD a_n27618_15480# pmos
Xpmos_1774 a_n26495_11166# VDD COMP14 VDD pmos
Xpmos_945 a_n64438_5186# VDD VDD a_n64585_5405# pmos
Xpmos_934 a_n67452_5186# VDD VDD a_n67599_5405# pmos
Xpmos_923 a_n66090_1481# VDD a_n65943_1262# VDD pmos
Xpmos_978 a_n67452_13034# VDD VDD a_n67599_13253# pmos
Xpmos_956 a_n63077_11945# VDD a_n62930_11726# VDD pmos
Xpmos_967 a_n67452_9110# VDD VDD a_n67599_9329# pmos
Xpmos_989 a_n63077_13253# VDD a_n62930_13034# VDD pmos
Xnmos$4_0 a_n31183_n28668# VSS OUTP VSS nmos$4
Xnmos$5_902 VEVAL VSS m1_n42954_14539# VSS nmos$5
Xnmos$5_924 VEVAL VSS m1_n39940_21079# VSS nmos$5
Xnmos$5_946 VEVAL VSS m1_n51985_19771# VSS nmos$5
Xnmos$5_913 VEVAL VSS m1_n44459_18463# VSS nmos$5
Xnmos$5_935 VEVAL VSS m1_n42954_17155# VSS nmos$5
Xnmos$5_968 VEVAL VSS m1_n51985_27619# VSS nmos$5
Xnmos$5_979 VEVAL VSS m1_n45958_25003# VSS nmos$5
Xnmos$5_957 VEVAL VSS m1_n48972_22387# VSS nmos$5
Xnmos$2_1120 WL_28 VSS SL_2N a_n78135_n9282# nmos$2
Xnmos$2_1131 a_n74975_n7894# VSS SL_4 a_n74661_n7905# nmos$2
Xnmos$2_1142 a_n76169_n5289# VSS ML_25 m1_n76072_n5081# nmos$2
Xnmos$2_1153 a_n74661_n3981# VSS ML_24 m1_n74564_n3773# nmos$2
Xnmos$2_1186 a_n81002_n1354# VSS SL_0 a_n80688_n1365# nmos$2
Xnmos$2_1164 a_n80688_n5289# VSS ML_25 m1_n80591_n5081# nmos$2
Xnmos$2_1175 a_n79183_n3981# VSS ML_24 m1_n79086_n3773# nmos$2
Xnmos$2_1197 a_n77988_n46# VSS SL_2 a_n77674_n57# nmos$2
Xpmos_1004 a_n55557_11945# VDD a_n55410_11726# VDD pmos
Xpmos_1015 a_n59916_9110# VDD VDD a_n60063_9329# pmos
Xpmos_1048 a_n54048_15869# VDD a_n53901_15650# VDD pmos
Xpmos_1037 a_n57062_14561# VDD a_n56915_14342# VDD pmos
Xpmos_1026 a_n58411_10418# VDD VDD a_n58558_10637# pmos
Xpmos_1059 a_n61425_10418# VDD VDD a_n61572_10637# pmos
Xpmos_219 a_n43365_n1354# VDD VDD a_n43512_n1434# pmos
Xpmos_208 a_n46369_n2662# VDD VDD a_n46516_n2742# pmos
Xpmos_2283 a_n35976_25025# VDD a_n35829_24806# VDD pmos
Xpmos_2272 a_n34324_23498# VDD VDD a_n34471_23717# pmos
Xpmos_2261 a_n37485_22409# VDD a_n37338_22190# VDD pmos
Xpmos_2250 a_n35976_21101# VDD a_n35829_20882# VDD pmos
Xpmos_1571 a_n63077_26333# VDD a_n62930_26114# VDD pmos
Xpmos_2294 a_n37485_25025# VDD a_n37338_24806# VDD pmos
Xpmos_1560 a_n63077_23717# VDD a_n62930_23498# VDD pmos
Xpmos_720 a_n66090_n9282# VDD a_n65943_n9202# VDD pmos
Xpmos_1593 a_n55557_25025# VDD a_n55410_24806# VDD pmos
Xpmos_1582 a_n66090_25025# VDD a_n65943_24806# VDD pmos
Xpmos_731 a_n64438_n7894# VDD VDD a_n64585_n7974# pmos
Xpmos_753 a_n66090_n5358# VDD a_n65943_n5278# VDD pmos
Xpmos_742 a_n64438_n5278# VDD VDD a_n64585_n5358# pmos
Xpmos_775 a_n64438_n1354# VDD VDD a_n64585_n1434# pmos
Xpmos_764 a_n64585_n1434# VDD a_n64438_n1354# VDD pmos
Xpmos_786 a_n54048_n5358# VDD a_n53901_n5278# VDD pmos
Xnmos$2_4729 a_n50574_20871# VSS ML_5 m1_n50477_21079# nmos$2
Xnmos$2_4707 a_n52082_18255# VSS ML_7 m1_n51985_18463# nmos$2
Xnmos$2_4718 a_n52543_17177# VSS a_n52082_16947# SL_19N nmos$2
Xpmos_797 a_n57062_n5358# VDD a_n56915_n5278# VDD pmos
Xnmos$5_209 VEVAL VSS m1_n80591_n11621# VSS nmos$5
Xnmos$2_927 a_n68643_n11829# VSS ML_30 m1_n68546_n11621# nmos$2
Xnmos$2_905 WL_31 VSS a_n70456_n13126# SL_7 nmos$2
Xnmos$2_938 a_n73470_n13126# VSS SL_5 a_n73156_n13137# nmos$2
Xnmos$2_916 a_n70142_n10521# VSS ML_29 m1_n70045_n10313# nmos$2
Xnmos$2_949 a_n73156_n11829# VSS ML_30 m1_n73059_n11621# nmos$2
Xpmos_17 a_n43365_n28971# VDD VDD a_n43512_n29051# pmos
Xpmos_28 a_n41856_n13126# VDD VDD a_n42003_n13206# pmos
Xpmos_39 a_n46369_n13126# VDD VDD a_n46516_n13206# pmos
Xnmos$5_710 VEVAL VSS m1_n65532_23695# VSS nmos$5
Xnmos$5_721 VEVAL VSS m1_n64027_21079# VSS nmos$5
Xnmos$5_732 VEVAL VSS m1_n65532_27619# VSS nmos$5
Xnmos$5_743 VEVAL VSS m1_n56504_26311# VSS nmos$5
Xnmos$5_754 VEVAL VSS m1_n35418_4075# VSS nmos$5
Xnmos$5_787 VEVAL VSS m1_n36927_13231# VSS nmos$5
Xnmos$5_776 VEVAL VSS m1_n35418_10615# VSS nmos$5
Xnmos$5_765 VEVAL VSS m1_n38432_5383# VSS nmos$5
Xnmos$5_798 VEVAL VSS m1_n39940_1459# VSS nmos$5
Xpmos_2080 a_n47874_19574# VDD VDD a_n48021_19793# pmos
Xpmos_2091 a_n52543_18485# VDD a_n52396_18266# VDD pmos
Xpmos_1390 a_n78135_23717# VDD a_n77988_23498# VDD pmos
Xnmos$2_5205 WL_20 VSS a_n53901_1262# SL_18 nmos$2
Xnmos$2_5216 a_n66090_1481# VSS a_n65629_1251# SL_10N nmos$2
Xpmos_550 a_n78135_n5358# VDD a_n77988_n5278# VDD pmos
Xpmos_561 a_n78135_n4050# VDD a_n77988_n3970# VDD pmos
Xnmos$2_4504 a_n42003_14561# VSS a_n41542_14331# SL_26N nmos$2
Xnmos$2_4515 a_n46369_10418# VSS SL_23 a_n46055_10407# nmos$2
Xnmos$2_5227 WL_20 VSS SL_15N a_n58558_1481# nmos$2
Xnmos$2_5249 WL_20 VSS a_n70456_1262# SL_7 nmos$2
Xnmos$2_5238 a_n73470_1262# VSS SL_5 a_n73156_1251# nmos$2
Xpmos_583 a_n76483_n1354# VDD VDD a_n76630_n1434# pmos
Xpmos_572 a_n81002_n1354# VDD VDD a_n81149_n1434# pmos
Xpmos_594 a_n68957_n5278# VDD VDD a_n69104_n5358# pmos
Xnmos$2_4548 a_n40498_19793# VSS a_n40037_19563# SL_27N nmos$2
Xnmos$2_4537 WL_7 VSS a_n41856_18266# SL_26 nmos$2
Xnmos$2_4526 a_n40498_17177# VSS a_n40037_16947# SL_27N nmos$2
Xnmos$2_3803 a_n38529_2559# VSS ML_19 m1_n38432_2767# nmos$2
Xnmos$2_4559 a_n45017_18485# VSS a_n44556_18255# m2_n44135_352# nmos$2
Xnmos$2_3836 WL_15 VSS a_n38843_7802# SL_28 nmos$2
Xnmos$2_3825 a_n37485_6713# VSS a_n37024_6483# SL_29N nmos$2
Xnmos$2_3814 a_n37485_4097# VSS a_n37024_3867# SL_29N nmos$2
Xnmos$2_3869 a_n34010_7791# VSS ML_15 m1_n33913_7999# nmos$2
Xnmos$2_3847 a_n34471_5405# VSS a_n34010_5175# SL_31N nmos$2
Xnmos$2_3858 a_n34324_5186# VSS SL_31 a_n34010_5175# nmos$2
Xnmos$2_702 a_n37485_n5358# VSS a_n37024_n5289# SL_29N nmos$2
Xnmos$2_735 a_n37024_n57# VSS ML_21 m1_n36927_151# nmos$2
Xnmos$2_746 a_n35976_n1434# VSS a_n35515_n1365# SL_30N nmos$2
Xnmos$2_724 a_n37024_n1365# VSS ML_22 m1_n36927_n1157# nmos$2
Xnmos$2_713 a_n38990_n4050# VSS a_n38529_n3981# SL_28N nmos$2
Xnmos$2_768 a_n35829_n1354# VSS SL_30 a_n35515_n1365# nmos$2
Xnmos$2_779 a_n34010_n2673# VSS ML_23 m1_n33913_n2465# nmos$2
Xnmos$2_757 a_n35829_n5278# VSS SL_30 a_n35515_n5289# nmos$2
Xpmos$1_114 OUTP VDD a_n27274_28422# m1_n28364_28345# pmos$1
Xpmos$1_103 a_n28089_26490# VDD m1_n27919_26996# a_n27274_26984# pmos$1
Xpmos$1_125 OUTP VDD m1_n26796_1112# a_n26151_1100# pmos$1
Xnmos$5_562 VEVAL VSS m1_n76072_15847# VSS nmos$5
Xnmos$5_551 VEVAL VSS m1_n80591_13231# VSS nmos$5
Xnmos$5_540 VEVAL VSS m1_n77577_11923# VSS nmos$5
Xnmos$5_595 VEVAL VSS m1_n71550_17155# VSS nmos$5
Xnmos$5_584 VEVAL VSS m1_n70045_13231# VSS nmos$5
Xnmos$5_573 VEVAL VSS m1_n73059_9307# VSS nmos$5
Xnmos$1_14 a_n28089_n8022# VSS m1_n26796_n7516# a_n26151_n7528# nmos$1
Xnmos$1_47 a_n28089_2044# VSS a_n27274_2538# m1_n28364_2461# nmos$1
Xnmos$1_36 OUTP VSS m1_n27919_n326# a_n27274_n338# nmos$1
Xnmos$1_25 OUTP VSS m1_n27919_n6078# a_n27274_n6090# nmos$1
Xnmos$1_69 a_n28089_12110# VSS a_n27274_12604# m1_n28364_12527# nmos$1
Xnmos$1_58 OUTP VSS m1_n27919_6864# a_n27274_6852# nmos$1
Xpmos$3_4 PC VDD ML_27 VDD pmos$3
Xnmos_519 a_n62930_10418# VSS a_n63077_10637# VSS nmos
Xnmos_508 a_n65943_7802# VSS a_n66090_8021# VSS nmos
Xnmos$2_2409 a_n55410_15650# VSS SL_17 a_n55096_15639# nmos$2
Xpmos$3_30 PC VDD ML_1 VDD pmos$3
Xnmos$2_1708 a_n64124_n57# VSS ML_21 m1_n64027_151# nmos$2
Xnmos$2_1719 WL_22 VSS a_n62930_n1354# SL_12 nmos$2
Xnmos$2_5024 a_n34471_22409# VSS a_n34010_22179# SL_31N nmos$2
Xnmos$2_5002 a_n37024_22179# VSS ML_4 m1_n36927_22387# nmos$2
Xnmos$2_5013 a_n38843_22190# VSS SL_28 a_n38529_22179# nmos$2
Xnmos$2_5068 WL_0 VSS a_n34324_27422# SL_31 nmos$2
Xnmos$2_5046 a_n34471_23717# VSS a_n34010_23487# SL_31N nmos$2
Xnmos$2_5035 WL_5 VSS SL_30N a_n35976_21101# nmos$2
Xnmos$2_5057 WL_6 VSS a_n35829_19574# SL_30 nmos$2
Xnmos$2_4323 WL_9 VSS a_n52396_15650# SL_19 nmos$2
Xnmos$2_4301 WL_10 VSS a_n50888_14342# SL_20 nmos$2
Xnmos$2_4312 WL_11 VSS a_n52396_13034# SL_19 nmos$2
Xpmos_391 a_n26495_n338# VDD COMP22 VDD pmos
Xpmos_380 a_n26495_n1776# VDD VDD m1_n26796_n1764# pmos
Xnmos$2_5079 a_n35976_26333# VSS a_n35515_26103# SL_30N nmos$2
Xnmos$2_3600 a_n64124_23487# VSS ML_3 m1_n64027_23695# nmos$2
Xnmos$2_3611 a_n61572_22409# VSS a_n61111_22179# SL_13N nmos$2
Xnmos$2_4334 a_n52543_15869# VSS a_n52082_15639# SL_19N nmos$2
Xnmos$2_4345 a_n48021_14561# VSS a_n47560_14331# SL_22N nmos$2
Xnmos$2_4356 a_n49069_13023# VSS ML_11 m1_n48972_13231# nmos$2
Xnmos$2_3655 a_n62930_27422# VSS SL_12 a_n62616_27411# nmos$2
Xnmos$2_3644 a_n61111_24795# VSS ML_2 m1_n61014_25003# nmos$2
Xnmos$2_3633 WL_3 VSS a_n62930_23498# SL_12 nmos$2
Xnmos$2_3622 a_n62616_22179# VSS ML_4 m1_n62519_22387# nmos$2
Xnmos$2_4367 a_n47560_15639# VSS ML_9 m1_n47463_15847# nmos$2
Xnmos$2_2910 WL_11 VSS SL_8N a_n69104_13253# nmos$2
Xnmos$2_4378 a_n40351_10418# VSS SL_27 a_n40037_10407# nmos$2
Xnmos$2_4389 WL_13 VSS a_n41856_10418# SL_26 nmos$2
Xnmos$2_3688 WL_0 VSS a_n65943_27422# SL_10 nmos$2
Xnmos$2_3677 WL_1 VSS SL_11N a_n64585_26333# nmos$2
Xnmos$2_3666 WL_2 VSS SL_12N a_n63077_25025# nmos$2
Xnmos$2_2943 a_n68643_16947# VSS ML_8 m1_n68546_17155# nmos$2
Xnmos$2_2932 WL_9 VSS a_n70456_15650# SL_7 nmos$2
Xnmos$2_2921 WL_11 VSS a_n70456_13034# SL_7 nmos$2
Xnmos$2_510 a_n42003_n2742# VSS a_n41542_n2673# SL_26N nmos$2
Xnmos$2_521 a_n46055_n2673# VSS ML_23 m1_n45958_n2465# nmos$2
Xnmos$2_3699 a_n67138_26103# VSS ML_1 m1_n67041_26311# nmos$2
Xnmos$2_2976 WL_6 VSS a_n68957_19574# SL_8 nmos$2
Xnmos$2_2965 a_n70603_19793# VSS a_n70142_19563# SL_7N nmos$2
Xnmos$2_2954 WL_8 VSS a_n67452_16958# SL_9 nmos$2
Xnmos$2_532 a_n46369_n1354# VSS SL_23 a_n46055_n1365# nmos$2
Xnmos$2_554 a_n46369_n6586# VSS SL_23 a_n46055_n6597# nmos$2
Xnmos$2_543 a_n40037_n6597# VSS ML_26 m1_n39940_n6389# nmos$2
Xnmos$2_2987 WL_7 VSS SL_6N a_n72108_18485# nmos$2
Xnmos$2_2998 a_n73156_18255# VSS ML_7 m1_n73059_18463# nmos$2
Xnmos$2_587 WL_31 VSS SL_30N a_n35976_n13206# nmos$2
Xnmos$2_576 WL_26 VSS a_n46369_n6586# SL_23 nmos$2
Xnmos$2_565 a_n44870_n6586# VSS SL_24 a_n44556_n6597# nmos$2
Xnmos$2_598 a_n35515_n11829# VSS ML_30 m1_n35418_n11621# nmos$2
Xnmos$2_4890 a_n42003_25025# VSS a_n41542_24795# SL_26N nmos$2
Xnmos$5_370 VEVAL VSS m1_n59505_n2465# VSS nmos$5
Xnmos$5_392 VEVAL VSS m1_n56504_5383# VSS nmos$5
Xnmos$5_381 VEVAL VSS m1_n59505_1459# VSS nmos$5
Xpmos$1_1 a_n28089_n12336# VDD a_n26151_n11842# a_n27618_n11842# pmos$1
Xnmos_305 a_n76483_n13126# VSS a_n76630_n13206# VSS nmos
Xnmos_338 a_n81002_n1354# VSS a_n81149_n1434# VSS nmos
Xnmos_316 a_n79497_n11818# VSS a_n79644_n11898# VSS nmos
Xnmos_327 a_n76483_n7894# VSS a_n76630_n7974# VSS nmos
Xnmos_349 a_n68957_n5278# VSS a_n69104_n5358# VSS nmos
Xnmos$2_2239 a_n67599_15869# VSS a_n67138_15639# SL_9N nmos$2
Xnmos$2_2228 WL_11 VSS a_n64438_13034# SL_11 nmos$2
Xnmos$2_2206 WL_12 VSS a_n65943_11726# SL_10 nmos$2
Xnmos$2_2217 a_n65629_9099# VSS ML_14 m1_n65532_9307# nmos$2
Xnmos$3_318 a_n63077_n11898# VSS VSS a_n62930_n11818# nmos$3
Xnmos$3_307 a_n58558_n9282# VSS VSS a_n58411_n9202# nmos$3
Xnmos$3_329 a_n66090_n7974# VSS VSS a_n65943_n7894# nmos$3
Xnmos$2_1527 a_n56915_n13126# VSS SL_16 a_n56601_n13137# nmos$2
Xnmos$2_1505 a_n53901_n9202# VSS SL_18 a_n53587_n9213# nmos$2
Xnmos$2_1516 a_n57062_n7974# VSS a_n56601_n7905# SL_16N nmos$2
Xnmos$2_1538 a_n62930_n13126# VSS SL_12 a_n62616_n13137# nmos$2
Xnmos$2_1549 WL_30 VSS a_n62930_n11818# SL_12 nmos$2
Xnmos$2_90 WL_29 VSS a_n40351_n10510# SL_27 nmos$2
Xnmos_1309 a_n34324_1262# VSS a_n34471_1481# VSS nmos
Xnmos_861 a_n27274_6852# VSS a_n27618_6852# VSS nmos
Xnmos_850 ML_18 VSS VSS a_n28485_5512# nmos
Xnmos$2_4131 WL_18 VSS a_n46369_3878# SL_23 nmos$2
Xnmos$2_4120 a_n47874_2570# VSS SL_22 a_n47560_2559# nmos$2
Xnmos_894 a_n34324_9110# VSS a_n34471_9329# VSS nmos
Xnmos_872 OUTP VSS a_n28089_7796# VSS nmos
Xnmos_883 a_n37338_6494# VSS a_n37485_6713# VSS nmos
Xnmos$2_4164 WL_16 VSS SL_20N a_n51035_6713# nmos$2
Xnmos$2_4153 a_n50574_3867# VSS ML_18 m1_n50477_4075# nmos$2
Xnmos$2_4142 WL_19 VSS a_n52396_2570# SL_19 nmos$2
Xnmos$2_3463 a_n58097_23487# VSS ML_3 m1_n58000_23695# nmos$2
Xnmos$2_3441 WL_5 VSS SL_15N a_n58558_21101# nmos$2
Xnmos$2_3430 WL_6 VSS a_n58411_19574# SL_15 nmos$2
Xnmos$2_3452 WL_5 VSS a_n59916_20882# SL_14 nmos$2
Xnmos$2_4186 a_n50574_7791# VSS ML_15 m1_n50477_7999# nmos$2
Xnmos$2_4197 a_n48021_6713# VSS a_n47560_6483# SL_22N nmos$2
Xnmos$2_4175 a_n54048_6713# VSS a_n53587_6483# SL_18N nmos$2
Xnmos$2_3485 a_n57062_23717# VSS a_n56601_23487# SL_16N nmos$2
Xnmos$2_3474 WL_4 VSS a_n53901_22190# SL_18 nmos$2
Xnmos$2_3496 a_n55096_22179# VSS ML_4 m1_n54999_22387# nmos$2
Xnmos$2_2740 WL_10 VSS a_n77988_14342# SL_2 nmos$2
Xnmos$2_2751 WL_11 VSS SL_0N a_n81149_13253# nmos$2
Xnmos$3_852 a_n48021_5405# VSS VSS a_n47874_5186# nmos$3
Xnmos$3_841 a_n52543_5405# VSS VSS a_n52396_5186# nmos$3
Xnmos$3_830 a_n49530_4097# VSS VSS a_n49383_3878# nmos$3
Xnmos$2_2762 a_n79183_15639# VSS ML_9 m1_n79086_15847# nmos$2
Xnmos$3_874 a_n46516_14561# VSS VSS a_n46369_14342# nmos$3
Xnmos$2_2773 a_n74661_13023# VSS ML_11 m1_n74564_13231# nmos$2
Xnmos$2_2784 WL_11 VSS a_n76483_13034# SL_3 nmos$2
Xnmos$3_885 a_n42003_10637# VSS VSS a_n41856_10418# nmos$3
Xnmos$3_863 a_n51035_9329# VSS VSS a_n50888_9110# nmos$3
Xnmos$2_362 a_n51035_173# VSS a_n50574_n57# SL_20N nmos$2
Xnmos$2_351 a_n54048_n1434# VSS a_n53587_n1365# SL_18N nmos$2
Xnmos$2_340 a_n52543_n4050# VSS a_n52082_n3981# SL_19N nmos$2
Xnmos$2_2795 a_n74975_15650# VSS SL_4 a_n74661_15639# nmos$2
Xnmos$3_896 a_n43512_14561# VSS VSS a_n43365_14342# nmos$3
Xnmos$2_384 WL_21 VSS a_n46369_n46# SL_23 nmos$2
Xnmos$2_373 a_n49383_n1354# VSS SL_21 a_n49069_n1365# nmos$2
Xnmos$2_395 WL_23 VSS a_n50888_n2662# SL_20 nmos$2
Xpmos_1901 a_n49530_8021# VDD a_n49383_7802# VDD pmos
Xpmos_1912 a_n50888_7802# VDD VDD a_n51035_8021# pmos
Xpmos_1945 a_n52543_15869# VDD a_n52396_15650# VDD pmos
Xpmos_1934 a_n52396_11726# VDD VDD a_n52543_11945# pmos
Xpmos_1923 a_n48021_10637# VDD a_n47874_10418# VDD pmos
Xpmos_1956 a_n49383_15650# VDD VDD a_n49530_15869# pmos
Xpmos_1978 a_n42003_11945# VDD a_n41856_11726# VDD pmos
Xpmos_1967 a_n50888_9110# VDD VDD a_n51035_9329# pmos
Xpmos_1989 a_n46369_11726# VDD VDD a_n46516_11945# pmos
Xnmos_15 a_n41856_n13126# VSS a_n42003_n13206# VSS nmos
Xnmos_26 a_n44870_n11818# VSS a_n45017_n11898# VSS nmos
Xnmos_48 a_n53901_n11818# VSS a_n54048_n11898# VSS nmos
Xnmos_59 a_n49383_n7894# VSS a_n49530_n7974# VSS nmos
Xnmos_37 a_n41856_n6586# VSS a_n42003_n6666# VSS nmos
Xnmos_102 a_n44870_n1354# VSS a_n45017_n1434# VSS nmos
Xnmos_113 a_n46369_n2662# VSS a_n46516_n2742# VSS nmos
Xnmos_124 a_n26151_n10404# VSS a_n26495_n10404# VSS nmos
Xnmos_157 a_n34324_n11818# VSS a_n34471_n11898# VSS nmos
Xnmos_135 ML_31 VSS VSS a_n28485_n13182# nmos
Xnmos_146 a_n26495_n7528# VSS VSS COMP27 nmos
Xnmos_168 a_n38843_n6586# VSS a_n38990_n6666# VSS nmos
Xnmos_179 a_n35829_n3970# VSS a_n35976_n4050# VSS nmos
Xnmos$2_2003 a_n55557_6713# VSS a_n55096_6483# SL_17N nmos$2
Xnmos$2_2014 a_n56601_5175# VSS ML_17 m1_n56504_5383# nmos$2
Xnmos$3_104 a_n40498_n1434# VSS VSS a_n40351_n1354# nmos$3
Xnmos$3_115 a_n37485_n13206# VSS VSS a_n37338_n13126# nmos$3
Xnmos$2_2025 a_n53901_7802# VSS SL_18 a_n53587_7791# nmos$2
Xnmos$2_2047 a_n64585_4097# VSS a_n64124_3867# SL_11N nmos$2
Xnmos$2_2036 a_n61425_2570# VSS SL_13 a_n61111_2559# nmos$2
Xnmos$3_148 a_n35976_173# VSS VSS a_n35829_n46# nmos$3
Xnmos$2_1302 a_n73617_n1434# VSS a_n73156_n1365# SL_5N nmos$2
Xnmos$3_126 a_n38990_n9282# VSS VSS a_n38843_n9202# nmos$3
Xnmos$3_137 a_n34471_n4050# VSS VSS a_n34324_n3970# nmos$3
Xnmos$2_2069 a_n67599_4097# VSS a_n67138_3867# SL_9N nmos$2
Xnmos$2_2058 WL_19 VSS SL_12N a_n63077_2789# nmos$2
Xnmos$2_1335 a_n67452_n46# VSS SL_9 a_n67138_n57# nmos$2
Xnmos$2_1313 WL_21 VSS a_n71961_n46# SL_6 nmos$2
Xnmos$2_1324 a_n68643_n1365# VSS ML_22 m1_n68546_n1157# nmos$2
Xnmos$3_159 a_n57062_n29051# VSS VSS a_n56915_n28971# nmos$3
Xnmos$2_1346 a_n67452_n2662# VSS SL_9 a_n67138_n2673# nmos$2
Xnmos$2_1357 a_n73617_n2742# VSS a_n73156_n2673# SL_5N nmos$2
Xnmos$2_1368 a_n76169_n6597# VSS ML_26 m1_n76072_n6389# nmos$2
Xnmos$2_1379 WL_26 VSS a_n73470_n6586# SL_5 nmos$2
Xpmos_1208 a_n79497_13034# VDD VDD a_n79644_13253# pmos
Xpmos_1219 a_n79644_13253# VDD a_n79497_13034# VDD pmos
Xnmos_1117 a_n49383_27422# VSS a_n49530_27641# VSS nmos
Xnmos_1106 a_n47874_23498# VSS a_n48021_23717# VSS nmos
Xnmos_1139 a_n44870_27422# VSS a_n45017_27641# VSS nmos
Xnmos_1128 a_n41856_24806# VSS a_n42003_25025# VSS nmos
Xnmos_680 a_n74975_18266# VSS a_n75122_18485# VSS nmos
Xnmos_691 a_n71961_23498# VSS a_n72108_23717# VSS nmos
Xnmos$2_3271 WL_0 VSS a_n81002_27422# SL_0 nmos$2
Xnmos$2_3260 WL_2 VSS a_n77988_24806# SL_2 nmos$2
Xnmos$2_3282 WL_1 VSS a_n79497_26114# SL_1 nmos$2
Xnmos$2_3293 a_n80688_26103# VSS ML_1 m1_n80591_26311# nmos$2
Xnmos$3_660 a_n78135_25025# VSS VSS a_n77988_24806# nmos$3
Xnmos$3_682 a_n72108_27641# VSS VSS a_n71961_27422# nmos$3
Xnmos$3_671 a_n70603_26333# VSS VSS a_n70456_26114# nmos$3
Xnmos$3_693 a_n60063_19793# VSS VSS a_n59916_19574# nmos$3
Xnmos$2_2592 a_n77988_5186# VSS SL_2 a_n77674_5175# nmos$2
Xnmos$2_2581 a_n81149_4097# VSS a_n80688_3867# SL_0N nmos$2
Xnmos$2_2570 WL_19 VSS SL_1N a_n79644_2789# nmos$2
Xnmos$2_170 a_n41856_n7894# VSS SL_26 a_n41542_n7905# nmos$2
Xnmos$2_192 WL_31 VSS a_n49383_n13126# SL_21 nmos$2
Xpmos_2 a_n37338_n28971# VDD VDD a_n37485_n29051# pmos
Xnmos$2_181 a_n42003_n9282# VSS a_n41542_n9213# SL_26N nmos$2
Xnmos$2_1891 WL_26 VSS SL_15N a_n58558_n6666# nmos$2
Xnmos$2_1880 WL_26 VSS SL_17N a_n55557_n6666# nmos$2
Xpmos_1720 a_n35829_11726# VDD VDD a_n35976_11945# pmos
Xpmos_1753 a_n37338_14342# VDD VDD a_n37485_14561# pmos
Xpmos_1742 a_n38843_13034# VDD VDD a_n38990_13253# pmos
Xpmos_1731 a_n35976_11945# VDD a_n35829_11726# VDD pmos
Xpmos_902 a_n54048_8021# VDD a_n53901_7802# VDD pmos
Xpmos_1797 a_n26495_15480# VDD VDD m1_n26796_15492# pmos
Xpmos_1786 OUTP VDD VDD a_n28089_13548# pmos
Xpmos_1775 OUTP VDD VDD a_n28089_10672# pmos
Xpmos_1764 a_n26495_9728# VDD COMP15 VDD pmos
Xpmos_935 a_n66090_6713# VDD a_n65943_6494# VDD pmos
Xpmos_924 a_n66090_4097# VDD a_n65943_3878# VDD pmos
Xpmos_913 a_n62930_2570# VDD VDD a_n63077_2789# pmos
Xpmos_979 a_n66090_13253# VDD a_n65943_13034# VDD pmos
Xpmos_957 a_n61572_11945# VDD a_n61425_11726# VDD pmos
Xpmos_968 a_n67452_11726# VDD VDD a_n67599_11945# pmos
Xpmos_946 a_n64438_7802# VDD VDD a_n64585_8021# pmos
Xnmos$5_903 VEVAL VSS m1_n42954_11923# VSS nmos$5
Xnmos$5_925 VEVAL VSS m1_n39940_22387# VSS nmos$5
Xnmos$5_914 VEVAL VSS m1_n45958_18463# VSS nmos$5
Xnmos$5_936 VEVAL VSS m1_n47463_18463# VSS nmos$5
Xnmos$5_969 VEVAL VSS m1_n50477_27619# VSS nmos$5
Xnmos$5_958 VEVAL VSS m1_n48972_23695# VSS nmos$5
Xnmos$5_947 VEVAL VSS m1_n50477_19771# VSS nmos$5
Xnmos$2_1110 WL_28 VSS SL_3N a_n76630_n9282# nmos$2
Xnmos$2_1121 a_n78135_n7974# VSS a_n77674_n7905# SL_2N nmos$2
Xnmos$2_1154 a_n79497_n5278# VSS SL_1 a_n79183_n5289# nmos$2
Xnmos$2_1132 a_n74975_n5278# VSS SL_4 a_n74661_n5289# nmos$2
Xnmos$2_1143 a_n77674_n3981# VSS ML_24 m1_n77577_n3773# nmos$2
Xnmos$2_1187 a_n81149_n1434# VSS a_n80688_n1365# SL_0N nmos$2
Xnmos$2_1176 WL_25 VSS a_n79497_n5278# SL_1 nmos$2
Xnmos$2_1165 WL_24 VSS SL_0N a_n81149_n4050# nmos$2
Xnmos$2_1198 a_n79183_n57# VSS ML_21 m1_n79086_151# nmos$2
Xpmos_1005 a_n56915_11726# VDD VDD a_n57062_11945# pmos
Xpmos_1016 a_n59916_11726# VDD VDD a_n60063_11945# pmos
Xpmos_1049 a_n55410_15650# VDD VDD a_n55557_15869# pmos
Xpmos_1038 a_n58411_14342# VDD VDD a_n58558_14561# pmos
Xpmos_1027 a_n57062_13253# VDD a_n56915_13034# VDD pmos
Xpmos_209 a_n45017_n1434# VDD a_n44870_n1354# VDD pmos
Xnmos$2_3090 a_n74661_18255# VSS ML_7 m1_n74564_18463# nmos$2
Xnmos$3_490 a_n73617_2789# VSS VSS a_n73470_2570# nmos$3
Xpmos_2240 a_n38990_19793# VDD a_n38843_19574# VDD pmos
Xpmos_2273 a_n34324_24806# VDD VDD a_n34471_25025# pmos
Xpmos_2262 a_n37485_23717# VDD a_n37338_23498# VDD pmos
Xpmos_2251 a_n38843_20882# VDD VDD a_n38990_21101# pmos
Xpmos_2295 a_n37485_27641# VDD a_n37338_27422# VDD pmos
Xpmos_1572 a_n63077_27641# VDD a_n62930_27422# VDD pmos
Xpmos_2284 a_n38843_24806# VDD VDD a_n38990_25025# pmos
Xpmos_1561 a_n64438_23498# VDD VDD a_n64585_23717# pmos
Xpmos_1550 a_n66090_22409# VDD a_n65943_22190# VDD pmos
Xpmos_710 a_n66090_n11898# VDD a_n65943_n11818# VDD pmos
Xpmos_1583 a_n67452_27422# VDD VDD a_n67599_27641# pmos
Xpmos_1594 a_n56915_24806# VDD VDD a_n57062_25025# pmos
Xpmos_721 a_n67452_n7894# VDD VDD a_n67599_n7974# pmos
Xpmos_732 a_n63077_n7974# VDD a_n62930_n7894# VDD pmos
Xpmos_754 a_n67452_n5278# VDD VDD a_n67599_n5358# pmos
Xpmos_743 a_n64438_n3970# VDD VDD a_n64585_n4050# pmos
Xpmos_765 a_n67452_n1354# VDD VDD a_n67599_n1434# pmos
Xpmos_776 a_n64438_n2662# VDD VDD a_n64585_n2742# pmos
Xpmos_787 a_n55410_n6586# VDD VDD a_n55557_n6666# pmos
Xnmos$2_4708 a_n52082_19563# VSS ML_6 m1_n51985_19771# nmos$2
Xnmos$2_4719 WL_8 VSS SL_19N a_n52543_17177# nmos$2
Xpmos_798 a_n58411_n6586# VDD VDD a_n58558_n6666# pmos
Xnmos$2_928 a_n69104_n11898# VSS a_n68643_n11829# SL_8N nmos$2
Xnmos$2_906 a_n70142_n13137# VSS ML_31 m1_n70045_n12929# nmos$2
Xnmos$2_917 a_n70603_n10590# VSS a_n70142_n10521# SL_7N nmos$2
Xnmos$2_939 WL_31 VSS a_n73470_n13126# SL_5 nmos$2
Xpmos_18 a_n46516_n29051# VDD a_n46369_n28971# VDD pmos
Xpmos_29 a_n40498_n13206# VDD a_n40351_n13126# VDD pmos
Xnmos$5_711 VEVAL VSS m1_n61014_22387# VSS nmos$5
Xnmos$5_700 VEVAL VSS m1_n65532_18463# VSS nmos$5
Xnmos$5_733 VEVAL VSS m1_n67041_26311# VSS nmos$5
Xnmos$5_744 VEVAL VSS m1_n58000_25003# VSS nmos$5
Xnmos$5_722 VEVAL VSS m1_n64027_19771# VSS nmos$5
Xnmos$5_788 VEVAL VSS m1_n38432_14539# VSS nmos$5
Xnmos$5_777 VEVAL VSS m1_n35418_9307# VSS nmos$5
Xnmos$5_766 VEVAL VSS m1_n38432_7999# VSS nmos$5
Xnmos$5_755 VEVAL VSS m1_n33913_4075# VSS nmos$5
Xnmos$5_799 VEVAL VSS m1_n39940_2767# VSS nmos$5
Xpmos_2081 a_n48021_18485# VDD a_n47874_18266# VDD pmos
Xpmos_2070 a_n46516_17177# VDD a_n46369_16958# VDD pmos
Xpmos_2092 a_n51035_18485# VDD a_n50888_18266# VDD pmos
Xpmos_1380 a_n79644_18485# VDD a_n79497_18266# VDD pmos
Xpmos_1391 a_n78135_22409# VDD a_n77988_22190# VDD pmos
Xnmos$2_5206 a_n55096_1251# VSS ML_20 m1_n54999_1459# nmos$2
Xnmos$2_5217 WL_20 VSS a_n58411_1262# SL_15 nmos$2
Xpmos_562 a_n79644_n6666# VDD a_n79497_n6586# VDD pmos
Xpmos_551 a_n78135_n6666# VDD a_n77988_n6586# VDD pmos
Xpmos_540 a_n75122_n5358# VDD a_n74975_n5278# VDD pmos
Xnmos$2_4505 a_n42003_13253# VSS a_n41542_13023# SL_26N nmos$2
Xnmos$2_5228 WL_20 VSS a_n56915_1262# SL_16 nmos$2
Xnmos$2_5239 WL_20 VSS a_n73470_1262# SL_5 nmos$2
Xpmos_573 a_n81149_173# VDD a_n81002_n46# VDD pmos
Xpmos_584 a_n76630_n1434# VDD a_n76483_n1354# VDD pmos
Xpmos_595 a_n67599_n5358# VDD a_n67452_n5278# VDD pmos
Xnmos$2_4527 a_n40351_16958# VSS SL_27 a_n40037_16947# nmos$2
Xnmos$2_4538 a_n41856_16958# VSS SL_26 a_n41542_16947# nmos$2
Xnmos$2_4516 a_n46369_11726# VSS SL_23 a_n46055_11715# nmos$2
Xnmos$2_3804 a_n38990_2789# VSS a_n38529_2559# SL_28N nmos$2
Xnmos$2_4549 WL_6 VSS SL_27N a_n40498_19793# nmos$2
Xnmos$2_3837 a_n38529_7791# VSS ML_15 m1_n38432_7999# nmos$2
Xnmos$2_3826 WL_16 VSS a_n38843_6494# SL_28 nmos$2
Xnmos$2_3815 WL_18 VSS SL_29N a_n37485_4097# nmos$2
Xnmos$2_3848 WL_16 VSS SL_31N a_n34471_6713# nmos$2
Xnmos$2_3859 a_n35976_5405# VSS a_n35515_5175# SL_30N nmos$2
Xnmos$2_703 WL_25 VSS SL_29N a_n37485_n5358# nmos$2
Xnmos$2_736 a_n37485_173# VSS a_n37024_n57# SL_29N nmos$2
Xnmos$2_725 WL_22 VSS SL_28N a_n38990_n1434# nmos$2
Xnmos$2_714 WL_24 VSS SL_28N a_n38990_n4050# nmos$2
Xnmos$2_747 WL_22 VSS a_n34324_n1354# SL_31 nmos$2
Xnmos$2_769 WL_23 VSS SL_30N a_n35976_n2742# nmos$2
Xnmos$2_758 WL_24 VSS a_n35829_n3970# SL_30 nmos$2
Xnmos$5_90 VEVAL VSS m1_n39940_n3773# VSS nmos$5
Xpmos$1_104 OUTP VDD a_n27274_26984# m1_n28364_26907# pmos$1
Xpmos$1_115 a_n28089_30804# VDD a_n26151_31298# a_n27618_31298# pmos$1
Xpmos$1_126 a_n28089_606# VDD m1_n27919_1112# a_n27274_1100# pmos$1
Xnmos$5_563 VEVAL VSS m1_n74564_15847# VSS nmos$5
Xnmos$5_552 VEVAL VSS m1_n80591_14539# VSS nmos$5
Xnmos$5_541 VEVAL VSS m1_n76072_11923# VSS nmos$5
Xnmos$5_530 VEVAL VSS m1_n77577_5383# VSS nmos$5
Xnmos$5_596 VEVAL VSS m1_n73059_18463# VSS nmos$5
Xnmos$5_585 VEVAL VSS m1_n70045_14539# VSS nmos$5
Xnmos$5_574 VEVAL VSS m1_n73059_11923# VSS nmos$5
Xnmos$1_48 OUTP VSS a_n26151_2538# a_n27618_2538# nmos$1
Xnmos$1_37 a_n27990_220# VSS a_n27274_n338# m1_n28364_n415# nmos$1
Xnmos$1_15 a_n28089_n8022# VSS a_n27274_n7528# m1_n28364_n7605# nmos$1
Xnmos$1_26 a_n28089_n5146# VSS a_n27274_n4652# m1_n28364_n4729# nmos$1
Xnmos$1_59 a_n28089_4920# VSS a_n27274_5414# m1_n28364_5337# nmos$1
Xpmos$3_5 PC VDD ML_28 VDD pmos$3
Xnmos_509 a_n61425_6494# VSS a_n61572_6713# VSS nmos
Xpmos$3_20 PC VDD ML_13 VDD pmos$3
Xnmos$2_1709 WL_21 VSS SL_10N a_n66090_173# nmos$2
Xpmos$3_31 PC VDD ML_0 VDD pmos$3
Xnmos$2_5014 WL_3 VSS a_n38843_23498# SL_28 nmos$2
Xnmos$2_5025 WL_4 VSS SL_31N a_n34471_22409# nmos$2
Xnmos$2_5003 WL_4 VSS a_n37338_22190# SL_29 nmos$2
Xpmos_370 a_n28485_n4554# VDD m1_n28364_n4729# VDD pmos
Xnmos$2_5047 WL_3 VSS SL_31N a_n34471_23717# nmos$2
Xnmos$2_5036 WL_5 VSS a_n34324_20882# SL_31 nmos$2
Xnmos$2_5058 a_n35829_19574# VSS SL_30 a_n35515_19563# nmos$2
Xnmos$2_4302 a_n51035_13253# VSS a_n50574_13023# SL_20N nmos$2
Xnmos$2_4313 a_n54048_13253# VSS a_n53587_13023# SL_18N nmos$2
Xpmos_392 a_n26495_n338# VDD VDD m1_n26796_n326# pmos
Xpmos_381 a_n26495_n1776# VDD COMP23 VDD pmos
Xnmos$2_5069 a_n35515_27411# VSS ML_0 m1_n35418_27619# nmos$2
Xnmos$2_3601 WL_3 VSS a_n64438_23498# SL_11 nmos$2
Xnmos$2_3612 a_n61425_22190# VSS SL_13 a_n61111_22179# nmos$2
Xnmos$2_4357 a_n49383_15650# VSS SL_21 a_n49069_15639# nmos$2
Xnmos$2_4324 WL_9 VSS a_n50888_15650# SL_20 nmos$2
Xnmos$2_4335 WL_11 VSS SL_22N a_n48021_13253# nmos$2
Xnmos$2_4346 a_n47874_13034# VSS SL_22 a_n47560_13023# nmos$2
Xnmos$2_3645 a_n61572_25025# VSS a_n61111_24795# SL_13N nmos$2
Xnmos$2_3634 a_n61425_23498# VSS SL_13 a_n61111_23487# nmos$2
Xnmos$2_3623 a_n63077_21101# VSS a_n62616_20871# SL_12N nmos$2
Xnmos$2_2900 WL_9 VSS SL_6N a_n72108_15869# nmos$2
Xnmos$2_4368 WL_13 VSS a_n40351_10418# SL_27 nmos$2
Xnmos$2_4379 a_n40037_9099# VSS ML_14 m1_n39940_9307# nmos$2
Xnmos$2_3656 a_n63077_27641# VSS a_n62616_27411# SL_12N nmos$2
Xnmos$2_3667 a_n61111_26103# VSS ML_1 m1_n61014_26311# nmos$2
Xnmos$2_3678 a_n66090_25025# VSS a_n65629_24795# SL_10N nmos$2
Xnmos$2_2933 a_n70456_15650# VSS SL_7 a_n70142_15639# nmos$2
Xnmos$2_2911 a_n69104_13253# VSS a_n68643_13023# SL_8N nmos$2
Xnmos$2_2922 a_n70456_13034# VSS SL_7 a_n70142_13023# nmos$2
Xnmos$2_500 a_n40037_n57# VSS ML_21 m1_n39940_151# nmos$2
Xnmos$2_511 a_n43512_n2742# VSS a_n43051_n2673# SL_25N nmos$2
Xnmos$2_3689 a_n67599_27641# VSS a_n67138_27411# SL_9N nmos$2
Xnmos$2_2966 WL_6 VSS a_n70456_19574# SL_7 nmos$2
Xnmos$2_2944 a_n68643_18255# VSS ML_7 m1_n68546_18463# nmos$2
Xnmos$2_2955 WL_7 VSS a_n70456_18266# SL_7 nmos$2
Xnmos$2_2977 WL_8 VSS a_n68957_16958# SL_8 nmos$2
Xnmos$2_522 WL_23 VSS SL_23N a_n46516_n2742# nmos$2
Xnmos$2_533 a_n46369_n2662# VSS SL_23 a_n46055_n2673# nmos$2
Xnmos$2_544 WL_26 VSS a_n40351_n6586# SL_27 nmos$2
Xnmos$2_2988 a_n71961_18266# VSS SL_6 a_n71647_18255# nmos$2
Xnmos$2_2999 a_n75122_17177# VSS a_n74661_16947# SL_4N nmos$2
Xnmos$2_588 a_n34324_n13126# VSS SL_31 a_n34010_n13137# nmos$2
Xnmos$2_555 WL_26 VSS SL_19N a_n52543_n6666# nmos$2
Xnmos$2_577 WL_26 VSS a_n47874_n6586# SL_22 nmos$2
Xnmos$2_566 WL_26 VSS a_n44870_n6586# SL_24 nmos$2
Xnmos$2_599 a_n34324_n10510# VSS SL_31 a_n34010_n10521# nmos$2
Xnmos$2_4880 a_n40351_27422# VSS SL_27 a_n40037_27411# nmos$2
Xnmos$2_4891 WL_1 VSS SL_26N a_n42003_26333# nmos$2
Xnmos$5_360 VEVAL VSS m1_n58000_n1157# VSS nmos$5
Xnmos$5_371 VEVAL VSS m1_n56504_n2465# VSS nmos$5
Xnmos$5_393 VEVAL VSS m1_n56504_6691# VSS nmos$5
Xnmos$5_382 VEVAL VSS m1_n59505_4075# VSS nmos$5
Xpmos$1_2 a_n28089_n12336# VDD m1_n27919_n11830# a_n27274_n11842# pmos$1
Xnmos_306 a_n77988_n13126# VSS a_n78135_n13206# VSS nmos
Xnmos_339 a_n81002_n46# VSS a_n81149_173# VSS nmos
Xnmos_317 a_n79497_n9202# VSS a_n79644_n9282# VSS nmos
Xnmos_328 a_n76483_n6586# VSS a_n76630_n6666# VSS nmos
Xnmos$2_2229 WL_10 VSS SL_9N a_n67599_14561# nmos$2
Xnmos$2_2207 a_n65943_11726# VSS SL_10 a_n65629_11715# nmos$2
Xnmos$2_2218 a_n65629_10407# VSS ML_13 m1_n65532_10615# nmos$2
Xnmos$3_319 a_n61572_n11898# VSS VSS a_n61425_n11818# nmos$3
Xnmos$3_308 a_n58558_n6666# VSS VSS a_n58411_n6586# nmos$3
Xnmos$2_1528 a_n56915_n10510# VSS SL_16 a_n56601_n10521# nmos$2
Xnmos$2_1506 WL_28 VSS a_n53901_n9202# SL_18 nmos$2
Xnmos$2_1517 WL_27 VSS SL_17N a_n55557_n7974# nmos$2
Xnmos$2_1539 WL_31 VSS SL_11N a_n64585_n13206# nmos$2
Xnmos$2_80 a_n43512_n10590# VSS a_n43051_n10521# SL_25N nmos$2
Xnmos$2_91 WL_29 VSS SL_27N a_n40498_n10590# nmos$2
Xnmos$2_4110 a_n40498_8021# VSS a_n40037_7791# SL_27N nmos$2
Xnmos_851 ML_17 VSS VSS a_n28485_6950# nmos
Xnmos_862 a_n27618_5414# VSS m1_n27919_5426# VSS nmos
Xnmos_840 a_n26495_3976# VSS m1_n26796_3988# VSS nmos
Xnmos$2_4121 a_n49530_2789# VSS a_n49069_2559# SL_21N nmos$2
Xnmos$2_3420 WL_7 VSS a_n59916_18266# SL_14 nmos$2
Xnmos_895 a_n34324_10418# VSS a_n34471_10637# VSS nmos
Xnmos_873 a_n26495_8290# VSS m1_n26796_8302# VSS nmos
Xnmos_884 a_n38843_6494# VSS a_n38990_6713# VSS nmos
Xnmos$2_4165 WL_16 VSS a_n50888_6494# SL_20 nmos$2
Xnmos$2_4132 WL_18 VSS SL_22N a_n48021_4097# nmos$2
Xnmos$2_4154 WL_18 VSS a_n50888_3878# SL_20 nmos$2
Xnmos$2_4143 a_n52396_2570# VSS SL_19 a_n52082_2559# nmos$2
Xnmos$2_3431 a_n58411_19574# VSS SL_15 a_n58097_19563# nmos$2
Xnmos$2_3442 a_n58411_20882# VSS SL_15 a_n58097_20871# nmos$2
Xnmos$2_3453 a_n59602_20871# VSS ML_5 m1_n59505_21079# nmos$2
Xnmos$2_4187 a_n50888_7802# VSS SL_20 a_n50574_7791# nmos$2
Xnmos$2_4198 WL_16 VSS SL_22N a_n48021_6713# nmos$2
Xnmos$2_4176 a_n52396_5186# VSS SL_19 a_n52082_5175# nmos$2
Xnmos$2_3486 WL_3 VSS a_n55410_23498# SL_17 nmos$2
Xnmos$2_3464 WL_3 VSS a_n58411_23498# SL_15 nmos$2
Xnmos$2_3475 WL_4 VSS a_n55410_22190# SL_17 nmos$2
Xnmos$2_3497 a_n55096_20871# VSS ML_5 m1_n54999_21079# nmos$2
Xnmos$2_2752 WL_9 VSS SL_0N a_n81149_15869# nmos$2
Xnmos$2_2730 WL_10 VSS SL_1N a_n79644_14561# nmos$2
Xnmos$2_2741 a_n77988_13034# VSS SL_2 a_n77674_13023# nmos$2
Xnmos$3_853 a_n46516_10637# VSS VSS a_n46369_10418# nmos$3
Xnmos$3_820 a_n45017_8021# VSS VSS a_n44870_7802# nmos$3
Xnmos$3_842 a_n52543_8021# VSS VSS a_n52396_7802# nmos$3
Xnmos$3_831 a_n46516_4097# VSS VSS a_n46369_3878# nmos$3
Xnmos$2_2785 WL_10 VSS a_n76483_14342# SL_3 nmos$2
Xnmos$3_875 a_n46516_13253# VSS VSS a_n46369_13034# nmos$3
Xnmos$2_2774 WL_11 VSS SL_3N a_n76630_13253# nmos$2
Xnmos$2_2763 WL_11 VSS a_n79497_13034# SL_1 nmos$2
Xnmos$3_886 a_n42003_9329# VSS VSS a_n41856_9110# nmos$3
Xnmos$3_864 a_n52543_9329# VSS VSS a_n52396_9110# nmos$3
Xnmos$2_363 WL_22 VSS SL_19N a_n52543_n1434# nmos$2
Xnmos$2_352 WL_22 VSS SL_18N a_n54048_n1434# nmos$2
Xnmos$2_330 a_n52396_n3970# VSS SL_19 a_n52082_n3981# nmos$2
Xnmos$2_341 WL_24 VSS SL_19N a_n52543_n4050# nmos$2
Xnmos$2_2796 WL_9 VSS SL_3N a_n76630_15869# nmos$2
Xnmos$3_897 a_n45017_13253# VSS VSS a_n44870_13034# nmos$3
Xnmos$2_385 a_n48021_173# VSS a_n47560_n57# SL_22N nmos$2
Xnmos$2_374 WL_22 VSS a_n49383_n1354# SL_21 nmos$2
Xnmos$2_396 a_n48021_n2742# VSS a_n47560_n2673# SL_22N nmos$2
Xpmos_1902 a_n47874_7802# VDD VDD a_n48021_8021# pmos
Xpmos_1946 a_n51035_15869# VDD a_n50888_15650# VDD pmos
Xpmos_1935 a_n51035_11945# VDD a_n50888_11726# VDD pmos
Xpmos_1924 a_n49530_10637# VDD a_n49383_10418# VDD pmos
Xpmos_1913 a_n47874_9110# VDD VDD a_n48021_9329# pmos
Xpmos_1957 a_n49530_15869# VDD a_n49383_15650# VDD pmos
Xpmos_1979 a_n40498_11945# VDD a_n40351_11726# VDD pmos
Xpmos_1968 a_n50888_10418# VDD VDD a_n51035_10637# pmos
Xnmos_16 a_n43365_n13126# VSS a_n43512_n13206# VSS nmos
Xnmos_49 a_n52396_n10510# VSS a_n52543_n10590# VSS nmos
Xnmos_27 a_n44870_n9202# VSS a_n45017_n9282# VSS nmos
Xnmos_38 a_n41856_n7894# VSS a_n42003_n7974# VSS nmos
Xnmos$5_190 VEVAL VSS m1_n71550_n6389# VSS nmos$5
Xnmos_103 a_n46369_n1354# VSS a_n46516_n1434# VSS nmos
Xnmos_114 a_n26495_n11842# VSS m1_n26796_n11830# VSS nmos
Xnmos_125 a_n26495_n10404# VSS VSS COMP29 nmos
Xnmos_136 ML_30 VSS VSS m2_n30953_n9084# nmos
Xnmos_147 a_n26495_n8966# VSS m1_n26796_n8954# VSS nmos
Xnmos_158 a_n34324_n10510# VSS a_n34471_n10590# VSS nmos
Xnmos_169 a_n37338_n7894# VSS a_n37485_n7974# VSS nmos
Xnmos$2_2004 WL_17 VSS a_n53901_5186# SL_18 nmos$2
Xnmos$3_105 a_n42003_n1434# VSS VSS a_n41856_n1354# nmos$3
Xnmos$2_2026 a_n53587_7791# VSS ML_15 m1_n53490_7999# nmos$2
Xnmos$2_2015 WL_16 VSS SL_16N a_n57062_6713# nmos$2
Xnmos$2_2037 WL_19 VSS SL_13N a_n61572_2789# nmos$2
Xnmos$2_1303 WL_22 VSS a_n73470_n1354# SL_5 nmos$2
Xnmos$3_116 a_n35976_n13206# VSS VSS a_n35829_n13126# nmos$3
Xnmos$3_127 a_n38990_n7974# VSS VSS a_n38843_n7894# nmos$3
Xnmos$3_138 a_n35976_n5358# VSS VSS a_n35829_n5278# nmos$3
Xnmos$2_2048 a_n63077_4097# VSS a_n62616_3867# SL_12N nmos$2
Xnmos$2_2059 a_n66090_2789# VSS a_n65629_2559# SL_10N nmos$2
Xnmos$3_149 a_n37485_173# VSS VSS a_n37338_n46# nmos$3
Xnmos$2_1336 a_n68957_n46# VSS SL_8 a_n68643_n57# nmos$2
Xnmos$2_1314 a_n71961_n46# VSS SL_6 a_n71647_n57# nmos$2
Xnmos$2_1325 a_n70456_n1354# VSS SL_7 a_n70142_n1365# nmos$2
Xnmos$2_1347 WL_23 VSS SL_8N a_n69104_n2742# nmos$2
Xnmos$2_1358 WL_23 VSS a_n71961_n2662# SL_6 nmos$2
Xnmos$2_1369 a_n76483_n6586# VSS SL_3 a_n76169_n6597# nmos$2
Xpmos_1209 a_n81149_13253# VDD a_n81002_13034# VDD pmos
Xnmos_1118 a_n47874_27422# VSS a_n48021_27641# VSS nmos
Xnmos_1107 a_n50888_18266# VSS a_n51035_18485# VSS nmos
Xnmos_1129 a_n41856_26114# VSS a_n42003_26333# VSS nmos
Xnmos_670 a_n68957_15650# VSS a_n69104_15869# VSS nmos
Xnmos_692 a_n73470_20882# VSS a_n73617_21101# VSS nmos
Xnmos_681 a_n74975_19574# VSS a_n75122_19793# VSS nmos
Xnmos$2_3250 a_n76483_26114# VSS SL_3 a_n76169_26103# nmos$2
Xnmos$2_3261 a_n79183_24795# VSS ML_2 m1_n79086_25003# nmos$2
Xnmos$2_3272 a_n81149_27641# VSS a_n80688_27411# SL_0N nmos$2
Xnmos$3_661 a_n81149_26333# VSS VSS a_n81002_26114# nmos$3
Xnmos$2_3283 a_n81002_26114# VSS SL_0 a_n80688_26103# nmos$2
Xnmos$2_3294 a_n69104_25025# VSS a_n68643_24795# SL_8N nmos$2
Xnmos$3_650 a_n76630_21101# VSS VSS a_n76483_20882# nmos$3
Xnmos$2_2560 WL_18 VSS SL_2N a_n78135_4097# nmos$2
Xnmos$3_672 a_n70603_27641# VSS VSS a_n70456_27422# nmos$3
Xnmos$3_694 a_n57062_19793# VSS VSS a_n56915_19574# nmos$3
Xnmos$3_683 a_n54048_18485# VSS VSS a_n53901_18266# nmos$3
Xnmos$2_2593 WL_17 VSS a_n77988_5186# SL_2 nmos$2
Xnmos$2_2582 a_n80688_3867# VSS ML_18 m1_n80591_4075# nmos$2
Xnmos$2_2571 a_n79644_2789# VSS a_n79183_2559# SL_1N nmos$2
Xnmos$2_160 a_n40037_n9213# VSS ML_28 m1_n39940_n9005# nmos$2
Xnmos$2_171 WL_27 VSS SL_25N a_n43512_n7974# nmos$2
Xnmos$2_1870 WL_23 VSS a_n55410_n2662# SL_17 nmos$2
Xnmos$2_182 a_n47560_n13137# VSS ML_31 m1_n47463_n12929# nmos$2
Xpmos_3 a_n38990_n29051# VDD a_n38843_n28971# VDD pmos
Xnmos$2_193 a_n49530_n11898# VSS a_n49069_n11829# SL_21N nmos$2
Xnmos$2_1892 a_n60063_n6666# VSS a_n59602_n6597# SL_14N nmos$2
Xnmos$2_1881 a_n55410_n6586# VSS SL_17 a_n55096_n6597# nmos$2
Xpmos_1721 a_n34324_11726# VDD VDD a_n34471_11945# pmos
Xpmos_1710 a_n35829_6494# VDD VDD a_n35976_6713# pmos
Xpmos_1754 a_n38843_14342# VDD VDD a_n38990_14561# pmos
Xpmos_1743 a_n38990_13253# VDD a_n38843_13034# VDD pmos
Xpmos_1732 a_n37338_11726# VDD VDD a_n37485_11945# pmos
Xpmos_903 a_n55410_7802# VDD VDD a_n55557_8021# pmos
Xpmos_1787 a_n28485_14140# VDD m1_n28364_13965# VDD pmos
Xpmos_1776 a_n26495_11166# VDD VDD m1_n26796_11178# pmos
Xpmos_1765 a_n26495_9728# VDD VDD m1_n26796_9740# pmos
Xpmos_936 a_n66090_8021# VDD a_n65943_7802# VDD pmos
Xpmos_914 a_n62930_3878# VDD VDD a_n63077_4097# pmos
Xpmos_925 a_n67452_3878# VDD VDD a_n67599_4097# pmos
Xpmos_1798 a_n28485_12702# VDD m1_n28364_12527# VDD pmos
Xpmos_969 a_n66090_11945# VDD a_n65943_11726# VDD pmos
Xpmos_958 a_n63077_10637# VDD a_n62930_10418# VDD pmos
Xpmos_947 a_n63077_8021# VDD a_n62930_7802# VDD pmos
Xnmos$5_926 VEVAL VSS m1_n41445_22387# VSS nmos$5
Xnmos$5_915 VEVAL VSS m1_n45958_17155# VSS nmos$5
Xnmos$5_937 VEVAL VSS m1_n47463_17155# VSS nmos$5
Xnmos$5_904 VEVAL VSS m1_n42954_9307# VSS nmos$5
Xnmos$5_959 VEVAL VSS m1_n47463_23695# VSS nmos$5
Xnmos$5_948 VEVAL VSS m1_n50477_21079# VSS nmos$5
Xnmos$2_1111 a_n74975_n9202# VSS SL_4 a_n74661_n9213# nmos$2
Xnmos$2_1100 WL_27 VSS SL_0N a_n81149_n7974# nmos$2
Xnmos$2_1122 a_n77674_n7905# VSS ML_27 m1_n77577_n7697# nmos$2
Xnmos$2_1133 a_n74661_n5289# VSS ML_25 m1_n74564_n5081# nmos$2
Xnmos$2_1144 WL_24 VSS a_n76483_n3970# SL_3 nmos$2
Xnmos$2_1155 a_n79183_n5289# VSS ML_25 m1_n79086_n5081# nmos$2
Xnmos$2_1166 a_n80688_n3981# VSS ML_24 m1_n80591_n3773# nmos$2
Xnmos$2_1177 WL_24 VSS a_n79497_n3970# SL_1 nmos$2
Xnmos$2_1199 WL_21 VSS a_n77988_n46# SL_2 nmos$2
Xnmos$2_1188 WL_22 VSS SL_0N a_n81149_n1434# nmos$2
Xpmos_1006 a_n55410_11726# VDD VDD a_n55557_11945# pmos
Xpmos_1039 a_n59916_14342# VDD VDD a_n60063_14561# pmos
Xpmos_1028 a_n58411_13034# VDD VDD a_n58558_13253# pmos
Xpmos_1017 a_n60063_11945# VDD a_n59916_11726# VDD pmos
Xnmos$2_3080 WL_3 VSS SL_8N a_n69104_23717# nmos$2
Xnmos$2_3091 WL_8 VSS SL_3N a_n76630_17177# nmos$2
Xnmos$3_480 a_n55557_14561# VSS VSS a_n55410_14342# nmos$3
Xnmos$2_2390 a_n53901_13034# VSS SL_18 a_n53587_13023# nmos$2
Xnmos$3_491 a_n73617_4097# VSS VSS a_n73470_3878# nmos$3
Xpmos_2230 a_n34471_18485# VDD a_n34324_18266# VDD pmos
Xpmos_2274 a_n34471_25025# VDD a_n34324_24806# VDD pmos
Xpmos_2263 a_n37485_21101# VDD a_n37338_20882# VDD pmos
Xpmos_2252 a_n38990_21101# VDD a_n38843_20882# VDD pmos
Xpmos_2241 a_n38990_18485# VDD a_n38843_18266# VDD pmos
Xpmos_2296 a_n37485_26333# VDD a_n37338_26114# VDD pmos
Xpmos_2285 a_n38990_25025# VDD a_n38843_24806# VDD pmos
Xpmos_1562 a_n61572_23717# VDD a_n61425_23498# VDD pmos
Xpmos_1551 a_n64585_23717# VDD a_n64438_23498# VDD pmos
Xpmos_1540 a_n64585_18485# VDD a_n64438_18266# VDD pmos
Xpmos_711 a_n64585_n11898# VDD a_n64438_n11818# VDD pmos
Xpmos_700 a_n64438_n11818# VDD VDD a_n64585_n11898# pmos
Xpmos_1595 a_n56915_27422# VDD VDD a_n57062_27641# pmos
Xpmos_1573 a_n64438_26114# VDD VDD a_n64585_26333# pmos
Xpmos_1584 a_n67452_26114# VDD VDD a_n67599_26333# pmos
Xpmos_722 a_n66090_n7974# VDD a_n65943_n7894# VDD pmos
Xpmos_733 a_n61572_n7974# VDD a_n61425_n7894# VDD pmos
Xpmos_744 a_n63077_n4050# VDD a_n62930_n3970# VDD pmos
Xpmos_766 a_n66090_n1434# VDD a_n65943_n1354# VDD pmos
Xpmos_777 a_n63077_n2742# VDD a_n62930_n2662# VDD pmos
Xpmos_755 a_n67452_n6586# VDD VDD a_n67599_n6666# pmos
Xnmos$2_4709 WL_6 VSS a_n52396_19574# SL_19 nmos$2
Xpmos_799 a_n57062_n6666# VDD a_n56915_n6586# VDD pmos
Xpmos_788 a_n54048_n6666# VDD a_n53901_n6586# VDD pmos
Xnmos$2_918 WL_30 VSS a_n67452_n11818# SL_9 nmos$2
Xnmos$2_929 WL_30 VSS SL_8N a_n69104_n11898# nmos$2
Xnmos$2_907 a_n70603_n13206# VSS a_n70142_n13137# SL_7N nmos$2
Xpmos_19 a_n52543_n29051# VDD a_n52396_n28971# VDD pmos
Xnmos$5_701 VEVAL VSS m1_n67041_17155# VSS nmos$5
Xnmos$5_734 VEVAL VSS m1_n65532_26311# VSS nmos$5
Xnmos$5_745 VEVAL VSS m1_n59505_25003# VSS nmos$5
Xnmos$5_723 VEVAL VSS m1_n61014_25003# VSS nmos$5
Xnmos$5_712 VEVAL VSS m1_n61014_21079# VSS nmos$5
Xnmos$5_778 VEVAL VSS m1_n35418_11923# VSS nmos$5
Xnmos$5_767 VEVAL VSS m1_n36927_7999# VSS nmos$5
Xnmos$5_756 VEVAL VSS m1_n36927_1459# VSS nmos$5
Xnmos$5_789 VEVAL VSS m1_n38432_13231# VSS nmos$5
Xpmos_2060 a_n43365_20882# VDD VDD a_n43512_21101# pmos
Xpmos_2082 a_n48021_17177# VDD a_n47874_16958# VDD pmos
Xpmos_2071 a_n49530_17177# VDD a_n49383_16958# VDD pmos
Xpmos_1370 a_n81149_19793# VDD a_n81002_19574# VDD pmos
Xpmos_2093 a_n52396_18266# VDD VDD a_n52543_18485# pmos
Xpmos_1392 a_n79497_23498# VDD VDD a_n79644_23717# pmos
Xpmos_1381 a_n79497_20882# VDD VDD a_n79644_21101# pmos
Xnmos$2_5207 WL_20 VSS a_n65943_1262# SL_10 nmos$2
Xpmos_530 a_n77988_n9202# VDD VDD a_n78135_n9282# pmos
Xpmos_541 a_n76483_n6586# VDD VDD a_n76630_n6666# pmos
Xpmos_552 a_n79497_n5278# VDD VDD a_n79644_n5358# pmos
Xnmos$2_4506 a_n46369_2570# VSS SL_23 a_n46055_2559# nmos$2
Xnmos$2_5218 WL_20 VSS SL_14N a_n60063_1481# nmos$2
Xnmos$2_5229 WL_20 VSS a_n67452_1262# SL_9 nmos$2
Xpmos_574 a_n81002_n46# VDD VDD a_n81149_173# pmos
Xpmos_585 a_n77988_n2662# VDD VDD a_n78135_n2742# pmos
Xpmos_596 a_n70603_n5358# VDD a_n70456_n5278# VDD pmos
Xpmos_563 a_n79644_n4050# VDD a_n79497_n3970# VDD pmos
Xnmos$2_4539 WL_6 VSS a_n41856_19574# SL_26 nmos$2
Xnmos$2_4517 a_n40037_18255# VSS ML_7 m1_n39940_18463# nmos$2
Xnmos$2_4528 WL_8 VSS a_n40351_16958# SL_27 nmos$2
Xnmos$2_3816 a_n37024_6483# VSS ML_16 m1_n36927_6691# nmos$2
Xnmos$2_3827 a_n38529_6483# VSS ML_16 m1_n38432_6691# nmos$2
Xnmos$2_3805 WL_19 VSS SL_28N a_n38990_2789# nmos$2
Xnmos_1290 a_n58411_1262# VSS a_n58558_1481# VSS nmos
Xnmos$2_3838 WL_15 VSS SL_28N a_n38990_8021# nmos$2
Xnmos$2_3849 a_n34010_5175# VSS ML_17 m1_n33913_5383# nmos$2
Xnmos$2_737 WL_21 VSS SL_29N a_n37485_173# nmos$2
Xnmos$2_726 WL_22 VSS a_n38843_n1354# SL_28 nmos$2
Xnmos$2_704 a_n37338_n5278# VSS SL_29 a_n37024_n5289# nmos$2
Xnmos$2_715 a_n37338_n3970# VSS SL_29 a_n37024_n3981# nmos$2
Xnmos$2_748 a_n35976_173# VSS a_n35515_n57# SL_30N nmos$2
Xnmos$2_759 a_n35829_n3970# VSS SL_30 a_n35515_n3981# nmos$2
Xnmos$5_80 VEVAL VSS m1_n48972_n1157# VSS nmos$5
Xnmos$5_91 VEVAL VSS m1_n44459_n5081# VSS nmos$5
Xpmos$1_105 a_n28089_25052# VDD m1_n27919_25558# a_n27274_25546# pmos$1
Xpmos$1_116 a_n28089_27928# VDD m1_n27919_28434# a_n27274_28422# pmos$1
Xpmos$1_127 OUTP VDD a_n27274_1100# m1_n28364_1023# pmos$1
Xnmos$5_520 VEVAL VSS m1_n79086_6691# VSS nmos$5
Xnmos$5_553 VEVAL VSS m1_n80591_15847# VSS nmos$5
Xnmos$5_542 VEVAL VSS m1_n74564_11923# VSS nmos$5
Xnmos$5_531 VEVAL VSS m1_n77577_7999# VSS nmos$5
Xnmos$5_586 VEVAL VSS m1_n70045_15847# VSS nmos$5
Xnmos$5_575 VEVAL VSS m1_n71550_11923# VSS nmos$5
Xnmos$5_564 VEVAL VSS m1_n68546_9307# VSS nmos$5
Xnmos$5_597 VEVAL VSS m1_n73059_17155# VSS nmos$5
Xnmos$1_38 OUTP VSS m1_n27919_1112# a_n27274_1100# nmos$1
Xnmos$1_16 OUTP VSS m1_n27919_n8954# a_n27274_n8966# nmos$1
Xnmos$1_27 OUTP VSS m1_n27919_n4640# a_n27274_n4652# nmos$1
Xnmos$1_49 a_n28089_3482# VSS m1_n26796_3988# a_n26151_3976# nmos$1
Xpmos$3_6 PC VDD ML_26 VDD pmos$3
Xpmos$3_21 PC VDD ML_11 VDD pmos$3
Xpmos$3_10 PC VDD ML_21 VDD pmos$3
Xpmos$3_32 PC VDD ML_3 VDD pmos$3
Xnmos$2_5015 a_n38529_23487# VSS ML_3 m1_n38432_23695# nmos$2
Xnmos$2_5004 a_n38529_22179# VSS ML_4 m1_n38432_22387# nmos$2
Xpmos_360 a_n27618_n3214# VDD VDD m1_n27919_n3202# pmos
Xnmos$2_5026 a_n34010_22179# VSS ML_4 m1_n33913_22387# nmos$2
Xnmos$2_5037 a_n34324_20882# VSS SL_31 a_n34010_20871# nmos$2
Xnmos$2_5048 a_n35829_20882# VSS SL_30 a_n35515_20871# nmos$2
Xnmos$2_5059 WL_5 VSS a_n35829_20882# SL_30 nmos$2
Xnmos$2_4314 WL_10 VSS SL_18N a_n54048_14561# nmos$2
Xnmos$2_4303 a_n50574_13023# VSS ML_11 m1_n50477_13231# nmos$2
Xpmos_393 OUTP VDD VDD a_n27990_220# pmos
Xpmos_382 OUTP VDD VDD a_n28089_n2270# pmos
Xpmos_371 a_n27274_n4652# VDD VDD a_n27618_n4652# pmos
Xnmos$2_3602 a_n66090_23717# VSS a_n65629_23487# SL_10N nmos$2
Xnmos$2_4325 WL_9 VSS SL_20N a_n51035_15869# nmos$2
Xnmos$2_4336 a_n47874_14342# VSS SL_22 a_n47560_14331# nmos$2
Xnmos$2_4347 WL_10 VSS a_n49383_14342# SL_21 nmos$2
Xnmos$2_3646 WL_2 VSS a_n61425_24806# SL_13 nmos$2
Xnmos$2_3635 WL_3 VSS a_n61425_23498# SL_13 nmos$2
Xnmos$2_3613 WL_4 VSS a_n61425_22190# SL_13 nmos$2
Xnmos$2_3624 a_n63077_22409# VSS a_n62616_22179# SL_12N nmos$2
Xnmos$2_4358 WL_9 VSS SL_21N a_n49530_15869# nmos$2
Xnmos$2_2901 a_n72108_15869# VSS a_n71647_15639# SL_6N nmos$2
Xnmos$2_4369 a_n40498_9329# VSS a_n40037_9099# SL_27N nmos$2
Xnmos$2_3657 a_n64585_27641# VSS a_n64124_27411# SL_11N nmos$2
Xnmos$2_3668 a_n61572_26333# VSS a_n61111_26103# SL_13N nmos$2
Xnmos$2_3679 a_n64438_24806# VSS SL_11 a_n64124_24795# nmos$2
Xnmos$2_2934 a_n68643_15639# VSS ML_9 m1_n68546_15847# nmos$2
Xnmos$2_2912 WL_11 VSS a_n67452_13034# SL_9 nmos$2
Xnmos$2_2923 WL_11 VSS SL_7N a_n70603_13253# nmos$2
Xnmos$2_501 WL_21 VSS SL_26N a_n42003_173# nmos$2
Xnmos$2_512 a_n41542_n2673# VSS ML_23 m1_n41445_n2465# nmos$2
Xnmos$2_2967 a_n70456_19574# VSS SL_7 a_n70142_19563# nmos$2
Xnmos$2_2945 WL_7 VSS SL_8N a_n69104_18485# nmos$2
Xnmos$2_2956 a_n70456_16958# VSS SL_7 a_n70142_16947# nmos$2
Xnmos$2_523 WL_23 VSS SL_25N a_n43512_n2742# nmos$2
Xnmos$2_545 a_n40498_n6666# VSS a_n40037_n6597# SL_27N nmos$2
Xnmos$2_534 a_n46369_n3970# VSS SL_23 a_n46055_n3981# nmos$2
Xnmos$2_2978 WL_7 VSS a_n68957_18266# SL_8 nmos$2
Xnmos$2_2989 a_n73617_17177# VSS a_n73156_16947# SL_5N nmos$2
Xnmos$2_556 a_n52543_n6666# VSS a_n52082_n6597# SL_19N nmos$2
Xnmos$2_578 a_n47874_n6586# VSS SL_22 a_n47560_n6597# nmos$2
Xnmos$2_567 a_n46516_n6666# VSS a_n46055_n6597# SL_23N nmos$2
Xnmos$2_589 WL_31 VSS a_n34324_n13126# SL_31 nmos$2
Xnmos$2_4870 a_n41542_24795# VSS ML_2 m1_n41445_25003# nmos$2
Xnmos$2_4881 WL_0 VSS a_n40351_27422# SL_27 nmos$2
Xnmos$2_4892 a_n40498_26333# VSS a_n40037_26103# SL_27N nmos$2
Xnmos$5_361 VEVAL VSS m1_n59505_n1157# VSS nmos$5
Xnmos$5_350 VEVAL VSS m1_n62519_n2465# VSS nmos$5
Xnmos$5_394 VEVAL VSS m1_n56504_7999# VSS nmos$5
Xnmos$5_383 VEVAL VSS m1_n58000_4075# VSS nmos$5
Xnmos$5_372 VEVAL VSS m1_n54999_1459# VSS nmos$5
Xpmos$1_3 OUTP VDD m1_n26796_n11830# a_n26151_n11842# pmos$1
Xnmos_307 a_n77988_n10510# VSS a_n78135_n10590# VSS nmos
Xnmos_318 a_n81002_n9202# VSS a_n81149_n9282# VSS nmos
Xnmos_329 a_n76483_n5278# VSS a_n76630_n5358# VSS nmos
Xnmos$2_2219 a_n64438_14342# VSS SL_11 a_n64124_14331# nmos$2
Xnmos$2_2208 a_n67138_11715# VSS ML_12 m1_n67041_11923# nmos$2
Xnmos$3_309 a_n54048_n9282# VSS VSS a_n53901_n9202# nmos$3
Xnmos$2_1507 a_n56601_n9213# VSS ML_28 m1_n56504_n9005# nmos$2
Xnmos$2_1518 a_n55557_n7974# VSS a_n55096_n7905# SL_17N nmos$2
Xnmos$2_1529 a_n61111_n13137# VSS ML_31 m1_n61014_n12929# nmos$2
Xnmos$2_70 WL_31 VSS a_n40351_n13126# SL_27 nmos$2
Xnmos$2_81 WL_30 VSS SL_25N a_n43512_n11898# nmos$2
Xnmos$2_92 a_n40498_n10590# VSS a_n40037_n10521# SL_27N nmos$2
Xnmos_830 a_n59916_26114# VSS a_n60063_26333# VSS nmos
Xnmos_852 ML_16 VSS VSS a_n28485_8388# nmos
Xnmos$2_4111 a_n40037_7791# VSS ML_15 m1_n39940_7999# nmos$2
Xnmos$2_4100 a_n41856_6494# VSS SL_26 a_n41542_6483# nmos$2
Xnmos_841 a_n26151_3976# VSS a_n26495_3976# VSS nmos
Xnmos$2_4122 WL_19 VSS a_n49383_2570# SL_21 nmos$2
Xpmos_190 a_n44870_n6586# VDD VDD a_n45017_n6666# pmos
Xnmos$2_3410 WL_7 VSS a_n58411_18266# SL_15 nmos$2
Xnmos_896 a_n35829_9110# VSS a_n35976_9329# VSS nmos
Xnmos_863 a_n27618_6852# VSS m1_n27919_6864# VSS nmos
Xnmos_885 a_n38843_5186# VSS a_n38990_5405# VSS nmos
Xnmos$2_4133 a_n47560_3867# VSS ML_18 m1_n47463_4075# nmos$2
Xnmos$2_4155 a_n51035_4097# VSS a_n50574_3867# SL_20N nmos$2
Xnmos_874 a_n34324_2570# VSS a_n34471_2789# VSS nmos
Xnmos$2_4144 WL_19 VSS SL_18N a_n54048_2789# nmos$2
Xnmos$2_3454 a_n59602_23487# VSS ML_3 m1_n59505_23695# nmos$2
Xnmos$2_3432 a_n58097_20871# VSS ML_5 m1_n58000_21079# nmos$2
Xnmos$2_3443 WL_5 VSS a_n58411_20882# SL_15 nmos$2
Xnmos$2_3421 a_n60063_19793# VSS a_n59602_19563# SL_14N nmos$2
Xnmos$2_4188 WL_15 VSS SL_20N a_n51035_8021# nmos$2
Xnmos$2_4199 WL_16 VSS a_n46369_6494# SL_23 nmos$2
Xnmos$2_4177 a_n52082_6483# VSS ML_16 m1_n51985_6691# nmos$2
Xnmos$2_4166 WL_17 VSS SL_20N a_n51035_5405# nmos$2
Xnmos$3_810 a_n42003_4097# VSS VSS a_n41856_3878# nmos$3
Xnmos$2_3487 WL_3 VSS SL_16N a_n57062_23717# nmos$2
Xnmos$2_3476 a_n57062_21101# VSS a_n56601_20871# SL_16N nmos$2
Xnmos$2_3465 WL_5 VSS a_n53901_20882# SL_18 nmos$2
Xnmos$2_2731 a_n79644_14561# VSS a_n79183_14331# SL_1N nmos$2
Xnmos$2_2742 a_n81149_13253# VSS a_n80688_13023# SL_0N nmos$2
Xnmos$2_2720 a_n80688_11715# VSS ML_12 m1_n80591_11923# nmos$2
Xnmos$3_821 a_n43512_8021# VSS VSS a_n43365_7802# nmos$3
Xnmos$3_843 a_n51035_8021# VSS VSS a_n50888_7802# nmos$3
Xnmos$3_832 a_n48021_4097# VSS VSS a_n47874_3878# nmos$3
Xnmos$2_320 WL_25 VSS SL_20N a_n51035_n5358# nmos$2
Xnmos$2_3498 a_n56915_19574# VSS SL_16 a_n56601_19563# nmos$2
Xnmos$2_2753 WL_9 VSS a_n81002_15650# SL_0 nmos$2
Xnmos$3_876 a_n49530_14561# VSS VSS a_n49383_14342# nmos$3
Xnmos$2_2764 WL_10 VSS a_n79497_14342# SL_1 nmos$2
Xnmos$2_2775 a_n76630_13253# VSS a_n76169_13023# SL_3N nmos$2
Xnmos$3_865 a_n52543_10637# VSS VSS a_n52396_10418# nmos$3
Xnmos$3_854 a_n46516_9329# VSS VSS a_n46369_9110# nmos$3
Xnmos$2_353 a_n54048_173# VSS a_n53587_n57# SL_18N nmos$2
Xnmos$2_342 a_n52543_n5358# VSS a_n52082_n5289# SL_19N nmos$2
Xnmos$2_331 WL_24 VSS a_n52396_n3970# SL_19 nmos$2
Xnmos$2_2797 a_n76630_15869# VSS a_n76169_15639# SL_3N nmos$2
Xnmos$3_898 a_n45017_14561# VSS VSS a_n44870_14342# nmos$3
Xnmos$2_2786 a_n76483_14342# VSS SL_3 a_n76169_14331# nmos$2
Xnmos$3_887 a_n42003_11945# VSS VSS a_n41856_11726# nmos$3
Xnmos$2_386 WL_21 VSS SL_22N a_n48021_173# nmos$2
Xnmos$2_364 WL_21 VSS SL_19N a_n52543_173# nmos$2
Xnmos$2_375 a_n49069_n1365# VSS ML_22 m1_n48972_n1157# nmos$2
Xnmos$2_397 WL_23 VSS SL_18N a_n54048_n2742# nmos$2
Xpmos_1903 a_n46516_8021# VDD a_n46369_7802# VDD pmos
Xpmos_1925 a_n48021_11945# VDD a_n47874_11726# VDD pmos
Xpmos_1936 a_n52396_10418# VDD VDD a_n52543_10637# pmos
Xpmos_1914 a_n46516_9329# VDD a_n46369_9110# VDD pmos
Xpmos_1958 a_n47874_15650# VDD VDD a_n48021_15869# pmos
Xpmos_1947 a_n52396_15650# VDD VDD a_n52543_15869# pmos
Xpmos_1969 a_n50888_11726# VDD VDD a_n51035_11945# pmos
Xnmos_17 a_n43365_n11818# VSS a_n43512_n11898# VSS nmos
Xnmos_39 a_n47874_n13126# VSS a_n48021_n13206# VSS nmos
Xnmos_28 a_n46369_n9202# VSS a_n46516_n9282# VSS nmos
Xnmos$5_180 VEVAL VSS m1_n71550_n12929# VSS nmos$5
Xnmos$5_191 VEVAL VSS m1_n71550_n7697# VSS nmos$5
Xnmos_104 a_n46369_n46# VSS a_n46516_173# VSS nmos
Xnmos_115 a_n26151_n11842# VSS a_n26495_n11842# VSS nmos
Xnmos_126 a_n26151_n13280# VSS a_n26495_n13280# VSS nmos
Xnmos_148 a_n26495_n8966# VSS VSS COMP28 nmos
Xnmos_137 ML_29 VSS VSS m2_n30953_n7856# nmos
Xnmos_159 a_n37338_n13126# VSS a_n37485_n13206# VSS nmos
Xnmos$2_2005 a_n53901_6494# VSS SL_18 a_n53587_6483# nmos$2
Xnmos$3_106 a_n42003_173# VSS VSS a_n41856_n46# nmos$3
Xnmos$2_2016 a_n55410_5186# VSS SL_17 a_n55096_5175# nmos$2
Xnmos$2_2027 a_n55096_5175# VSS ML_17 m1_n54999_5383# nmos$2
Xnmos$2_2038 a_n61111_2559# VSS ML_19 m1_n61014_2767# nmos$2
Xnmos$3_117 a_n38990_n13206# VSS VSS a_n38843_n13126# nmos$3
Xnmos$3_128 a_n38990_n6666# VSS VSS a_n38843_n6586# nmos$3
Xnmos$3_139 a_n37485_n5358# VSS VSS a_n37338_n5278# nmos$3
Xnmos$2_2049 WL_18 VSS a_n62930_3878# SL_12 nmos$2
Xnmos$2_1315 a_n72108_173# VSS a_n71647_n57# SL_6N nmos$2
Xnmos$2_1326 a_n70142_n1365# VSS ML_22 m1_n70045_n1157# nmos$2
Xnmos$2_1304 a_n73470_n1354# VSS SL_5 a_n73156_n1365# nmos$2
Xnmos$2_1337 WL_21 VSS SL_8N a_n69104_173# nmos$2
Xnmos$2_1348 a_n69104_n2742# VSS a_n68643_n2673# SL_8N nmos$2
Xnmos$2_1359 a_n71961_n2662# VSS SL_6 a_n71647_n2673# nmos$2
Xnmos_1108 a_n50888_16958# VSS a_n51035_17177# VSS nmos
Xnmos_1119 a_n52396_24806# VSS a_n52543_25025# VSS nmos
Xnmos_671 a_n68957_18266# VSS a_n69104_18485# VSS nmos
Xnmos_660 a_n74975_15650# VSS a_n75122_15869# VSS nmos
Xnmos_693 a_n73470_22190# VSS a_n73617_22409# VSS nmos
Xnmos_682 a_n71961_19574# VSS a_n72108_19793# VSS nmos
Xnmos$2_3240 a_n78135_27641# VSS a_n77674_27411# SL_2N nmos$2
Xnmos$2_3251 WL_1 VSS a_n76483_26114# SL_3 nmos$2
Xnmos$2_3262 a_n79497_24806# VSS SL_1 a_n79183_24795# nmos$2
Xnmos$2_3273 a_n80688_27411# VSS ML_0 m1_n80591_27619# nmos$2
Xnmos$2_3284 WL_1 VSS SL_0N a_n81149_26333# nmos$2
Xnmos$2_3295 a_n68957_24806# VSS SL_8 a_n68643_24795# nmos$2
Xnmos$3_651 a_n76630_23717# VSS VSS a_n76483_23498# nmos$3
Xnmos$3_640 a_n81149_22409# VSS VSS a_n81002_22190# nmos$3
Xnmos$2_2550 WL_19 VSS a_n74975_2570# SL_4 nmos$2
Xnmos$3_673 a_n67599_27641# VSS VSS a_n67452_27422# nmos$3
Xnmos$3_662 a_n79644_26333# VSS VSS a_n79497_26114# nmos$3
Xnmos$3_695 a_n58558_18485# VSS VSS a_n58411_18266# nmos$3
Xnmos$3_684 a_n54048_17177# VSS VSS a_n53901_16958# nmos$3
Xnmos$2_2594 a_n79497_6494# VSS SL_1 a_n79183_6483# nmos$2
Xnmos$2_2561 a_n78135_4097# VSS a_n77674_3867# SL_2N nmos$2
Xnmos$2_2583 WL_18 VSS a_n81002_3878# SL_0 nmos$2
Xnmos$2_2572 a_n77988_2570# VSS SL_2 a_n77674_2559# nmos$2
Xnmos$2_161 WL_28 VSS SL_26N a_n42003_n9282# nmos$2
Xnmos$2_150 a_n46055_n7905# VSS ML_27 m1_n45958_n7697# nmos$2
Xnmos$2_1871 WL_23 VSS SL_16N a_n57062_n2742# nmos$2
Xnmos$2_1860 a_n59602_n2673# VSS ML_23 m1_n59505_n2465# nmos$2
Xnmos$2_183 WL_31 VSS SL_22N a_n48021_n13206# nmos$2
Xpmos_4 a_n31996_n28654# VDD a_n31183_n28668# VDD pmos
Xnmos$2_194 WL_30 VSS a_n49383_n11818# SL_21 nmos$2
Xnmos$2_172 a_n41542_n7905# VSS ML_27 m1_n41445_n7697# nmos$2
Xnmos$2_1882 a_n56601_n6597# VSS ML_26 m1_n56504_n6389# nmos$2
Xnmos$2_1893 WL_26 VSS SL_14N a_n60063_n6666# nmos$2
Xpmos_1700 a_n38843_7802# VDD VDD a_n38990_8021# pmos
Xpmos_1711 a_n34471_5405# VDD a_n34324_5186# VDD pmos
Xpmos_1744 a_n38843_15650# VDD VDD a_n38990_15869# pmos
Xpmos_1722 a_n34324_10418# VDD VDD a_n34471_10637# pmos
Xpmos_1733 a_n38843_10418# VDD VDD a_n38990_10637# pmos
Xpmos_1788 a_n26151_14042# VDD VDD a_n26495_14042# pmos
Xpmos_1755 a_n34324_13034# VDD VDD a_n34471_13253# pmos
Xpmos_1777 a_n26151_11166# VDD VDD a_n26495_11166# pmos
Xpmos_1766 OUTP VDD VDD a_n28089_9234# pmos
Xpmos_926 a_n64585_4097# VDD a_n64438_3878# VDD pmos
Xpmos_904 a_n61572_1481# VDD a_n61425_1262# VDD pmos
Xpmos_915 a_n62930_1262# VDD VDD a_n63077_1481# pmos
Xpmos_1799 OUTP VDD VDD a_n28089_12110# pmos
Xpmos_959 a_n62930_10418# VDD VDD a_n63077_10637# pmos
Xpmos_948 a_n61572_8021# VDD a_n61425_7802# VDD pmos
Xpmos_937 a_n67452_7802# VDD VDD a_n67599_8021# pmos
Xnmos$5_927 VEVAL VSS m1_n41445_21079# VSS nmos$5
Xnmos$5_916 VEVAL VSS m1_n45958_19771# VSS nmos$5
Xnmos$5_905 VEVAL VSS m1_n42954_15847# VSS nmos$5
Xnmos$5_949 VEVAL VSS m1_n50477_22387# VSS nmos$5
Xnmos$5_938 VEVAL VSS m1_n48972_17155# VSS nmos$5
Xnmos$2_1101 a_n80688_n7905# VSS ML_27 m1_n80591_n7697# nmos$2
Xnmos$2_1112 WL_28 VSS a_n74975_n9202# SL_4 nmos$2
Xnmos$2_1123 WL_27 VSS SL_2N a_n78135_n7974# nmos$2
Xnmos$2_1134 WL_25 VSS a_n74975_n5278# SL_4 nmos$2
Xnmos$2_1145 a_n76169_n3981# VSS ML_24 m1_n76072_n3773# nmos$2
Xnmos$2_1178 a_n77988_n1354# VSS SL_2 a_n77674_n1365# nmos$2
Xnmos$2_1156 WL_25 VSS a_n77988_n5278# SL_2 nmos$2
Xnmos$2_1167 a_n81149_n4050# VSS a_n80688_n3981# SL_0N nmos$2
Xnmos$2_1189 a_n81149_173# VSS a_n80688_n57# SL_0N nmos$2
Xpmos_1007 a_n54048_11945# VDD a_n53901_11726# VDD pmos
Xpmos_1029 a_n60063_13253# VDD a_n59916_13034# VDD pmos
Xpmos_1018 a_n57062_11945# VDD a_n56915_11726# VDD pmos
Xnmos_490 a_n56915_5186# VSS a_n57062_5405# VSS nmos
Xnmos$2_3070 a_n70603_22409# VSS a_n70142_22179# SL_7N nmos$2
Xnmos$2_3081 a_n69104_23717# VSS a_n68643_23487# SL_8N nmos$2
Xnmos$2_3092 a_n74975_16958# VSS SL_4 a_n74661_16947# nmos$2
Xnmos$3_470 a_n60063_13253# VSS VSS a_n59916_13034# nmos$3
Xnmos$3_481 a_n55557_15869# VSS VSS a_n55410_15650# nmos$3
Xnmos$2_2380 a_n60063_15869# VSS a_n59602_15639# SL_14N nmos$2
Xnmos$2_2391 a_n53587_13023# VSS ML_11 m1_n53490_13231# nmos$2
Xnmos$3_492 a_n72108_4097# VSS VSS a_n71961_3878# nmos$3
Xnmos$2_1690 a_n64438_n1354# VSS SL_11 a_n64124_n1365# nmos$2
Xpmos_2220 a_n27618_21232# VDD VDD m1_n27919_21244# pmos
Xpmos_2231 a_n35829_18266# VDD VDD a_n35976_18485# pmos
Xpmos_2253 a_n38990_22409# VDD a_n38843_22190# VDD pmos
Xpmos_2264 a_n34324_20882# VDD VDD a_n34471_21101# pmos
Xpmos_2242 a_n35976_19793# VDD a_n35829_19574# VDD pmos
Xpmos_2286 a_n38990_27641# VDD a_n38843_27422# VDD pmos
Xpmos_2297 a_n26495_25546# VDD COMP4 VDD pmos
Xpmos_2275 a_n35829_24806# VDD VDD a_n35976_25025# pmos
Xpmos_1563 a_n61572_22409# VDD a_n61425_22190# VDD pmos
Xpmos_1552 a_n65943_22190# VDD VDD a_n66090_22409# pmos
Xpmos_1530 a_n62930_19574# VDD VDD a_n63077_19793# pmos
Xpmos_1541 a_n64585_19793# VDD a_n64438_19574# VDD pmos
Xpmos_701 a_n63077_n11898# VDD a_n62930_n11818# VDD pmos
Xpmos_1596 a_n56915_26114# VDD VDD a_n57062_26333# pmos
Xpmos_1574 a_n61572_26333# VDD a_n61425_26114# VDD pmos
Xpmos_1585 a_n66090_26333# VDD a_n65943_26114# VDD pmos
Xpmos_712 a_n65943_n11818# VDD VDD a_n66090_n11898# pmos
Xpmos_723 a_n64585_n7974# VDD a_n64438_n7894# VDD pmos
Xpmos_734 a_n62930_n7894# VDD VDD a_n63077_n7974# pmos
Xpmos_745 a_n61572_n4050# VDD a_n61425_n3970# VDD pmos
Xpmos_778 a_n63077_n1434# VDD a_n62930_n1354# VDD pmos
Xpmos_767 a_n67452_n2662# VDD VDD a_n67599_n2742# pmos
Xpmos_756 a_n66090_n6666# VDD a_n65943_n6586# VDD pmos
Xpmos_789 a_n56915_n6586# VDD VDD a_n57062_n6666# pmos
Xnmos$2_919 a_n67452_n11818# VSS SL_9 a_n67138_n11829# nmos$2
Xnmos$2_908 WL_29 VSS SL_7N a_n70603_n10590# nmos$2
Xnmos$2_0 a_n37338_n28971# VSS PSL_29 a_n37024_n28982# nmos$2
Xnmos$5_702 VEVAL VSS m1_n67041_18463# VSS nmos$5
Xnmos$5_724 VEVAL VSS m1_n62519_25003# VSS nmos$5
Xnmos$5_735 VEVAL VSS m1_n64027_25003# VSS nmos$5
Xnmos$5_713 VEVAL VSS m1_n62519_21079# VSS nmos$5
Xnmos$5_746 VEVAL VSS m1_n59505_27619# VSS nmos$5
Xnmos$5_779 VEVAL VSS m1_n33913_11923# VSS nmos$5
Xnmos$5_768 VEVAL VSS m1_n33913_6691# VSS nmos$5
Xnmos$5_757 VEVAL VSS m1_n36927_2767# VSS nmos$5
Xpmos_2050 a_n46369_23498# VDD VDD a_n46516_23717# pmos
Xpmos_2061 a_n43365_22190# VDD VDD a_n43512_22409# pmos
Xpmos_2072 a_n49383_16958# VDD VDD a_n49530_17177# pmos
Xpmos_2083 a_n48021_19793# VDD a_n47874_19574# VDD pmos
Xpmos_2094 a_n52396_19574# VDD VDD a_n52543_19793# pmos
Xpmos_1360 a_n76630_19793# VDD a_n76483_19574# VDD pmos
Xpmos_1371 a_n81149_18485# VDD a_n81002_18266# VDD pmos
Xpmos_1393 a_n79644_22409# VDD a_n79497_22190# VDD pmos
Xpmos_1382 a_n78135_21101# VDD a_n77988_20882# VDD pmos
Xnmos$2_5208 a_n67599_1481# VSS a_n67138_1251# SL_9N nmos$2
Xpmos_531 a_n77988_n10510# VDD VDD a_n78135_n10590# pmos
Xpmos_520 a_n81149_n7974# VDD a_n81002_n7894# VDD pmos
Xpmos_553 a_n79497_n6586# VDD VDD a_n79644_n6666# pmos
Xpmos_542 a_n77988_n5278# VDD VDD a_n78135_n5358# pmos
Xnmos$2_5219 a_n56915_1262# VSS SL_16 a_n56601_1251# nmos$2
Xpmos_575 a_n78135_173# VDD a_n77988_n46# VDD pmos
Xpmos_586 a_n77988_n1354# VDD VDD a_n78135_n1434# pmos
Xpmos_564 a_n79644_n5358# VDD a_n79497_n5278# VDD pmos
Xnmos$2_4518 a_n40498_18485# VSS a_n40037_18255# SL_27N nmos$2
Xnmos$2_4529 WL_8 VSS a_n41856_16958# SL_26 nmos$2
Xnmos$2_4507 a_n46369_3878# VSS SL_23 a_n46055_3867# nmos$2
Xpmos_597 a_n70603_n6666# VDD a_n70456_n6586# VDD pmos
Xnmos$2_3817 WL_16 VSS SL_29N a_n37485_6713# nmos$2
Xnmos$2_3828 a_n38990_6713# VSS a_n38529_6483# SL_28N nmos$2
Xnmos_1280 a_n40351_5186# VSS a_n40498_5405# VSS nmos
Xnmos$2_3806 a_n38843_3878# VSS SL_28 a_n38529_3867# nmos$2
Xnmos$2_3839 a_n38990_8021# VSS a_n38529_7791# SL_28N nmos$2
Xnmos_1291 a_n73470_1262# VSS a_n73617_1481# VSS nmos
Xnmos$2_727 a_n38843_n1354# VSS SL_28 a_n38529_n1365# nmos$2
Xnmos$2_705 a_n38990_n5358# VSS a_n38529_n5289# SL_28N nmos$2
Xnmos$2_716 a_n37024_n3981# VSS ML_24 m1_n36927_n3773# nmos$2
Xnmos$2_749 WL_21 VSS a_n34324_n46# SL_31 nmos$2
Xnmos$2_738 WL_21 VSS a_n37338_n46# SL_29 nmos$2
Xnmos$5_81 VEVAL VSS m1_n48972_151# VSS nmos$5
Xnmos$5_92 VEVAL VSS m1_n45958_n5081# VSS nmos$5
Xnmos$5_70 VEVAL VSS m1_n47463_n3773# VSS nmos$5
Xpmos$1_117 a_n28089_30804# VDD m1_n27919_31310# a_n27274_31298# pmos$1
Xpmos$1_106 OUTP VDD m1_n26796_26996# a_n26151_26984# pmos$1
Xnmos$5_510 VEVAL VSS m1_n77577_4075# VSS nmos$5
Xnmos$5_543 VEVAL VSS m1_n79086_9307# VSS nmos$5
Xnmos$5_532 VEVAL VSS m1_n74564_7999# VSS nmos$5
Xnmos$5_521 VEVAL VSS m1_n80591_5383# VSS nmos$5
Xnmos$5_587 VEVAL VSS m1_n68546_15847# VSS nmos$5
Xnmos$5_554 VEVAL VSS m1_n79086_15847# VSS nmos$5
Xnmos$5_576 VEVAL VSS m1_n71550_14539# VSS nmos$5
Xnmos$5_565 VEVAL VSS m1_n68546_10615# VSS nmos$5
Xnmos$5_598 VEVAL VSS m1_n73059_19771# VSS nmos$5
Xnmos$1_39 a_n28089_606# VSS a_n27274_1100# m1_n28364_1023# nmos$1
Xnmos$1_17 OUTP VSS a_n26151_n8966# a_n27618_n8966# nmos$1
Xnmos$1_28 a_n28089_n3708# VSS a_n27274_n3214# m1_n28364_n3291# nmos$1
Xpmos$3_7 PC VDD ML_24 VDD pmos$3
Xpmos$3_11 PC VDD ML_22 VDD pmos$3
Xpmos$3_22 PC VDD ML_9 VDD pmos$3
Xnmos$2_5016 a_n38990_23717# VSS a_n38529_23487# SL_28N nmos$2
Xnmos$2_5005 WL_4 VSS a_n38843_22190# SL_28 nmos$2
Xpmos_1190 a_n76483_10418# VDD VDD a_n76630_10637# pmos
Xpmos_350 a_n35829_n46# VDD VDD a_n35976_173# pmos
Xpmos_361 a_n28485_n3116# VDD m1_n28364_n3291# VDD pmos
Xnmos$2_5049 WL_4 VSS a_n35829_22190# SL_30 nmos$2
Xnmos$2_5027 a_n34010_20871# VSS ML_5 m1_n33913_21079# nmos$2
Xnmos$2_5038 a_n35515_20871# VSS ML_5 m1_n35418_21079# nmos$2
Xnmos$2_4304 a_n50888_14342# VSS SL_20 a_n50574_14331# nmos$2
Xpmos_383 a_n26151_n1776# VDD VDD a_n26495_n1776# pmos
Xpmos_394 a_n40351_n5278# VDD VDD a_n40498_n5358# pmos
Xpmos_372 a_n26495_n4652# VDD COMP25 VDD pmos
Xnmos$2_3603 a_n65629_20871# VSS ML_5 m1_n65532_21079# nmos$2
Xnmos$2_4326 a_n51035_15869# VSS a_n50574_15639# SL_20N nmos$2
Xnmos$2_4337 WL_10 VSS a_n46369_14342# SL_23 nmos$2
Xnmos$2_4348 a_n49383_14342# VSS SL_21 a_n49069_14331# nmos$2
Xnmos$2_4315 WL_10 VSS a_n52396_14342# SL_19 nmos$2
Xnmos$2_3636 a_n61572_23717# VSS a_n61111_23487# SL_13N nmos$2
Xnmos$2_3614 a_n61111_22179# VSS ML_4 m1_n61014_22387# nmos$2
Xnmos$2_3625 a_n62616_20871# VSS ML_5 m1_n62519_21079# nmos$2
Xnmos$2_4359 a_n49530_15869# VSS a_n49069_15639# SL_21N nmos$2
Xnmos$2_3658 WL_0 VSS SL_11N a_n64585_27641# nmos$2
Xnmos$2_3669 WL_1 VSS SL_13N a_n61572_26333# nmos$2
Xnmos$2_3647 a_n62930_24806# VSS SL_12 a_n62616_24795# nmos$2
Xnmos$2_2902 a_n71647_15639# VSS ML_9 m1_n71550_15847# nmos$2
Xnmos$2_2913 WL_10 VSS SL_8N a_n69104_14561# nmos$2
Xnmos$2_2924 WL_10 VSS a_n70456_14342# SL_7 nmos$2
Xnmos$2_502 a_n42003_173# VSS a_n41542_n57# SL_26N nmos$2
Xnmos$2_2968 WL_6 VSS SL_7N a_n70603_19793# nmos$2
Xnmos$2_2946 a_n68957_18266# VSS SL_8 a_n68643_18255# nmos$2
Xnmos$2_2957 a_n70456_18266# VSS SL_7 a_n70142_18255# nmos$2
Xnmos$2_2935 a_n69104_15869# VSS a_n68643_15639# SL_8N nmos$2
Xnmos$2_524 WL_23 VSS SL_26N a_n42003_n2742# nmos$2
Xnmos$2_513 WL_23 VSS a_n41856_n2662# SL_26 nmos$2
Xnmos$2_535 a_n46369_n13126# VSS SL_23 a_n46055_n13137# nmos$2
Xnmos$2_2979 a_n72108_17177# VSS a_n71647_16947# SL_6N nmos$2
Xnmos$2_557 a_n52396_n6586# VSS SL_19 a_n52082_n6597# nmos$2
Xnmos$2_579 WL_26 VSS SL_23N a_n46516_n6666# nmos$2
Xnmos$2_568 WL_26 VSS a_n43365_n6586# SL_25 nmos$2
Xnmos$2_546 WL_26 VSS SL_26N a_n42003_n6666# nmos$2
Xnmos$2_4860 a_n52543_25025# VSS a_n52082_24795# SL_19N nmos$2
Xnmos$2_4882 a_n40037_27411# VSS ML_0 m1_n39940_27619# nmos$2
Xnmos$2_4893 WL_1 VSS SL_27N a_n40498_26333# nmos$2
Xnmos$2_4871 a_n41856_24806# VSS SL_26 a_n41542_24795# nmos$2
Xnmos$5_362 VEVAL VSS m1_n59505_151# VSS nmos$5
Xnmos$5_351 VEVAL VSS m1_n64027_151# VSS nmos$5
Xnmos$5_340 VEVAL VSS m1_n62519_n1157# VSS nmos$5
Xnmos$5_395 VEVAL VSS m1_n54999_7999# VSS nmos$5
Xnmos$5_384 VEVAL VSS m1_n58000_6691# VSS nmos$5
Xnmos$5_373 VEVAL VSS m1_n54999_2767# VSS nmos$5
Xpmos$1_4 OUTP VDD a_n27274_n13280# m1_n28364_n13357# pmos$1
Xnmos_308 a_n77988_n11818# VSS a_n78135_n11898# VSS nmos
Xnmos_319 a_n81002_n6586# VSS a_n81149_n6666# VSS nmos
Xnmos$2_2209 WL_12 VSS SL_9N a_n67599_11945# nmos$2
Xnmos$2_1508 WL_28 VSS SL_16N a_n57062_n9282# nmos$2
Xnmos$2_1519 WL_27 VSS a_n53901_n7894# SL_18 nmos$2
Xnmos$2_71 WL_31 VSS SL_27N a_n40498_n13206# nmos$2
Xnmos$2_60 a_n50574_n28982# VSS a_n32313_n28669# m1_n50477_n28774# nmos$2
Xnmos$2_82 a_n41542_n11829# VSS ML_30 m1_n41445_n11621# nmos$2
Xnmos$2_93 a_n40351_n11818# VSS SL_27 a_n40037_n11829# nmos$2
Xnmos_820 a_n65943_27422# VSS a_n66090_27641# VSS nmos
Xnmos_831 a_n59916_27422# VSS a_n60063_27641# VSS nmos
Xnmos$2_4101 WL_15 VSS a_n41856_7802# SL_26 nmos$2
Xnmos$2_4112 a_n42003_6713# VSS a_n41542_6483# SL_26N nmos$2
Xnmos_853 a_n26495_5414# VSS VSS COMP18 nmos
Xnmos_842 a_n26495_3976# VSS VSS COMP19 nmos
Xpmos_191 a_n43512_n6666# VDD a_n43365_n6586# VDD pmos
Xpmos_180 a_n40498_n5358# VDD a_n40351_n5278# VDD pmos
Xnmos$2_3411 WL_7 VSS SL_14N a_n60063_18485# nmos$2
Xnmos$2_3400 WL_8 VSS a_n56915_16958# SL_16 nmos$2
Xnmos_886 a_n38843_7802# VSS a_n38990_8021# VSS nmos
Xnmos_864 a_n27274_5414# VSS a_n27618_5414# VSS nmos
Xnmos$2_4134 a_n48021_4097# VSS a_n47560_3867# SL_22N nmos$2
Xnmos$2_4156 a_n50888_3878# VSS SL_20 a_n50574_3867# nmos$2
Xnmos_875 a_n35829_2570# VSS a_n35976_2789# VSS nmos
Xnmos$2_4123 WL_19 VSS SL_21N a_n49530_2789# nmos$2
Xnmos$2_4145 a_n52082_2559# VSS ML_19 m1_n51985_2767# nmos$2
Xnmos$2_3444 a_n60063_21101# VSS a_n59602_20871# SL_14N nmos$2
Xnmos$2_3433 WL_5 VSS a_n56915_20882# SL_16 nmos$2
Xnmos$2_3422 WL_6 VSS SL_14N a_n60063_19793# nmos$2
Xnmos$3_800 a_n38990_14561# VSS VSS a_n38843_14342# nmos$3
Xnmos_897 a_n35829_10418# VSS a_n35976_10637# VSS nmos
Xnmos$2_4189 a_n51035_8021# VSS a_n50574_7791# SL_20N nmos$2
Xnmos$2_4167 a_n50574_6483# VSS ML_16 m1_n50477_6691# nmos$2
Xnmos$2_4178 a_n54048_5405# VSS a_n53587_5175# SL_18N nmos$2
Xnmos$2_3488 a_n56601_23487# VSS ML_3 m1_n56504_23695# nmos$2
Xnmos$2_3455 a_n60063_23717# VSS a_n59602_23487# SL_14N nmos$2
Xnmos$2_3466 a_n53901_22190# VSS SL_18 a_n53587_22179# nmos$2
Xnmos$2_3477 a_n56601_22179# VSS ML_4 m1_n56504_22387# nmos$2
Xnmos$2_2743 a_n81002_14342# VSS SL_0 a_n80688_14331# nmos$2
Xnmos$2_2732 a_n79644_13253# VSS a_n79183_13023# SL_1N nmos$2
Xnmos$2_2721 WL_12 VSS a_n77988_11726# SL_2 nmos$2
Xnmos$2_2710 a_n80688_9099# VSS ML_14 m1_n80591_9307# nmos$2
Xnmos$3_822 a_n40498_6713# VSS VSS a_n40351_6494# nmos$3
Xnmos$3_844 a_n46516_6713# VSS VSS a_n46369_6494# nmos$3
Xnmos$3_811 a_n40498_4097# VSS VSS a_n40351_3878# nmos$3
Xnmos$3_833 a_n48021_2789# VSS VSS a_n47874_2570# nmos$3
Xnmos$2_310 WL_24 VSS a_n49383_n3970# SL_21 nmos$2
Xnmos$2_3499 a_n56915_20882# VSS SL_16 a_n56601_20871# nmos$2
Xnmos$2_2765 WL_9 VSS a_n79497_15650# SL_1 nmos$2
Xnmos$2_2754 a_n81149_15869# VSS a_n80688_15639# SL_0N nmos$2
Xnmos$2_2776 a_n77674_14331# VSS ML_10 m1_n77577_14539# nmos$2
Xnmos$3_877 a_n49530_13253# VSS VSS a_n49383_13034# nmos$3
Xnmos$3_866 a_n52543_11945# VSS VSS a_n52396_11726# nmos$3
Xnmos$3_855 a_n49530_10637# VSS VSS a_n49383_10418# nmos$3
Xnmos$2_354 WL_21 VSS a_n52396_n46# SL_19 nmos$2
Xnmos$2_343 a_n50574_n1365# VSS ML_22 m1_n50477_n1157# nmos$2
Xnmos$2_321 a_n51035_n5358# VSS a_n50574_n5289# SL_20N nmos$2
Xnmos$2_332 WL_24 VSS SL_18N a_n54048_n4050# nmos$2
Xnmos$3_899 a_n45017_15869# VSS VSS a_n44870_15650# nmos$3
Xnmos$2_2798 a_n74661_15639# VSS ML_9 m1_n74564_15847# nmos$2
Xnmos$2_2787 a_n76169_14331# VSS ML_10 m1_n76072_14539# nmos$2
Xnmos$3_888 a_n40498_11945# VSS VSS a_n40351_11726# nmos$3
Xnmos$2_387 a_n47874_n46# VSS SL_22 a_n47560_n57# nmos$2
Xnmos$2_376 a_n49530_n1434# VSS a_n49069_n1365# SL_21N nmos$2
Xnmos$2_365 a_n52543_n1434# VSS a_n52082_n1365# SL_19N nmos$2
Xnmos$2_398 WL_23 VSS a_n52396_n2662# SL_19 nmos$2
Xpmos_1926 a_n47874_10418# VDD VDD a_n48021_10637# pmos
Xpmos_1937 a_n51035_10637# VDD a_n50888_10418# VDD pmos
Xpmos_1915 a_n49530_9329# VDD a_n49383_9110# VDD pmos
Xpmos_1904 a_n48021_5405# VDD a_n47874_5186# VDD pmos
Xpmos_1959 a_n46516_15869# VDD a_n46369_15650# VDD pmos
Xpmos_1948 a_n52396_14342# VDD VDD a_n52543_14561# pmos
Xnmos_18 a_n43365_n10510# VSS a_n43512_n10590# VSS nmos
Xnmos_29 a_n46369_n7894# VSS a_n46516_n7974# VSS nmos
Xnmos$2_4690 WL_7 VSS SL_20N a_n51035_18485# nmos$2
Xnmos$5_170 VEVAL VSS m1_n74564_n28774# VSS nmos$5
Xnmos$5_181 VEVAL VSS m1_n73059_n12929# VSS nmos$5
Xnmos$5_192 VEVAL VSS m1_n68546_n9005# VSS nmos$5
Xnmos_105 a_n44870_n46# VSS a_n45017_173# VSS nmos
Xnmos_127 a_n26495_n13280# VSS m1_n26796_n13268# VSS nmos
Xnmos_116 a_n27618_n13280# VSS m1_n27919_n13268# VSS nmos
Xnmos_138 ML_28 VSS VSS a_n28485_n8868# nmos
Xnmos_149 a_n26495_n7528# VSS m1_n26796_n7516# VSS nmos
Xnmos$2_2017 a_n57062_8021# VSS a_n56601_7791# SL_16N nmos$2
Xnmos$2_2028 a_n55096_6483# VSS ML_16 m1_n54999_6691# nmos$2
Xnmos$2_2006 WL_17 VSS SL_17N a_n55557_5405# nmos$2
Xnmos$3_107 a_n40498_173# VSS VSS a_n40351_n46# nmos$3
Xnmos$3_118 a_n38990_n11898# VSS VSS a_n38843_n11818# nmos$3
Xnmos$3_129 a_n35976_n7974# VSS VSS a_n35829_n7894# nmos$3
Xnmos$2_2039 a_n61572_2789# VSS a_n61111_2559# SL_13N nmos$2
Xnmos$2_1316 WL_21 VSS SL_6N a_n72108_173# nmos$2
Xnmos$2_1327 WL_22 VSS a_n70456_n1354# SL_7 nmos$2
Xnmos$2_1305 a_n75122_n1434# VSS a_n74661_n1365# SL_4N nmos$2
Xnmos$2_1338 a_n69104_173# VSS a_n68643_n57# SL_8N nmos$2
Xnmos$2_1349 a_n68643_n2673# VSS ML_23 m1_n68546_n2465# nmos$2
Xnmos_1109 a_n50888_22190# VSS a_n51035_22409# VSS nmos
Xnmos_661 a_n71961_15650# VSS a_n72108_15869# VSS nmos
Xnmos_650 a_n74975_9110# VSS a_n75122_9329# VSS nmos
Xnmos_694 a_n73470_23498# VSS a_n73617_23717# VSS nmos
Xnmos_683 a_n73470_19574# VSS a_n73617_19793# VSS nmos
Xnmos_672 a_n68957_16958# VSS a_n69104_17177# VSS nmos
Xnmos$2_3241 a_n77674_27411# VSS ML_0 m1_n77577_27619# nmos$2
Xnmos$2_3252 a_n76169_26103# VSS ML_1 m1_n76072_26311# nmos$2
Xnmos$2_3230 a_n78135_25025# VSS a_n77674_24795# SL_2N nmos$2
Xnmos$2_3274 WL_0 VSS a_n77988_27422# SL_2 nmos$2
Xnmos$2_3285 WL_1 VSS a_n81002_26114# SL_0 nmos$2
Xnmos$2_3296 a_n68643_24795# VSS ML_2 m1_n68546_25003# nmos$2
Xnmos$2_3263 a_n77988_24806# VSS SL_2 a_n77674_24795# nmos$2
Xnmos$3_652 a_n75122_23717# VSS VSS a_n74975_23498# nmos$3
Xnmos$3_641 a_n79644_22409# VSS VSS a_n79497_22190# nmos$3
Xnmos$3_630 a_n78135_17177# VSS VSS a_n77988_16958# nmos$3
Xnmos$2_2540 a_n69104_8021# VSS a_n68643_7791# SL_8N nmos$2
Xnmos$2_2551 WL_19 VSS a_n76483_2570# SL_3 nmos$2
Xnmos$3_674 a_n69104_26333# VSS VSS a_n68957_26114# nmos$3
Xnmos$3_663 a_n81149_25025# VSS VSS a_n81002_24806# nmos$3
Xnmos$3_685 a_n55557_17177# VSS VSS a_n55410_16958# nmos$3
Xnmos$2_2562 a_n76169_3867# VSS ML_18 m1_n76072_4075# nmos$2
Xnmos$2_2584 a_n79644_4097# VSS a_n79183_3867# SL_1N nmos$2
Xnmos$2_2573 a_n79183_2559# VSS ML_19 m1_n79086_2767# nmos$2
Xnmos$2_140 WL_28 VSS m2_n44135_352# a_n45017_n9282# nmos$2
Xnmos$2_162 a_n40498_n9282# VSS a_n40037_n9213# SL_27N nmos$2
Xnmos$2_151 a_n45017_n7974# VSS a_n44556_n7905# m2_n44135_352# nmos$2
Xnmos$3_696 a_n58558_17177# VSS VSS a_n58411_16958# nmos$3
Xnmos$2_2595 a_n79644_5405# VSS a_n79183_5175# SL_1N nmos$2
Xnmos$2_1872 a_n57062_n2742# VSS a_n56601_n2673# SL_16N nmos$2
Xnmos$2_1861 a_n60063_n2742# VSS a_n59602_n2673# SL_14N nmos$2
Xnmos$2_184 a_n48021_n13206# VSS a_n47560_n13137# SL_22N nmos$2
Xpmos_5 a_n35829_n28971# VDD VDD a_n35976_n29051# pmos
Xnmos$2_195 WL_30 VSS SL_21N a_n49530_n11898# nmos$2
Xnmos$2_173 a_n43512_n7974# VSS a_n43051_n7905# SL_25N nmos$2
Xnmos$2_1883 WL_26 VSS SL_16N a_n57062_n6666# nmos$2
Xnmos$2_1850 a_n56915_n3970# VSS SL_16 a_n56601_n3981# nmos$2
Xnmos$2_1894 a_n59602_n6597# VSS ML_26 m1_n59505_n6389# nmos$2
Xpmos_1701 a_n38990_8021# VDD a_n38843_7802# VDD pmos
Xpmos_1712 a_n34471_6713# VDD a_n34324_6494# VDD pmos
Xpmos_1745 a_n38990_15869# VDD a_n38843_15650# VDD pmos
Xpmos_1723 a_n34471_10637# VDD a_n34324_10418# VDD pmos
Xpmos_1734 a_n37338_10418# VDD VDD a_n37485_10637# pmos
Xpmos_1756 a_n34471_13253# VDD a_n34324_13034# VDD pmos
Xpmos_1778 ML_13 VDD a_n28485_12702# VDD pmos
Xpmos_1767 a_n26151_9728# VDD VDD a_n26495_9728# pmos
Xpmos_927 a_n65943_3878# VDD VDD a_n66090_4097# pmos
Xpmos_905 a_n61572_2789# VDD a_n61425_2570# VDD pmos
Xpmos_916 a_n65943_2570# VDD VDD a_n66090_2789# pmos
Xpmos_1789 a_n26495_14042# VDD COMP12 VDD pmos
Xpmos_938 a_n64585_8021# VDD a_n64438_7802# VDD pmos
Xpmos_949 a_n62930_6494# VDD VDD a_n63077_6713# pmos
Xnmos$5_928 VEVAL VSS m1_n41445_23695# VSS nmos$5
Xnmos$5_917 VEVAL VSS m1_n44459_19771# VSS nmos$5
Xnmos$5_906 VEVAL VSS m1_n39940_18463# VSS nmos$5
Xnmos$5_939 VEVAL VSS m1_n48972_18463# VSS nmos$5
Xnmos$2_1102 a_n79183_n7905# VSS ML_27 m1_n79086_n7697# nmos$2
Xnmos$2_1113 a_n74661_n9213# VSS ML_28 m1_n74564_n9005# nmos$2
Xnmos$2_1124 a_n76483_n7894# VSS SL_3 a_n76169_n7905# nmos$2
Xnmos$2_1135 a_n76630_n5358# VSS a_n76169_n5289# SL_3N nmos$2
Xnmos$2_1157 a_n77988_n5278# VSS SL_2 a_n77674_n5289# nmos$2
Xnmos$2_1168 a_n81002_n3970# VSS SL_0 a_n80688_n3981# nmos$2
Xnmos$2_1146 a_n78135_n4050# VSS a_n77674_n3981# SL_2N nmos$2
Xnmos$2_1179 WL_22 VSS a_n77988_n1354# SL_2 nmos$2
Xpmos_1019 a_n58411_11726# VDD VDD a_n58558_11945# pmos
Xpmos_1008 a_n55410_10418# VDD VDD a_n55557_10637# pmos
Xnmos_491 a_n56915_7802# VSS a_n57062_8021# VSS nmos
Xnmos_480 a_n58411_3878# VSS a_n58558_4097# VSS nmos
Xnmos$2_3060 a_n69104_21101# VSS a_n68643_20871# SL_8N nmos$2
Xnmos$2_3071 WL_4 VSS a_n70456_22190# SL_7 nmos$2
Xnmos$2_3082 WL_3 VSS a_n67452_23498# SL_9 nmos$2
Xnmos$2_3093 WL_8 VSS a_n74975_16958# SL_4 nmos$2
Xnmos$3_460 a_n57062_10637# VSS VSS a_n56915_10418# nmos$3
Xnmos$3_482 a_n54048_15869# VSS VSS a_n53901_15650# nmos$3
Xnmos$2_2381 WL_9 VSS a_n56915_15650# SL_16 nmos$2
Xnmos$3_471 a_n60063_14561# VSS VSS a_n59916_14342# nmos$3
Xnmos$2_2392 WL_11 VSS a_n53901_13034# SL_18 nmos$2
Xnmos$2_2370 a_n59602_13023# VSS ML_11 m1_n59505_13231# nmos$2
Xnmos$3_493 a_n72108_6713# VSS VSS a_n71961_6494# nmos$3
Xnmos$2_1691 a_n64124_n1365# VSS ML_22 m1_n64027_n1157# nmos$2
Xnmos$2_1680 a_n65943_n3970# VSS SL_10 a_n65629_n3981# nmos$2
Xpmos_2210 a_n26495_22670# VDD VDD m1_n26796_22682# pmos
Xpmos_2221 a_n28485_21330# VDD m1_n28364_21155# VDD pmos
Xpmos_2254 a_n38990_23717# VDD a_n38843_23498# VDD pmos
Xpmos_2265 a_n35829_20882# VDD VDD a_n35976_21101# pmos
Xpmos_2232 a_n34324_19574# VDD VDD a_n34471_19793# pmos
Xpmos_2243 a_n37338_19574# VDD VDD a_n37485_19793# pmos
Xpmos_1520 a_n63077_17177# VDD a_n62930_16958# VDD pmos
Xpmos_2276 a_n34471_27641# VDD a_n34324_27422# VDD pmos
Xpmos_2298 a_n27618_26984# VDD VDD m1_n27919_26996# pmos
Xpmos_2287 a_n38990_26333# VDD a_n38843_26114# VDD pmos
Xpmos_1553 a_n64585_22409# VDD a_n64438_22190# VDD pmos
Xpmos_1542 a_n65943_19574# VDD VDD a_n66090_19793# pmos
Xpmos_1531 a_n65943_16958# VDD VDD a_n66090_17177# pmos
Xpmos_702 a_n61572_n11898# VDD a_n61425_n11818# VDD pmos
Xpmos_1575 a_n61572_27641# VDD a_n61425_27422# VDD pmos
Xpmos_1586 a_n66090_27641# VDD a_n65943_27422# VDD pmos
Xpmos_1564 a_n62930_20882# VDD VDD a_n63077_21101# pmos
Xpmos_713 a_n65943_n10510# VDD VDD a_n66090_n10590# pmos
Xpmos_735 a_n62930_n10510# VDD VDD a_n63077_n10590# pmos
Xpmos_724 a_n65943_n7894# VDD VDD a_n66090_n7974# pmos
Xpmos_1597 a_n55557_26333# VDD a_n55410_26114# VDD pmos
Xpmos_768 a_n66090_n2742# VDD a_n65943_n2662# VDD pmos
Xpmos_746 a_n62930_n5278# VDD VDD a_n63077_n5358# pmos
Xpmos_757 a_n67452_n3970# VDD VDD a_n67599_n4050# pmos
Xpmos_779 a_n64438_n46# VDD VDD a_n64585_173# pmos
Xnmos$2_909 a_n70603_n11898# VSS a_n70142_n11829# SL_7N nmos$2
Xnmos$2_1 a_n37485_n29051# VSS a_n37024_n28982# PSL_29N nmos$2
Xnmos$5_725 VEVAL VSS m1_n62519_27619# VSS nmos$5
Xnmos$5_736 VEVAL VSS m1_n64027_27619# VSS nmos$5
Xnmos$5_714 VEVAL VSS m1_n62519_22387# VSS nmos$5
Xnmos$5_703 VEVAL VSS m1_n67041_19771# VSS nmos$5
Xnmos$5_747 VEVAL VSS m1_n58000_27619# VSS nmos$5
Xnmos$5_769 VEVAL VSS m1_n33913_5383# VSS nmos$5
Xnmos$5_758 VEVAL VSS m1_n38432_2767# VSS nmos$5
Xnmos$3_290 a_n54048_n10590# VSS VSS a_n53901_n10510# nmos$3
Xpmos_2051 a_n45017_23717# VDD a_n44870_23498# VDD pmos
Xpmos_2062 a_n42003_22409# VDD a_n41856_22190# VDD pmos
Xpmos_2073 a_n49383_19574# VDD VDD a_n49530_19793# pmos
Xpmos_2040 a_n46369_18266# VDD VDD a_n46516_18485# pmos
Xpmos_1350 a_n67599_22409# VDD a_n67452_22190# VDD pmos
Xpmos_2095 a_n51035_19793# VDD a_n50888_19574# VDD pmos
Xpmos_1361 a_n77988_19574# VDD VDD a_n78135_19793# pmos
Xpmos_2084 a_n52396_16958# VDD VDD a_n52543_17177# pmos
Xpmos_510 a_n79644_n13206# VDD a_n79497_n13126# VDD pmos
Xpmos_1394 a_n79644_23717# VDD a_n79497_23498# VDD pmos
Xpmos_1383 a_n81002_20882# VDD VDD a_n81149_21101# pmos
Xpmos_1372 a_n81002_18266# VDD VDD a_n81149_18485# pmos
Xpmos_532 a_n76630_n9282# VDD a_n76483_n9202# VDD pmos
Xpmos_521 a_n79497_n7894# VDD VDD a_n79644_n7974# pmos
Xpmos_543 a_n77988_n6586# VDD VDD a_n78135_n6666# pmos
Xnmos$2_5209 WL_20 VSS SL_9N a_n67599_1481# nmos$2
Xpmos_576 a_n79497_n46# VDD VDD a_n79644_173# pmos
Xpmos_587 a_n76630_n2742# VDD a_n76483_n2662# VDD pmos
Xpmos_565 a_n79497_n2662# VDD VDD a_n79644_n2742# pmos
Xpmos_554 a_n81002_n5278# VDD VDD a_n81149_n5358# pmos
Xnmos$2_4519 WL_7 VSS SL_27N a_n40498_18485# nmos$2
Xnmos$2_4508 a_n46369_5186# VSS SL_23 a_n46055_5175# nmos$2
Xpmos_598 a_n70456_n6586# VDD VDD a_n70603_n6666# pmos
Xnmos_1270 a_n40351_16958# VSS a_n40498_17177# VSS nmos
Xnmos$2_3818 WL_16 VSS a_n37338_6494# SL_29 nmos$2
Xnmos_1281 a_n40351_6494# VSS a_n40498_6713# VSS nmos
Xnmos$2_3807 WL_18 VSS SL_28N a_n38990_4097# nmos$2
Xnmos$2_3829 WL_17 VSS a_n38843_5186# SL_28 nmos$2
Xnmos_1292 a_n59916_1262# VSS a_n60063_1481# VSS nmos
Xnmos$2_728 a_n38990_n1434# VSS a_n38529_n1365# SL_28N nmos$2
Xnmos$2_706 WL_25 VSS SL_28N a_n38990_n5358# nmos$2
Xnmos$2_717 a_n37485_n4050# VSS a_n37024_n3981# SL_29N nmos$2
Xnmos$2_739 a_n37338_n46# VSS SL_29 a_n37024_n57# nmos$2
Xnmos$5_82 VEVAL VSS m1_n47463_151# VSS nmos$5
Xnmos$5_60 VEVAL VSS m1_n50477_n6389# VSS nmos$5
Xnmos$5_71 VEVAL VSS m1_n50477_n5081# VSS nmos$5
Xnmos$5_93 VEVAL VSS m1_n45958_n3773# VSS nmos$5
Xpmos$1_118 a_n28089_29366# VDD a_n26151_29860# a_n27618_29860# pmos$1
Xpmos$1_107 a_n28089_26490# VDD a_n26151_26984# a_n27618_26984# pmos$1
Xnmos$5_500 VEVAL VSS m1_n70045_5383# VSS nmos$5
Xnmos$5_511 VEVAL VSS m1_n76072_4075# VSS nmos$5
Xnmos$5_544 VEVAL VSS m1_n79086_10615# VSS nmos$5
Xnmos$5_533 VEVAL VSS m1_n76072_7999# VSS nmos$5
Xnmos$5_522 VEVAL VSS m1_n80591_6691# VSS nmos$5
Xnmos$5_555 VEVAL VSS m1_n74564_14539# VSS nmos$5
Xnmos$5_577 VEVAL VSS m1_n71550_13231# VSS nmos$5
Xnmos$5_566 VEVAL VSS m1_n70045_10615# VSS nmos$5
Xnmos$5_599 VEVAL VSS m1_n71550_19771# VSS nmos$5
Xnmos$5_588 VEVAL VSS m1_n68546_17155# VSS nmos$5
Xnmos$1_18 OUTP VSS m1_n27919_n7516# a_n27274_n7528# nmos$1
Xnmos$1_29 OUTP VSS m1_n27919_n3202# a_n27274_n3214# nmos$1
Xpmos$3_8 PC VDD ML_25 VDD pmos$3
Xpmos$3_12 PC VDD ML_20 VDD pmos$3
Xpmos$3_23 PC VDD ML_10 VDD pmos$3
Xnmos$2_5006 WL_4 VSS SL_28N a_n38990_22409# nmos$2
Xpmos_1191 a_n76630_10637# VDD a_n76483_10418# VDD pmos
Xpmos_1180 a_n76483_9110# VDD VDD a_n76630_9329# pmos
Xpmos_351 a_n34471_173# VDD a_n34324_n46# VDD pmos
Xpmos_340 a_n37338_n46# VDD VDD a_n37485_173# pmos
Xnmos$2_5017 WL_3 VSS SL_28N a_n38990_23717# nmos$2
Xnmos$2_5028 a_n34471_21101# VSS a_n34010_20871# SL_31N nmos$2
Xnmos$2_5039 a_n35976_22409# VSS a_n35515_22179# SL_30N nmos$2
Xnmos$2_4305 WL_11 VSS a_n50888_13034# SL_20 nmos$2
Xpmos_384 a_n27274_n1776# VDD VDD a_n27618_n1776# pmos
Xpmos_373 a_n26151_n4652# VDD VDD a_n26495_n4652# pmos
Xpmos_395 a_n40351_n3970# VDD VDD a_n40498_n4050# pmos
Xpmos_362 a_n27274_n3214# VDD VDD a_n27618_n3214# pmos
Xnmos$2_4327 a_n50888_15650# VSS SL_20 a_n50574_15639# nmos$2
Xnmos$2_4338 a_n47560_13023# VSS ML_11 m1_n47463_13231# nmos$2
Xnmos$2_4316 a_n52082_13023# VSS ML_11 m1_n51985_13231# nmos$2
Xnmos$2_3637 WL_3 VSS SL_13N a_n61572_23717# nmos$2
Xnmos$2_3615 WL_4 VSS SL_13N a_n61572_22409# nmos$2
Xnmos$2_3626 a_n62930_22190# VSS SL_12 a_n62616_22179# nmos$2
Xnmos$2_3604 a_n65629_22179# VSS ML_4 m1_n65532_22387# nmos$2
Xnmos$2_4349 a_n49069_14331# VSS ML_10 m1_n48972_14539# nmos$2
Xnmos$2_3659 a_n61572_27641# VSS a_n61111_27411# SL_13N nmos$2
Xnmos$2_3648 WL_2 VSS a_n62930_24806# SL_12 nmos$2
Xnmos$2_2903 a_n71961_15650# VSS SL_6 a_n71647_15639# nmos$2
Xnmos$2_2914 a_n68643_14331# VSS ML_10 m1_n68546_14539# nmos$2
Xnmos$2_2925 WL_10 VSS SL_7N a_n70603_14561# nmos$2
Xnmos$2_503 a_n42003_n1434# VSS a_n41542_n1365# SL_26N nmos$2
Xnmos$2_2958 a_n70603_18485# VSS a_n70142_18255# SL_7N nmos$2
Xnmos$2_2947 a_n67452_16958# VSS SL_9 a_n67138_16947# nmos$2
Xnmos$2_2936 WL_9 VSS a_n67452_15650# SL_9 nmos$2
Xnmos$2_525 WL_23 VSS SL_27N a_n40498_n2742# nmos$2
Xnmos$2_514 a_n41856_n2662# VSS SL_26 a_n41542_n2673# nmos$2
Xnmos$2_536 a_n42003_n6666# VSS a_n41542_n6597# SL_26N nmos$2
Xnmos$2_2969 a_n70142_19563# VSS ML_6 m1_n70045_19771# nmos$2
Xnmos$2_558 a_n52082_n6597# VSS ML_26 m1_n51985_n6389# nmos$2
Xnmos$2_569 WL_26 VSS m2_n44135_352# a_n45017_n6666# nmos$2
Xnmos$2_547 a_n40351_n6586# VSS SL_27 a_n40037_n6597# nmos$2
Xnmos$2_4850 WL_1 VSS a_n50888_26114# SL_20 nmos$2
Xnmos$2_4861 WL_2 VSS SL_19N a_n52543_25025# nmos$2
Xnmos$2_4883 WL_0 VSS SL_27N a_n40498_27641# nmos$2
Xnmos$2_4894 a_n40351_26114# VSS SL_27 a_n40037_26103# nmos$2
Xnmos$2_4872 a_n43512_25025# VSS a_n43051_24795# SL_25N nmos$2
Xnmos$5_341 VEVAL VSS m1_n62519_151# VSS nmos$5
Xnmos$5_352 VEVAL VSS m1_n54999_n5081# VSS nmos$5
Xnmos$5_330 VEVAL VSS m1_n61014_n3773# VSS nmos$5
Xnmos$5_385 VEVAL VSS m1_n58000_5383# VSS nmos$5
Xnmos$5_374 VEVAL VSS m1_n56504_1459# VSS nmos$5
Xnmos$5_363 VEVAL VSS m1_n58000_151# VSS nmos$5
Xnmos$5_396 VEVAL VSS m1_n61014_2767# VSS nmos$5
Xpmos$1_5 a_n28089_n13774# VDD m1_n27919_n13268# a_n27274_n13280# pmos$1
Xnmos_309 a_n76483_n10510# VSS a_n76630_n10590# VSS nmos
Xnmos$2_1509 a_n55410_n9202# VSS SL_17 a_n55096_n9213# nmos$2
Xnmos$2_50 a_n47560_n28982# VSS a_n32313_n28669# m1_n47463_n28774# nmos$2
Xnmos$2_61 a_n52396_n28971# VSS PSL_19 a_n52082_n28982# nmos$2
Xnmos$2_72 a_n40498_n13206# VSS a_n40037_n13137# SL_27N nmos$2
Xnmos$2_94 WL_30 VSS a_n40351_n11818# SL_27 nmos$2
Xnmos$2_83 a_n41542_n10521# VSS ML_29 m1_n41445_n10313# nmos$2
Xnmos_810 a_n64438_24806# VSS a_n64585_25025# VSS nmos
Xpmos_170 a_n48021_n1434# VDD a_n47874_n1354# VDD pmos
Xnmos_832 a_n58411_27422# VSS a_n58558_27641# VSS nmos
Xnmos_821 a_n55410_26114# VSS a_n55557_26333# VSS nmos
Xnmos$2_4102 a_n41856_7802# VSS SL_26 a_n41542_7791# nmos$2
Xnmos$2_4113 a_n42003_5405# VSS a_n41542_5175# SL_26N nmos$2
Xnmos_843 a_n27274_2538# VSS a_n27618_2538# VSS nmos
Xpmos_192 a_n43512_n5358# VDD a_n43365_n5278# VDD pmos
Xpmos_181 a_n41856_n5278# VDD VDD a_n42003_n5358# pmos
Xnmos$2_3401 WL_7 VSS a_n56915_18266# SL_16 nmos$2
Xnmos_887 a_n37338_7802# VSS a_n37485_8021# VSS nmos
Xnmos_854 a_n26495_6852# VSS m1_n26796_6864# VSS nmos
Xnmos_865 a_n28485_6950# VSS VSS m1_n28364_6775# nmos
Xnmos_876 a_n35829_3878# VSS a_n35976_4097# VSS nmos
Xnmos$2_4135 WL_18 VSS a_n47874_3878# SL_22 nmos$2
Xnmos$2_4124 a_n49069_2559# VSS ML_19 m1_n48972_2767# nmos$2
Xnmos$2_4146 a_n54048_2789# VSS a_n53587_2559# SL_18N nmos$2
Xnmos$2_3434 WL_4 VSS SL_15N a_n58558_22409# nmos$2
Xnmos$2_3445 a_n59916_22190# VSS SL_14 a_n59602_22179# nmos$2
Xnmos$2_3423 a_n59602_19563# VSS ML_6 m1_n59505_19771# nmos$2
Xnmos$2_3412 a_n59602_18255# VSS ML_7 m1_n59505_18463# nmos$2
Xnmos$3_801 a_n38990_13253# VSS VSS a_n38843_13034# nmos$3
Xnmos_898 a_n35829_11726# VSS a_n35976_11945# VSS nmos
Xnmos$2_2700 a_n79183_10407# VSS ML_13 m1_n79086_10615# nmos$2
Xnmos$2_4168 a_n50888_6494# VSS SL_20 a_n50574_6483# nmos$2
Xnmos$2_4179 a_n52396_6494# VSS SL_19 a_n52082_6483# nmos$2
Xnmos$2_4157 WL_18 VSS SL_19N a_n52543_4097# nmos$2
Xnmos$2_3456 WL_3 VSS SL_14N a_n60063_23717# nmos$2
Xnmos$2_3467 a_n55557_21101# VSS a_n55096_20871# SL_17N nmos$2
Xnmos$2_3478 WL_4 VSS SL_16N a_n57062_22409# nmos$2
Xnmos$2_2733 a_n79497_13034# VSS SL_1 a_n79183_13023# nmos$2
Xnmos$2_2722 a_n77988_11726# VSS SL_2 a_n77674_11715# nmos$2
Xnmos$2_2711 a_n81149_10637# VSS a_n80688_10407# SL_0N nmos$2
Xnmos$3_823 a_n40498_5405# VSS VSS a_n40351_5186# nmos$3
Xnmos$3_812 a_n43512_2789# VSS VSS a_n43365_2570# nmos$3
Xnmos$3_834 a_n51035_2789# VSS VSS a_n50888_2570# nmos$3
Xnmos$2_300 WL_25 VSS a_n47874_n5278# SL_22 nmos$2
Xnmos$2_311 a_n49530_n4050# VSS a_n49069_n3981# SL_21N nmos$2
Xnmos$2_3489 a_n55410_23498# VSS SL_17 a_n55096_23487# nmos$2
Xnmos$2_2755 a_n81002_15650# VSS SL_0 a_n80688_15639# nmos$2
Xnmos$2_2766 WL_10 VSS SL_3N a_n76630_14561# nmos$2
Xnmos$2_2744 a_n81149_14561# VSS a_n80688_14331# SL_0N nmos$2
Xnmos$3_867 a_n51035_11945# VSS VSS a_n50888_11726# nmos$3
Xnmos$3_856 a_n49530_9329# VSS VSS a_n49383_9110# nmos$3
Xnmos$3_845 a_n46516_5405# VSS VSS a_n46369_5186# nmos$3
Xnmos$2_344 a_n50888_n1354# VSS SL_20 a_n50574_n1365# nmos$2
Xnmos$2_322 a_n50574_n5289# VSS ML_25 m1_n50477_n5081# nmos$2
Xnmos$2_333 a_n54048_n4050# VSS a_n53587_n3981# SL_18N nmos$2
Xnmos$3_878 a_n49530_15869# VSS VSS a_n49383_15650# nmos$3
Xnmos$2_2788 WL_9 VSS a_n76483_15650# SL_3 nmos$2
Xnmos$2_2777 WL_10 VSS SL_2N a_n78135_14561# nmos$2
Xnmos$3_889 a_n43512_9329# VSS VSS a_n43365_9110# nmos$3
Xnmos$2_2799 WL_14 VSS a_n67452_9110# SL_9 nmos$2
Xnmos$2_366 a_n52543_173# VSS a_n52082_n57# SL_19N nmos$2
Xnmos$2_355 WL_21 VSS SL_18N a_n54048_173# nmos$2
Xnmos$2_377 WL_22 VSS SL_21N a_n49530_n1434# nmos$2
Xnmos$2_388 WL_21 VSS a_n47874_n46# SL_22 nmos$2
Xnmos$2_399 a_n52396_n2662# VSS SL_19 a_n52082_n2673# nmos$2
Xpmos_1927 a_n46516_10637# VDD a_n46369_10418# VDD pmos
Xpmos_1916 a_n49383_9110# VDD VDD a_n49530_9329# pmos
Xpmos_1905 a_n48021_6713# VDD a_n47874_6494# VDD pmos
Xpmos_1949 a_n51035_14561# VDD a_n50888_14342# VDD pmos
Xpmos_1938 a_n52543_10637# VDD a_n52396_10418# VDD pmos
Xnmos_19 a_n41856_n10510# VSS a_n42003_n10590# VSS nmos
Xnmos$2_4680 a_n49069_19563# VSS ML_6 m1_n48972_19771# nmos$2
Xnmos$2_4691 WL_8 VSS a_n50888_16958# SL_20 nmos$2
Xnmos$5_160 VEVAL VSS m1_n62519_n28774# VSS nmos$5
Xnmos$2_3990 WL_13 VSS a_n35829_10418# SL_30 nmos$2
Xnmos$5_182 VEVAL VSS m1_n73059_n11621# VSS nmos$5
Xnmos$5_171 VEVAL VSS m1_n77577_n28774# VSS nmos$5
Xnmos$5_193 VEVAL VSS m1_n70045_n9005# VSS nmos$5
Xnmos_106 a_n41856_n1354# VSS a_n42003_n1434# VSS nmos
Xnmos_128 a_n28485_n13182# VSS VSS m1_n28364_n13357# nmos
Xnmos_117 a_n27618_n10404# VSS m1_n27919_n10392# VSS nmos
Xnmos_139 a_n26151_n7528# VSS a_n26495_n7528# VSS nmos
Xnmos$2_2029 a_n55096_7791# VSS ML_15 m1_n54999_7999# nmos$2
Xnmos$2_2018 WL_15 VSS a_n55410_7802# SL_17 nmos$2
Xnmos$2_2007 WL_17 VSS a_n55410_5186# SL_17 nmos$2
Xnmos$3_108 a_n42003_n2742# VSS VSS a_n41856_n2662# nmos$3
Xnmos$3_119 a_n38990_n10590# VSS VSS a_n38843_n10510# nmos$3
Xnmos$2_1306 a_n73617_173# VSS a_n73156_n57# SL_5N nmos$2
Xnmos$2_1317 WL_22 VSS SL_5N a_n73617_n1434# nmos$2
Xnmos$2_1339 a_n68643_n57# VSS ML_21 m1_n68546_151# nmos$2
Xnmos$2_1328 WL_22 VSS SL_7N a_n70603_n1434# nmos$2
Xnmos_640 a_n76483_15650# VSS a_n76630_15869# VSS nmos
Xnmos_662 a_n73470_14342# VSS a_n73617_14561# VSS nmos
Xnmos_651 a_n74975_11726# VSS a_n75122_11945# VSS nmos
Xnmos$2_3220 a_n74661_23487# VSS ML_3 m1_n74564_23695# nmos$2
Xnmos_695 a_n68957_20882# VSS a_n69104_21101# VSS nmos
Xnmos_673 a_n70456_18266# VSS a_n70603_18485# VSS nmos
Xnmos_684 a_n73470_16958# VSS a_n73617_17177# VSS nmos
Xnmos$2_3242 a_n74661_27411# VSS ML_0 m1_n74564_27619# nmos$2
Xnmos$2_3253 WL_1 VSS SL_2N a_n78135_26333# nmos$2
Xnmos$2_3231 a_n76483_24806# VSS SL_3 a_n76169_24795# nmos$2
Xnmos$2_3275 WL_0 VSS SL_1N a_n79644_27641# nmos$2
Xnmos$2_3286 a_n81149_26333# VSS a_n80688_26103# SL_0N nmos$2
Xnmos$2_3264 a_n81149_25025# VSS a_n80688_24795# SL_0N nmos$2
Xnmos$3_620 a_n69104_23717# VSS VSS a_n68957_23498# nmos$3
Xnmos$3_642 a_n79644_21101# VSS VSS a_n79497_20882# nmos$3
Xnmos$3_631 a_n79644_17177# VSS VSS a_n79497_16958# nmos$3
Xnmos$2_2541 a_n68643_7791# VSS ML_15 m1_n68546_7999# nmos$2
Xnmos$2_2530 a_n70456_6494# VSS SL_7 a_n70142_6483# nmos$2
Xnmos$3_675 a_n69104_27641# VSS VSS a_n68957_27422# nmos$3
Xnmos$2_3297 WL_2 VSS a_n67452_24806# SL_9 nmos$2
Xnmos$3_653 a_n75122_25025# VSS VSS a_n74975_24806# nmos$3
Xnmos$3_664 a_n79644_25025# VSS VSS a_n79497_24806# nmos$3
Xnmos$3_686 a_n55557_18485# VSS VSS a_n55410_18266# nmos$3
Xnmos$2_2563 WL_18 VSS a_n74975_3878# SL_4 nmos$2
Xnmos$2_2585 a_n79183_3867# VSS ML_18 m1_n79086_4075# nmos$2
Xnmos$2_2552 a_n76169_2559# VSS ML_19 m1_n76072_2767# nmos$2
Xnmos$2_2574 a_n80688_2559# VSS ML_19 m1_n80591_2767# nmos$2
Xnmos$2_1840 WL_21 VSS a_n53901_n46# SL_18 nmos$2
Xnmos$2_130 WL_30 VSS a_n43365_n11818# SL_25 nmos$2
Xnmos$2_141 WL_28 VSS SL_23N a_n46516_n9282# nmos$2
Xnmos$2_152 WL_27 VSS m2_n44135_352# a_n45017_n7974# nmos$2
Xnmos$3_697 a_n58558_19793# VSS VSS a_n58411_19574# nmos$3
Xnmos$2_2596 WL_16 VSS SL_1N a_n79644_6713# nmos$2
Xnmos$2_1873 a_n56915_n1354# VSS SL_16 a_n56601_n1365# nmos$2
Xnmos$2_1851 a_n58097_n2673# VSS ML_23 m1_n58000_n2465# nmos$2
Xnmos$2_1862 WL_23 VSS SL_14N a_n60063_n2742# nmos$2
Xnmos$2_185 WL_31 VSS a_n47874_n13126# SL_22 nmos$2
Xpmos_6 a_n34471_n29051# VDD a_n34324_n28971# VDD pmos
Xnmos$2_196 a_n49069_n11829# VSS ML_30 m1_n48972_n11621# nmos$2
Xnmos$2_163 WL_28 VSS a_n40351_n9202# SL_27 nmos$2
Xnmos$2_174 WL_27 VSS SL_27N a_n40498_n7974# nmos$2
Xnmos$2_1895 a_n57062_n6666# VSS a_n56601_n6597# SL_16N nmos$2
Xnmos$2_1884 WL_26 VSS a_n55410_n6586# SL_17 nmos$2
Xpmos_1702 a_n37338_7802# VDD VDD a_n37485_8021# pmos
Xpmos_1724 a_n35829_10418# VDD VDD a_n35976_10637# pmos
Xpmos_1735 a_n37485_10637# VDD a_n37338_10418# VDD pmos
Xpmos_1713 a_n35829_7802# VDD VDD a_n35976_8021# pmos
Xpmos_1746 a_n35976_15869# VDD a_n35829_15650# VDD pmos
Xpmos_1757 a_n35829_13034# VDD VDD a_n35976_13253# pmos
Xpmos_1768 a_n28485_9826# VDD m1_n28364_9651# VDD pmos
Xpmos_1779 ML_15 VDD a_n28485_9826# VDD pmos
Xpmos_917 a_n64585_2789# VDD a_n64438_2570# VDD pmos
Xpmos_906 a_n64438_1262# VDD VDD a_n64585_1481# pmos
Xpmos_939 a_n65943_7802# VDD VDD a_n66090_8021# pmos
Xpmos_928 a_n64585_6713# VDD a_n64438_6494# VDD pmos
Xnmos$5_918 VEVAL VSS m1_n44459_22387# VSS nmos$5
Xnmos$5_907 VEVAL VSS m1_n39940_17155# VSS nmos$5
Xnmos$5_929 VEVAL VSS m1_n39940_23695# VSS nmos$5
Xnmos$2_1114 a_n76630_n9282# VSS a_n76169_n9213# SL_3N nmos$2
Xnmos$2_1103 a_n79497_n7894# VSS SL_1 a_n79183_n7905# nmos$2
Xnmos$2_1125 WL_27 VSS a_n76483_n7894# SL_3 nmos$2
Xnmos$2_1158 a_n79644_n5358# VSS a_n79183_n5289# SL_1N nmos$2
Xnmos$2_1136 WL_25 VSS SL_3N a_n76630_n5358# nmos$2
Xnmos$2_1169 WL_24 VSS a_n81002_n3970# SL_0 nmos$2
Xnmos$2_1147 a_n76483_n3970# VSS SL_3 a_n76169_n3981# nmos$2
Xpmos_1009 a_n56915_10418# VDD VDD a_n57062_10637# pmos
Xnmos_470 a_n56915_n2662# VSS a_n57062_n2742# VSS nmos
Xnmos_492 a_n55410_7802# VSS a_n55557_8021# VSS nmos
Xnmos_481 a_n58411_6494# VSS a_n58558_6713# VSS nmos
Xnmos$2_3061 WL_4 VSS SL_8N a_n69104_22409# nmos$2
Xnmos$2_3050 WL_4 VSS SL_5N a_n73617_22409# nmos$2
Xnmos$2_3083 a_n68643_23487# VSS ML_3 m1_n68546_23695# nmos$2
Xnmos$2_3072 WL_5 VSS SL_7N a_n70603_21101# nmos$2
Xnmos$2_3094 a_n74661_16947# VSS ML_8 m1_n74564_17155# nmos$2
Xnmos$2_2360 WL_10 VSS SL_15N a_n58558_14561# nmos$2
Xnmos$3_450 a_n63077_14561# VSS VSS a_n62930_14342# nmos$3
Xnmos$3_461 a_n60063_10637# VSS VSS a_n59916_10418# nmos$3
Xnmos$2_2382 WL_9 VSS a_n58411_15650# SL_15 nmos$2
Xnmos$3_472 a_n60063_15869# VSS VSS a_n59916_15650# nmos$3
Xnmos$2_2393 a_n55557_14561# VSS a_n55096_14331# SL_17N nmos$2
Xnmos$2_2371 a_n60063_14561# VSS a_n59602_14331# SL_14N nmos$2
Xnmos$3_494 a_n72108_5405# VSS VSS a_n71961_5186# nmos$3
Xnmos$3_483 a_n67599_2789# VSS VSS a_n67452_2570# nmos$3
Xnmos$2_1670 a_n64438_n5278# VSS SL_11 a_n64124_n5289# nmos$2
Xnmos$2_1681 WL_24 VSS SL_9N a_n67599_n4050# nmos$2
Xnmos$2_1692 WL_22 VSS SL_10N a_n66090_n1434# nmos$2
Xpmos_2211 a_n26151_22670# VDD VDD a_n26495_22670# pmos
Xpmos_2222 a_n28485_22768# VDD m1_n28364_22593# VDD pmos
Xpmos_2200 a_n27618_18356# VDD VDD m1_n27919_18368# pmos
Xpmos_2255 a_n38843_23498# VDD VDD a_n38990_23717# pmos
Xpmos_1510 a_n55557_21101# VDD a_n55410_20882# VDD pmos
Xpmos_2233 a_n34324_18266# VDD VDD a_n34471_18485# pmos
Xpmos_2244 a_n37338_18266# VDD VDD a_n37485_18485# pmos
Xpmos_2277 a_n34471_26333# VDD a_n34324_26114# VDD pmos
Xpmos_2288 a_n38843_26114# VDD VDD a_n38990_26333# pmos
Xpmos_1554 a_n65943_23498# VDD VDD a_n66090_23717# pmos
Xpmos_2266 a_n34471_21101# VDD a_n34324_20882# VDD pmos
Xpmos_1543 a_n65943_20882# VDD VDD a_n66090_21101# pmos
Xpmos_1521 a_n64438_16958# VDD VDD a_n64585_17177# pmos
Xpmos_1532 a_n64585_17177# VDD a_n64438_16958# VDD pmos
Xpmos_1587 a_n65943_27422# VDD VDD a_n66090_27641# pmos
Xpmos_2299 OUTP VDD VDD a_n28089_26490# pmos
Xpmos_1576 a_n62930_24806# VDD VDD a_n63077_25025# pmos
Xpmos_1565 a_n62930_23498# VDD VDD a_n63077_23717# pmos
Xpmos_703 a_n62930_n11818# VDD VDD a_n63077_n11898# pmos
Xpmos_714 a_n64585_n10590# VDD a_n64438_n10510# VDD pmos
Xpmos_736 a_n62930_n9202# VDD VDD a_n63077_n9282# pmos
Xpmos_725 a_n61572_n9282# VDD a_n61425_n9202# VDD pmos
Xpmos_1598 a_n55557_27641# VDD a_n55410_27422# VDD pmos
Xpmos_769 a_n67452_n46# VDD VDD a_n67599_173# pmos
Xpmos_747 a_n62930_n6586# VDD VDD a_n63077_n6666# pmos
Xpmos_758 a_n66090_n4050# VDD a_n65943_n3970# VDD pmos
Xnmos$2_2 a_n38843_n28971# VSS PSL_28 a_n38529_n28982# nmos$2
Xnmos$5_726 VEVAL VSS m1_n61014_27619# VSS nmos$5
Xnmos$5_715 VEVAL VSS m1_n62519_23695# VSS nmos$5
Xnmos$5_704 VEVAL VSS m1_n65532_19771# VSS nmos$5
Xnmos$5_748 VEVAL VSS m1_n59505_26311# VSS nmos$5
Xnmos$5_737 VEVAL VSS m1_n64027_26311# VSS nmos$5
Xnmos$5_759 VEVAL VSS m1_n38432_1459# VSS nmos$5
Xnmos$2_2190 a_n64124_9099# VSS ML_14 m1_n64027_9307# nmos$2
Xnmos$3_280 a_n70603_n2742# VSS VSS a_n70456_n2662# nmos$3
Xnmos$3_291 a_n57062_n13206# VSS VSS a_n56915_n13126# nmos$3
Xpmos_2030 a_n40498_19793# VDD a_n40351_19574# VDD pmos
Xpmos_2063 a_n43365_23498# VDD VDD a_n43512_23717# pmos
Xpmos_2052 a_n45017_22409# VDD a_n44870_22190# VDD pmos
Xpmos_2041 a_n43512_19793# VDD a_n43365_19574# VDD pmos
Xpmos_1351 a_n69104_22409# VDD a_n68957_22190# VDD pmos
Xpmos_2096 a_n52396_20882# VDD VDD a_n52543_21101# pmos
Xpmos_1340 a_n68957_20882# VDD VDD a_n69104_21101# pmos
Xpmos_2074 a_n49530_19793# VDD a_n49383_19574# VDD pmos
Xpmos_1362 a_n75122_19793# VDD a_n74975_19574# VDD pmos
Xpmos_2085 a_n51035_17177# VDD a_n50888_16958# VDD pmos
Xpmos_500 a_n76483_n11818# VDD VDD a_n76630_n11898# pmos
Xpmos_1395 a_n79644_21101# VDD a_n79497_20882# VDD pmos
Xpmos_1384 a_n81149_21101# VDD a_n81002_20882# VDD pmos
Xpmos_1373 a_n81002_19574# VDD VDD a_n81149_19793# pmos
Xpmos_533 a_n76630_n10590# VDD a_n76483_n10510# VDD pmos
Xpmos_511 a_n78135_n9282# VDD a_n77988_n9202# VDD pmos
Xpmos_522 a_n78135_n7974# VDD a_n77988_n7894# VDD pmos
Xpmos_544 a_n76630_n6666# VDD a_n76483_n6586# VDD pmos
Xpmos_566 a_n79497_n1354# VDD VDD a_n79644_n1434# pmos
Xpmos_577 a_n79644_n1434# VDD a_n79497_n1354# VDD pmos
Xpmos_555 a_n81149_n6666# VDD a_n81002_n6586# VDD pmos
Xnmos$2_4509 a_n46369_13034# VSS SL_23 a_n46055_13023# nmos$2
Xpmos_588 a_n76630_173# VDD a_n76483_n46# VDD pmos
Xpmos_599 a_n70456_n5278# VDD VDD a_n70603_n5358# pmos
Xnmos_1260 OUTP VSS a_n28089_27928# VSS nmos
Xnmos_1271 a_n40351_18266# VSS a_n40498_18485# VSS nmos
Xnmos$2_3819 a_n37485_5405# VSS a_n37024_5175# SL_29N nmos$2
Xnmos$2_3808 a_n38529_3867# VSS ML_18 m1_n38432_4075# nmos$2
Xnmos_1282 a_n55410_1262# VSS a_n55557_1481# VSS nmos
Xnmos_1293 a_n71961_1262# VSS a_n72108_1481# VSS nmos
Xnmos$2_707 a_n38529_n5289# VSS ML_25 m1_n38432_n5081# nmos$2
Xnmos$2_718 WL_24 VSS SL_29N a_n37485_n4050# nmos$2
Xnmos$2_729 a_n38529_n1365# VSS ML_22 m1_n38432_n1157# nmos$2
Xnmos$5_83 VEVAL VSS m1_n47463_n2465# VSS nmos$5
Xnmos$5_50 VEVAL VSS m1_n51985_n12929# VSS nmos$5
Xnmos$5_61 VEVAL VSS m1_n47463_n9005# VSS nmos$5
Xnmos$5_72 VEVAL VSS m1_n51985_n5081# VSS nmos$5
Xnmos$5_94 VEVAL VSS m1_n44459_n3773# VSS nmos$5
Xpmos$1_108 OUTP VDD m1_n26796_31310# a_n26151_31298# pmos$1
Xpmos$1_119 OUTP VDD a_n27274_31298# m1_n28364_31221# pmos$1
Xnmos$5_501 VEVAL VSS m1_n70045_6691# VSS nmos$5
Xnmos$5_534 VEVAL VSS m1_n74564_10615# VSS nmos$5
Xnmos$5_523 VEVAL VSS m1_n80591_7999# VSS nmos$5
Xnmos$5_512 VEVAL VSS m1_n74564_4075# VSS nmos$5
Xnmos$5_578 VEVAL VSS m1_n73059_13231# VSS nmos$5
Xnmos$5_556 VEVAL VSS m1_n74564_13231# VSS nmos$5
Xnmos$5_567 VEVAL VSS m1_n70045_9307# VSS nmos$5
Xnmos$5_545 VEVAL VSS m1_n80591_9307# VSS nmos$5
Xnmos$5_589 VEVAL VSS m1_n68546_18463# VSS nmos$5
Xnmos$1_19 a_n28089_n9460# VSS m1_n26796_n8954# a_n26151_n8966# nmos$1
Xpmos$3_9 PC VDD ML_23 VDD pmos$3
Xpmos$3_24 PC VDD ML_8 VDD pmos$3
Xpmos$3_13 PC VDD ML_18 VDD pmos$3
Xpmos_1170 a_n76483_6494# VDD VDD a_n76630_6713# pmos
Xnmos$2_5007 a_n38529_20871# VSS ML_5 m1_n38432_21079# nmos$2
Xpmos_1181 a_n75122_9329# VDD a_n74975_9110# VDD pmos
Xpmos_1192 a_n79497_9110# VDD VDD a_n79644_9329# pmos
Xpmos_352 a_n34324_n46# VDD VDD a_n34471_173# pmos
Xpmos_330 a_n35976_n1434# VDD a_n35829_n1354# VDD pmos
Xpmos_341 a_n37485_n1434# VDD a_n37338_n1354# VDD pmos
Xnmos$2_5018 a_n38843_23498# VSS SL_28 a_n38529_23487# nmos$2
Xnmos$2_5029 WL_5 VSS SL_31N a_n34471_21101# nmos$2
Xpmos_385 a_n27618_n1776# VDD VDD m1_n27919_n1764# pmos
Xpmos_374 ML_26 VDD a_n28485_n5992# VDD pmos
Xpmos_363 a_n26495_n3214# VDD VDD m1_n26796_n3202# pmos
Xnmos$2_4328 a_n50574_15639# VSS ML_9 m1_n50477_15847# nmos$2
Xnmos$2_4339 WL_10 VSS a_n47874_14342# SL_22 nmos$2
Xnmos$2_4306 WL_10 VSS SL_20N a_n51035_14561# nmos$2
Xnmos$2_4317 a_n52396_14342# VSS SL_19 a_n52082_14331# nmos$2
Xpmos_396 a_n40351_n46# VDD VDD a_n40498_173# pmos
Xnmos$2_3605 a_n65629_23487# VSS ML_3 m1_n65532_23695# nmos$2
Xnmos$2_3627 WL_4 VSS a_n62930_22190# SL_12 nmos$2
Xnmos$2_3616 WL_5 VSS SL_11N a_n64585_21101# nmos$2
Xnmos$2_3649 a_n64585_25025# VSS a_n64124_24795# SL_11N nmos$2
Xnmos$2_3638 a_n61111_23487# VSS ML_3 m1_n61014_23695# nmos$2
Xnmos_1090 a_n52396_18266# VSS a_n52543_18485# VSS nmos
Xnmos$2_2904 WL_9 VSS SL_5N a_n73617_15869# nmos$2
Xnmos$2_2915 a_n68957_14342# VSS SL_8 a_n68643_14331# nmos$2
Xnmos$2_2948 WL_7 VSS a_n67452_18266# SL_9 nmos$2
Xnmos$2_2959 WL_7 VSS SL_7N a_n70603_18485# nmos$2
Xnmos$2_2937 a_n67452_15650# VSS SL_9 a_n67138_15639# nmos$2
Xnmos$2_2926 a_n70603_14561# VSS a_n70142_14331# SL_7N nmos$2
Xnmos$2_526 a_n40498_n2742# VSS a_n40037_n2673# SL_27N nmos$2
Xnmos$2_515 a_n40037_n2673# VSS ML_23 m1_n39940_n2465# nmos$2
Xnmos$2_504 a_n44870_n2662# VSS SL_24 a_n44556_n2673# nmos$2
Xnmos$3_1050 a_n73617_1481# VSS VSS a_n73470_1262# nmos$3
Xnmos$2_559 WL_26 VSS a_n52396_n6586# SL_19 nmos$2
Xnmos$2_548 a_n50888_n6586# VSS SL_20 a_n50574_n6597# nmos$2
Xnmos$2_537 WL_26 VSS SL_25N a_n43512_n6666# nmos$2
Xnmos$2_4840 WL_0 VSS SL_18N a_n54048_27641# nmos$2
Xnmos$2_4851 a_n52396_26114# VSS SL_19 a_n52082_26103# nmos$2
Xnmos$2_4873 a_n41542_27411# VSS ML_0 m1_n41445_27619# nmos$2
Xnmos$2_4884 WL_1 VSS a_n41856_26114# SL_26 nmos$2
Xnmos$2_4862 a_n40351_24806# VSS SL_27 a_n40037_24795# nmos$2
Xnmos$5_342 VEVAL VSS m1_n61014_151# VSS nmos$5
Xnmos$5_320 VEVAL VSS m1_n61014_n6389# VSS nmos$5
Xnmos$5_331 VEVAL VSS m1_n65532_n5081# VSS nmos$5
Xnmos$5_353 VEVAL VSS m1_n56504_n5081# VSS nmos$5
Xnmos$2_4895 WL_1 VSS a_n40351_26114# SL_27 nmos$2
Xnmos$5_386 VEVAL VSS m1_n59505_5383# VSS nmos$5
Xnmos$5_375 VEVAL VSS m1_n56504_2767# VSS nmos$5
Xnmos$5_364 VEVAL VSS m1_n54999_n1157# VSS nmos$5
Xnmos$5_397 VEVAL VSS m1_n61014_1459# VSS nmos$5
Xpmos$1_6 OUTP VDD m1_n26796_n13268# a_n26151_n13280# pmos$1
Xnmos$2_40 a_n40037_n28982# VSS a_n32313_n28669# m1_n39940_n28774# nmos$2
Xnmos$2_51 WL VSS a_n47874_n28971# PSL_22 nmos$2
Xnmos$2_62 WL VSS PSL_18N a_n54048_n29051# nmos$2
Xnmos$2_73 a_n41542_n13137# VSS ML_31 m1_n41445_n12929# nmos$2
Xnmos$2_84 a_n41856_n11818# VSS SL_26 a_n41542_n11829# nmos$2
Xnmos$2_95 WL_30 VSS SL_27N a_n40498_n11898# nmos$2
Xnmos_800 a_n61425_20882# VSS a_n61572_21101# VSS nmos
Xpmos_160 a_n47874_n2662# VDD VDD a_n48021_n2742# pmos
Xnmos_811 a_n64438_26114# VSS a_n64585_26333# VSS nmos
Xnmos_822 a_n55410_24806# VSS a_n55557_25025# VSS nmos
Xnmos$2_4103 a_n41542_7791# VSS ML_15 m1_n41445_7999# nmos$2
Xnmos_833 a_n27618_3976# VSS m1_n27919_3988# VSS nmos
Xnmos_844 a_n26495_2538# VSS VSS COMP20 nmos
Xpmos_171 a_n48021_173# VDD a_n47874_n46# VDD pmos
Xpmos_193 a_n44870_n5278# VDD VDD a_n45017_n5358# pmos
Xpmos_182 a_n42003_n5358# VDD a_n41856_n5278# VDD pmos
Xnmos$2_3402 a_n58411_18266# VSS SL_15 a_n58097_18255# nmos$2
Xnmos$2_4114 a_n42003_8021# VSS a_n41542_7791# SL_26N nmos$2
Xnmos_855 OUTP VSS a_n28089_4920# VSS nmos
Xnmos_866 a_n28485_5512# VSS VSS m1_n28364_5337# nmos
Xnmos_877 a_n34324_3878# VSS a_n34471_4097# VSS nmos
Xnmos$2_4136 a_n47874_3878# VSS SL_22 a_n47560_3867# nmos$2
Xnmos$2_4147 WL_18 VSS SL_18N a_n54048_4097# nmos$2
Xnmos$2_4125 a_n49383_2570# VSS SL_21 a_n49069_2559# nmos$2
Xnmos$2_3435 WL_4 VSS a_n56915_22190# SL_16 nmos$2
Xnmos$2_3424 a_n59916_19574# VSS SL_14 a_n59602_19563# nmos$2
Xnmos$2_3413 a_n59916_16958# VSS SL_14 a_n59602_16947# nmos$2
Xnmos_899 a_n34324_11726# VSS a_n34471_11945# VSS nmos
Xnmos$2_4169 a_n51035_6713# VSS a_n50574_6483# SL_20N nmos$2
Xnmos_888 a_n34324_5186# VSS a_n34471_5405# VSS nmos
Xnmos$2_4158 a_n52543_4097# VSS a_n52082_3867# SL_19N nmos$2
Xnmos$2_3457 a_n59916_23498# VSS SL_14 a_n59602_23487# nmos$2
Xnmos$2_3468 WL_5 VSS SL_17N a_n55557_21101# nmos$2
Xnmos$2_3479 WL_5 VSS SL_16N a_n57062_21101# nmos$2
Xnmos$2_3446 WL_4 VSS a_n59916_22190# SL_14 nmos$2
Xnmos$3_802 a_n38990_15869# VSS VSS a_n38843_15650# nmos$3
Xnmos$2_2734 a_n79183_14331# VSS ML_10 m1_n79086_14539# nmos$2
Xnmos$2_2723 a_n79497_11726# VSS SL_1 a_n79183_11715# nmos$2
Xnmos$2_2701 a_n79497_10418# VSS SL_1 a_n79183_10407# nmos$2
Xnmos$2_2712 a_n81002_10418# VSS SL_0 a_n80688_10407# nmos$2
Xnmos$3_824 a_n42003_6713# VSS VSS a_n41856_6494# nmos$3
Xnmos$3_813 a_n45017_2789# VSS VSS a_n44870_2570# nmos$3
Xnmos$3_835 a_n52543_2789# VSS VSS a_n52396_2570# nmos$3
Xnmos$2_301 WL_25 VSS SL_22N a_n48021_n5358# nmos$2
Xnmos$2_2756 a_n80688_15639# VSS ML_9 m1_n80591_15847# nmos$2
Xnmos$2_2767 a_n74661_14331# VSS ML_10 m1_n74564_14539# nmos$2
Xnmos$3_868 a_n51035_13253# VSS VSS a_n50888_13034# nmos$3
Xnmos$2_2745 a_n80688_13023# VSS ML_11 m1_n80591_13231# nmos$2
Xnmos$3_857 a_n49530_11945# VSS VSS a_n49383_11726# nmos$3
Xnmos$3_846 a_n49530_5405# VSS VSS a_n49383_5186# nmos$3
Xnmos$2_345 a_n51035_n1434# VSS a_n50574_n1365# SL_20N nmos$2
Xnmos$2_323 WL_25 VSS a_n50888_n5278# SL_20 nmos$2
Xnmos$2_334 WL_24 VSS SL_20N a_n51035_n4050# nmos$2
Xnmos$2_312 a_n49069_n3981# VSS ML_24 m1_n48972_n3773# nmos$2
Xnmos$3_879 a_n46516_15869# VSS VSS a_n46369_15650# nmos$3
Xnmos$2_2789 a_n77674_15639# VSS ML_9 m1_n77577_15847# nmos$2
Xnmos$2_2778 a_n78135_14561# VSS a_n77674_14331# SL_2N nmos$2
Xnmos$2_378 WL_21 VSS SL_21N a_n49530_173# nmos$2
Xnmos$2_356 a_n52396_n46# VSS SL_19 a_n52082_n57# nmos$2
Xnmos$2_367 a_n47560_n1365# VSS ML_22 m1_n47463_n1157# nmos$2
Xnmos$2_389 a_n52543_n2742# VSS a_n52082_n2673# SL_19N nmos$2
Xpmos_1917 a_n49530_11945# VDD a_n49383_11726# VDD pmos
Xpmos_1928 a_n52396_9110# VDD VDD a_n52543_9329# pmos
Xpmos_1906 a_n48021_8021# VDD a_n47874_7802# VDD pmos
Xpmos_1939 a_n53901_10418# VDD VDD a_n54048_10637# pmos
Xnmos$2_4681 a_n49383_19574# VSS SL_21 a_n49069_19563# nmos$2
Xnmos$2_4692 a_n50888_18266# VSS SL_20 a_n50574_18255# nmos$2
Xnmos$2_4670 WL_8 VSS SL_21N a_n49530_17177# nmos$2
Xnmos$5_150 VEVAL VSS m1_n35418_151# VSS nmos$5
Xnmos$5_161 VEVAL VSS m1_n64027_n28774# VSS nmos$5
Xnmos$2_3980 WL_9 VSS SL_30N a_n35976_15869# nmos$2
Xnmos$2_3991 a_n35829_10418# VSS SL_30 a_n35515_10407# nmos$2
Xnmos$5_172 VEVAL VSS m1_n76072_n28774# VSS nmos$5
Xnmos$5_183 VEVAL VSS m1_n73059_n10313# VSS nmos$5
Xnmos$5_194 VEVAL VSS m1_n70045_n7697# VSS nmos$5
Xnmos$2_890 a_n80688_n28982# VSS a_n32313_n28669# m1_n80591_n28774# nmos$2
Xnmos_107 a_n43365_n1354# VSS a_n43512_n1434# VSS nmos
Xnmos_129 OUTP VSS a_n28089_n13774# VSS nmos
Xnmos_118 OUTP VSS a_n28089_n12336# VSS nmos
Xnmos$2_2019 WL_15 VSS SL_16N a_n57062_8021# nmos$2
Xnmos$2_2008 WL_17 VSS SL_16N a_n57062_5405# nmos$2
Xnmos$3_109 a_n43512_n2742# VSS VSS a_n43365_n2662# nmos$3
Xnmos$2_1318 WL_21 VSS SL_5N a_n73617_173# nmos$2
Xnmos$2_1307 WL_21 VSS a_n73470_n46# SL_5 nmos$2
Xnmos$2_1329 a_n70603_n1434# VSS a_n70142_n1365# SL_7N nmos$2
Xnmos_630 a_n79497_13034# VSS a_n79644_13253# VSS nmos
Xnmos_652 a_n71961_11726# VSS a_n72108_11945# VSS nmos
Xnmos_641 a_n68957_9110# VSS a_n69104_9329# VSS nmos
Xnmos$2_3210 a_n77674_20871# VSS ML_5 m1_n77577_21079# nmos$2
Xnmos_685 a_n73470_18266# VSS a_n73617_18485# VSS nmos
Xnmos_674 a_n70456_16958# VSS a_n70603_17177# VSS nmos
Xnmos_663 a_n73470_13034# VSS a_n73617_13253# VSS nmos
Xnmos$2_3243 WL_0 VSS a_n74975_27422# SL_4 nmos$2
Xnmos$2_3232 a_n76169_24795# VSS ML_2 m1_n76072_25003# nmos$2
Xnmos$2_3221 WL_3 VSS a_n74975_23498# SL_4 nmos$2
Xnmos_696 a_n68957_22190# VSS a_n69104_22409# VSS nmos
Xnmos$3_610 a_n73617_22409# VSS VSS a_n73470_22190# nmos$3
Xnmos$2_3276 a_n79644_27641# VSS a_n79183_27411# SL_1N nmos$2
Xnmos$2_3254 a_n78135_26333# VSS a_n77674_26103# SL_2N nmos$2
Xnmos$2_3287 WL_1 VSS SL_1N a_n79644_26333# nmos$2
Xnmos$2_3265 WL_2 VSS SL_0N a_n81149_25025# nmos$2
Xnmos$3_621 a_n69104_22409# VSS VSS a_n68957_22190# nmos$3
Xnmos$3_643 a_n81149_21101# VSS VSS a_n81002_20882# nmos$3
Xnmos$3_632 a_n81149_18485# VSS VSS a_n81002_18266# nmos$3
Xnmos$2_2542 a_n67452_7802# VSS SL_9 a_n67138_7791# nmos$2
Xnmos$2_2520 WL_17 VSS SL_8N a_n69104_5405# nmos$2
Xnmos$2_2531 WL_17 VSS SL_7N a_n70603_5405# nmos$2
Xnmos$2_120 a_n44870_n11818# VSS SL_24 a_n44556_n11829# nmos$2
Xnmos$3_665 a_n79644_27641# VSS VSS a_n79497_27422# nmos$3
Xnmos$3_654 a_n75122_26333# VSS VSS a_n74975_26114# nmos$3
Xnmos$2_3298 a_n67452_24806# VSS SL_9 a_n67138_24795# nmos$2
Xnmos$3_676 a_n69104_25025# VSS VSS a_n68957_24806# nmos$3
Xnmos$2_2564 WL_18 VSS SL_3N a_n76630_4097# nmos$2
Xnmos$2_2553 a_n76483_2570# VSS SL_3 a_n76169_2559# nmos$2
Xnmos$2_2575 a_n81002_2570# VSS SL_0 a_n80688_2559# nmos$2
Xnmos$2_1830 a_n57062_n1434# VSS a_n56601_n1365# SL_16N nmos$2
Xnmos$2_131 a_n43365_n11818# VSS SL_25 a_n43051_n11829# nmos$2
Xnmos$2_142 WL_28 VSS a_n44870_n9202# SL_24 nmos$2
Xnmos$2_153 a_n43365_n7894# VSS SL_25 a_n43051_n7905# nmos$2
Xnmos$3_698 a_n57062_21101# VSS VSS a_n56915_20882# nmos$3
Xnmos$3_687 a_n55557_19793# VSS VSS a_n55410_19574# nmos$3
Xnmos$2_2597 WL_16 VSS a_n77988_6494# SL_2 nmos$2
Xnmos$2_2586 WL_18 VSS a_n77988_3878# SL_2 nmos$2
Xnmos$2_1841 a_n53587_n57# VSS ML_21 m1_n53490_151# nmos$2
Xnmos$2_1863 a_n53901_n2662# VSS SL_18 a_n53587_n2673# nmos$2
Xnmos$2_1852 a_n58558_n2742# VSS a_n58097_n2673# SL_15N nmos$2
Xnmos$2_186 a_n47874_n13126# VSS SL_22 a_n47560_n13137# nmos$2
Xpmos_7 a_n34324_n28971# VDD VDD a_n34471_n29051# pmos
Xnmos$2_164 a_n43512_n9282# VSS a_n43051_n9213# SL_25N nmos$2
Xnmos$2_175 WL_27 VSS a_n40351_n7894# SL_27 nmos$2
Xnmos$2_1874 WL_26 VSS SL_9N a_n67599_n6666# nmos$2
Xnmos$2_197 WL_29 VSS SL_21N a_n49530_n10590# nmos$2
Xnmos$2_1896 a_n67599_n6666# VSS a_n67138_n6597# SL_9N nmos$2
Xnmos$2_1885 a_n55096_n6597# VSS ML_26 m1_n54999_n6389# nmos$2
Xpmos_1703 a_n35976_8021# VDD a_n35829_7802# VDD pmos
Xpmos_1736 a_n35976_10637# VDD a_n35829_10418# VDD pmos
Xpmos_1725 a_n37338_9110# VDD VDD a_n37485_9329# pmos
Xpmos_1714 a_n34471_8021# VDD a_n34324_7802# VDD pmos
Xpmos_1758 a_n34471_15869# VDD a_n34324_15650# VDD pmos
Xpmos_1747 a_n37338_15650# VDD VDD a_n37485_15869# pmos
Xpmos_1769 a_n27274_9728# VDD VDD a_n27618_9728# pmos
Xpmos_907 a_n63077_2789# VDD a_n62930_2570# VDD pmos
Xpmos_918 a_n65943_1262# VDD VDD a_n66090_1481# pmos
Xpmos_929 a_n64585_5405# VDD a_n64438_5186# VDD pmos
Xnmos$2_5190 WL_20 VSS a_n41856_1262# SL_26 nmos$2
.ends

.subckt pmos$5 a_68_n36# w_n62_n62# a_94_0# a_0_0#
X0 a_94_0# a_68_n36# a_0_0# w_n62_n62# sg13_lv_pmos ad=5.1p pd=30.68u as=5.1p ps=30.68u w=15u l=0.13u
.ends

.subckt nmos$6 a_74_n26# sub a_0_0# a_100_10#
X0 a_100_10# a_74_n26# a_0_0# sub sg13_lv_nmos ad=0.104p pd=1.34u as=0.104p ps=1.34u w=0.2u l=0.13u
.ends

.subckt COMPLETE_PROYECT_FIG VDD X VSS Y Q L_HI D B C B_N S A_N B1 A2 A1 A0 B2 C1
+ reset clk q[21] q[22] q[24] q[25] q[26] q[28] q[29] q[19] q[18] q[10] q[11] q[12]
+ q[13] q[8] q[7] q[3] q[5] q[6] VEVAL_IN VEVAL1 PC q[1] SLN[1] q[14] SL[0] q[9] q[4]
+ SLN[9] q[2] SLN[5] SLN[0] q[15] X_uq343 q[17] X_uq346 q[16] q[20] X_uq362 X_uq338
+ X_uq339 q[31] q[30] q[23] q[27] WL_REF serial_in_data din[19] din[1] din[20] din[21]
+ din[22] din[23] din[24] din[25] din[26] din[28] din[29] din[2] din[30] din[31] din[3]
+ din[4] din[5] din[6] din[7] din[8] din[9] dout din[14] din[0] din[27] din[10] din[11]
+ din[12] din[13] din[15] din[16] din[17] din[18] X_uq0 X_uq1 X_uq2 X_uq3 X_uq4 X_uq5
+ X_uq6 X_uq7 X_uq8 X_uq9 X_uq10 X_uq11 X_uq12 X_uq13 X_uq14 X_uq15 X_uq16 X_uq17
+ X_uq18 X_uq19 X_uq20 X_uq21 X_uq22 X_uq23 X_uq24 X_uq25 X_uq26 X_uq27 X_uq28 X_uq29
+ X_uq30 X_uq31 X_uq32 X_uq33 X_uq34 X_uq35 X_uq36 X_uq37 X_uq38 X_uq39 X_uq40 X_uq41
+ X_uq42 X_uq43 X_uq44 X_uq45 X_uq46 X_uq47 X_uq48 X_uq49 X_uq50 X_uq51 X_uq52 X_uq53
+ X_uq54 X_uq55 X_uq56 X_uq57 X_uq58 X_uq59 X_uq61 X_uq62 X_uq63 X_uq64 X_uq65 X_uq66
+ X_uq67 X_uq68 X_uq69 X_uq70 X_uq72 X_uq73 X_uq74 X_uq77 X_uq78 X_uq79 X_uq80 X_uq81
+ X_uq82 X_uq83 X_uq84 X_uq85 X_uq88 X_uq89 X_uq90 X_uq91 X_uq93 X_uq94 X_uq95 X_uq96
+ X_uq97 X_uq98 X_uq99 X_uq112 X_uq113 X_uq123 X_uq135 X_uq136 X_uq137 X_uq138 X_uq141
+ X_uq143 X_uq144 X_uq145 X_uq147 X_uq148 X_uq150 X_uq152 X_uq156 X_uq157 X_uq159
+ X_uq160 X_uq162 X_uq163 X_uq164 X_uq167 X_uq168 X_uq170 X_uq171 X_uq172 X_uq173
+ X_uq174 X_uq175 X_uq176 X_uq177 X_uq178 X_uq179 X_uq182 X_uq183 X_uq184 X_uq185
+ X_uq188 X_uq189 X_uq190 X_uq191 X_uq192 X_uq193 X_uq194 X_uq195 X_uq197 X_uq198
+ X_uq199 X_uq200 X_uq201 X_uq202 X_uq203 X_uq205 X_uq206 X_uq208 X_uq210 X_uq211
+ X_uq212 X_uq215 X_uq216 X_uq218 X_uq219 X_uq220 X_uq221 X_uq222 X_uq224 X_uq226
+ X_uq233 X_uq235 X_uq236 X_uq237 X_uq239 X_uq240 X_uq241 X_uq242 X_uq243 X_uq244
+ X_uq247 X_uq248 X_uq249 X_uq250 X_uq251 X_uq255 X_uq256 X_uq259 X_uq260 X_uq262
+ X_uq263 X_uq264 X_uq266 X_uq267 X_uq268 X_uq271 X_uq272 X_uq273 X_uq275 X_uq276
+ X_uq277 X_uq279 X_uq280 X_uq281 X_uq282 X_uq284 X_uq286 X_uq293 X_uq294 X_uq297
+ X_uq300 X_uq303 X_uq304 X_uq305 X_uq308 X_uq311 X_uq312 X_uq313 X_uq314 X_uq315
+ X_uq319 X_uq321 X_uq323 X_uq324 X_uq326 X_uq328 X_uq333 X_uq335 X_uq341 X_uq345
+ X_uq348 A_uq24 X_uq352 A_uq30 SLN[7] SLN[6] X_uq372 X_uq373 X_uq375 X_uq376 X_uq379
+ X_uq382 X_uq383 X_uq387 X_uq390 A A_uq0 X_uq397 X_uq399 X_uq400 X_uq401 X_uq404
+ X_uq405 X_uq406 X_uq407 X_uq409 X_uq411 X_uq412 X_uq413 X_uq420 A_uq37 X_uq424 X_uq425
+ X_uq426 X_uq427 X_uq429 X_uq430 X_uq431 X_uq432 X_uq433 X_uq434 X_uq435 X_uq436
+ X_uq437 X_uq438 A_uq15 A_uq20 X_uq444 X_uq445 X_uq446 X_uq447 X_uq448 X_uq449 X_uq450
+ X_uq451 X_uq452 X_uq454 X_uq455 X_uq458 A_uq2 A_uq6 A_uq7 A_uq8 A_uq19 A_uq38 A_uq44
+ A_uq57 A_uq65 A_uq71 A_uq72 A_uq74 A_uq75 A_uq76 A_uq80 A_uq81 A_uq82 A_uq87 A_uq88
+ A_uq89 A_uq90 A_uq91 A_uq92 A_uq93 A_uq94 A_uq95 A_uq97 A_uq98 A_uq99 X_uq325 A_uq210
+ A_uq322 A_uq334 A_uq347 A_uq391 Y_uq0 Y_uq1 Y_uq2 Y_uq3 Y_uq4 Y_uq5 Y_uq6 Y_uq7
+ Y_uq8 Y_uq9 Y_uq10 Y_uq11 Y_uq12 Y_uq13 Y_uq14 Y_uq15 Y_uq16 Y_uq17 Y_uq18 Y_uq19
+ Y_uq20 Y_uq21 Y_uq22 Y_uq23 Y_uq24 Y_uq25 Y_uq26 Y_uq27 Y_uq28 Y_uq29 Y_uq30 Y_uq31
+ Y_uq32 Y_uq33 Y_uq34 Y_uq35 Y_uq36 Y_uq37 Y_uq39 Y_uq40 Y_uq41 Y_uq42 Y_uq44 Y_uq45
+ Y_uq47 Y_uq48 Y_uq49 Y_uq51 Y_uq52 Y_uq54 Y_uq55 Y_uq56 Y_uq57 Y_uq62 Y_uq63 Y_uq64
+ Y_uq65 Y_uq66 Y_uq68 Y_uq70 Y_uq71 Y_uq72 Y_uq73 Y_uq74 Y_uq75 Y_uq76 Y_uq80 Y_uq82
+ Y_uq83 Y_uq84 Y_uq85 Y_uq86 Y_uq88 Y_uq89 Y_uq90 Y_uq91 Y_uq92 Y_uq93 Y_uq94 Y_uq95
+ Y_uq97 Y_uq98 Y_uq103 Y_uq104 Y_uq105 Y_uq107 Y_uq109 Y_uq110 Y_uq113 Y_uq116 Y_uq119
+ Y_uq122 Y_uq127 Y_uq129 Y_uq130 Y_uq131 Y_uq133 Y_uq137 Y_uq139 Y_uq141 Y_uq142
+ Y_uq144 Y_uq146 Y_uq148 Y_uq149 Y_uq152 Y_uq155 Y_uq159 Y_uq162 Y_uq163 Y_uq164
+ Y_uq165 Y_uq167 Y_uq169 Y_uq172 Y_uq174 Y_uq176 Y_uq178 Y_uq180 Y_uq181 Y_uq185
+ Y_uq186 Y_uq188 Y_uq189 Y_uq190 Y_uq192 Y_uq194 Y_uq195 Y_uq196 Y_uq197 Y_uq199
+ Y_uq201 Y_uq203 Y_uq205 Y_uq206 Y_uq207 Y_uq208 Y_uq209 Y_uq210 Y_uq211 Y_uq212
+ Y_uq214 Y_uq219 Y_uq228 Y_uq229 Y_uq230 Y_uq231 Y_uq232 Y_uq233 Y_uq234 Y_uq235
+ Y_uq236 Y_uq237 Y_uq238 Y_uq239 Y_uq240 Y_uq242 Y_uq243 Y_uq246 Y_uq247 Y_uq249
+ Y_uq250 Y_uq252 Y_uq253 Y_uq254 Y_uq256 Y_uq257 Y_uq258 Y_uq260 Y_uq261 Y_uq263
+ Y_uq264 Y_uq265 Y_uq266 Y_uq267 Y_uq268 Y_uq269 Y_uq270 Y_uq271 Y_uq272 Y_uq276
+ Y_uq277 Y_uq280 Y_uq281 Y_uq283 Y_uq285 Y_uq286 Y_uq288 Y_uq289 Y_uq290 Y_uq291
+ Y_uq292 Y_uq293 Y_uq294 Y_uq295 Y_uq303 Y_uq304 Y_uq306 Y_uq308 Y_uq309 Y_uq310
+ Y_uq311 Y_uq314 Y_uq317 Y_uq318 Y_uq319 Y_uq322 Y_uq324 Y_uq326 Y_uq328 Y_uq329
+ Y_uq331 Y_uq332 Y_uq334 Y_uq335 Y_uq337 Y_uq338 Y_uq339 Y_uq340 Y_uq342 Y_uq344
+ Y_uq345 Y_uq346 Y_uq347 Y_uq349 Y_uq351 Y_uq352 Y_uq353 Y_uq356 Y_uq357 Y_uq358
+ Y_uq360 Y_uq363 Y_uq364 Y_uq366 B_uq1 B_uq2 B_uq3 B_uq4 B_uq5 B_uq6 B_uq7 B_uq8
+ B_uq9 B_uq10 B_uq11 B_uq12 B_uq13 B_uq14 B_uq15 B_uq16 B_uq17 B_uq18 B_uq19 B_uq20
+ B_uq21 B_uq22 B_uq23 B_uq24 B_uq25 B_uq26 B_uq27 B_uq28 B_uq29 B_uq30 B_uq31 B_uq32
+ B_uq33 B_uq38 B_uq40 B_uq42 B_uq43 B_uq48 B_uq49 B_uq50 B_uq51 B_uq55 B_uq58 B_uq60
+ B_uq63 B_uq64 B_uq65 B_uq66 B_uq67 B_uq68 B_uq70 B_uq73 B_uq74 B_uq75 B_uq76 B_uq77
+ B_uq78 B_uq79 B_uq80 B_uq81 B_uq83 B_uq84 B_uq85 B_uq86 B_uq87 B_uq88 B_uq89 B_uq91
+ B_uq92 B_uq93 B_uq96 C1_uq2 C1_uq4 C1_uq5 C1_uq6 C1_uq7 C1_uq8 C_uq0 C_uq1 C_uq2
+ C_uq3 C_uq4 C_uq5 C_uq6 C_uq8 C_uq9 C_uq13 C_uq14 C_uq15 C_uq16 C_uq18 C_uq19 C_uq20
+ C_uq21 C_uq22 C_uq23 C_uq24 C_uq25 C_uq26 C_uq27 C_uq28 C_uq29 C_uq30 C_uq31 C_uq32
+ C_uq33 C_uq34 C_uq36 C_uq37 C_uq39 C_uq42 C_uq43 C_uq44 C_uq45 C_uq46 C_uq47 C_uq48
+ C_uq49 C_uq50 C_uq51 C_uq52 C_uq53 C_uq54 C_uq55 C_uq56 C_uq57 C_uq58 C_uq59 C_uq60
+ C_uq61 C_uq62 C_uq63 C_uq64 C_uq65 C_uq66 C_uq67 C_uq68 C_uq69 C_uq70 C_uq71 C_uq72
+ C_uq73 B2_uq6 B2_uq7 B2_uq8 B2_uq9 A1_uq9 D_uq0 D_uq1 D_uq2 D_uq3 D_uq4 D_uq5 D_uq6
+ D_uq7 D_uq8 D_uq9 D_uq10 D_uq11 D_uq12 D_uq13 D_uq14 D_uq15 D_uq16 D_uq17 D_uq18
+ D_uq19 D_uq20 D_uq21 D_uq22 D_uq23 D_uq24 D_uq25 D_uq26 D_uq27 D_uq28 D_uq29 D_uq30
+ D_uq31 D_uq32 D_uq33 D_uq34 D_uq35 D_uq36 D_uq37 D_uq38 D_uq39 D_uq40 D_uq41 D_uq42
+ D_uq43 D_uq44 D_uq45 D_uq46 D_uq47 D_uq48 D_uq49 D_uq50 D_uq51 D_uq52 D_uq53 D_uq54
+ D_uq55 D_uq56 D_uq57 D_uq58 D_uq59 D_uq60 D_uq61 D_uq62 D_uq63 D_uq64 D_uq65 L_HI_uq0
+ L_HI_uq1 L_HI_uq2 L_HI_uq3 L_HI_uq4 L_HI_uq5 L_HI_uq6 L_HI_uq7 L_HI_uq8 L_HI_uq9
+ L_HI_uq10 L_HI_uq11 L_HI_uq12 L_HI_uq13 L_HI_uq14 L_HI_uq15 L_HI_uq16 L_HI_uq17
+ L_HI_uq18 L_HI_uq19 L_HI_uq20 L_HI_uq21 L_HI_uq22 L_HI_uq23 L_HI_uq24 L_HI_uq25
+ L_HI_uq26 L_HI_uq27 L_HI_uq28 L_HI_uq29 L_HI_uq30 L_HI_uq31 L_HI_uq32 L_HI_uq33
+ L_HI_uq34 L_HI_uq35 L_HI_uq36 L_HI_uq37 L_HI_uq38 L_HI_uq39 L_HI_uq40 A2_uq1 A2_uq2
+ A2_uq3 A2_uq6 A2_uq9 B1_uq1 B1_uq2 B1_uq5 B1_uq6 B1_uq7 Q_uq0 Q_uq1 Q_uq2 Q_uq3
+ Q_uq4 Q_uq5 Q_uq6 Q_uq7 Q_uq8 Q_uq9 Q_uq10 Q_uq11 Q_uq12 Q_uq13 Q_uq14 Q_uq15 Q_uq16
+ Q_uq17 Q_uq18 Q_uq19 Q_uq21 Q_uq22 Q_uq23 Q_uq24 Q_uq25 Q_uq26 Q_uq27 Q_uq28 Q_uq29
+ Q_uq30 Q_uq31 Q_uq32 Q_uq33 Q_uq34 Q_uq35 Q_uq36 Q_uq37 Q_uq38 Q_uq39 Q_uq40 Q_uq41
+ Q_uq42 Q_uq43 Q_uq44 Q_uq45 Q_uq46 Q_uq47 Q_uq48 Q_uq49 Q_uq50 Q_uq51 Q_uq52 Q_uq53
+ Q_uq54 Q_uq55 Q_uq56 Q_uq57 Q_uq58 Q_uq59 Q_uq60 S_uq0 A0_uq0
Xpmos$4_0 X_uq328 VDD m1_25585_66727# VDD pmos$4
Xnmos$7_0 VEVAL1 VSS VEVAL VSS nmos$7
Xpmos$4_1 a_26644_66906# VDD A_uq391 VDD pmos$4
Xpmos$4_2 a_26346_66907# VDD a_26644_66906# VDD pmos$4
Xpmos$4_3 serial_in_data VDD a_26346_66907# m1_25585_66727# pmos$4
XANALOG_FIGURE_0 X_uq247 X_uq44 X_uq54 X_uq58 X_uq1 X_uq248 X_uq45 X_uq25 X_uq249
+ X_uq26 X_uq46 X_uq27 din[19] X_uq224 X_uq38 X_uq12 din[18] din[29] X_uq240 X_uq9
+ X_uq39 X_uq2 din[17] din[28] q[19] X_uq56 X_uq333 A din[16] din[27] q[29] q[18]
+ X_uq55 X_uq0 din[15] din[26] q[17] q[28] X_uq37 X_uq62 A_uq20 din[25] din[14] q[16]
+ q[27] X_uq3 q[9] X_uq21 X_uq18 a_25784_16427# din[24] din[13] q[15] q[26] A_uq0
+ q[8] X_uq17 din[9] din[23] din[12] q[14] q[25] q[7] A_uq38 din[8] WL_REF din[22]
+ din[11] q[13] q[24] q[6] m1_26206_16511# din[7] din[21] din[10] q[23] q[12] q[5]
+ din[6] din[20] din[31] q[22] q[11] X_uq175 q[4] din[5] din[30] q[10] q[21] X_uq172
+ X_uq205 q[3] X_uq30 A_uq19 din[4] q[31] q[20] X_uq171 X_uq182 X_uq28 q[2] din[3]
+ q[30] X_uq170 X_uq192 q[1] VEVAL X_uq32 din[2] X_uq10 X_uq177 X_uq191 SL[0] X_uq23
+ X_uq49 din[1] X_uq185 X_uq219 X_uq335 X_uq69 A_uq57 din[0] SLN[0] X_uq184 X_uq218
+ SLN[1] X_uq194 X_uq198 X_uq352 X_uq11 X_uq43 X_uq183 X_uq203 X_uq362 A_uq7 X_uq193
+ X_uq216 X_uq348 A_uq15 A_uq6 X_uq178 X_uq176 X_uq13 A_uq8 X_uq173 X_uq343 X_uq341
+ A_uq37 SLN[7] A_uq2 SLN[6] A_uq24 X_uq338 X_uq20 X_uq29 SLN[9] X_uq346 X_uq19 X
+ VSS VDD X_uq31 SLN[5] X_uq34 X_uq14 X_uq6 PC X_uq24 X_uq33 X_uq47 X_uq40 X_uq16
+ X_uq35 A A_uq30 X_uq212 X_uq8 X_uq41 X_uq50 X_uq36 X_uq233 X_uq42 X_uq51 X_uq15
+ A_uq44 X_uq57 X_uq243 X_uq4 X_uq52 X_uq65 X_uq339 A_uq65 X_uq244 X_uq5 X_uq53 X_uq48
+ X_uq235 X_uq7 X_uq22 X_uq63 ANALOG_FIGURE
Xpmos$5_0 VEVAL1 VEVAL_IN VEVAL VEVAL_IN pmos$5
Xnmos$6_0 serial_in_data VSS X_uq328 a_26346_66907# nmos$6
Xnmos$6_1 X_uq328 VSS VSS m1_25585_66727# nmos$6
Xnmos$6_2 a_26644_66906# VSS VSS A_uq391 nmos$6
Xnmos$6_3 a_26346_66907# VSS VSS a_26644_66906# nmos$6
X0 Y_uq65 D_uq1 VSS VSS sg13_lv_nmos ad=0.2618p pd=2.22u as=0.1463p ps=1.15u w=0.77u l=0.13u
X1 B_uq38 a_77604_21489# VSS VSS sg13_lv_nmos ad=0.2516p pd=2.16u as=0.1331p ps=1.12u w=0.74u l=0.13u
X2 VSS a_34876_68338# a_34525_68195# VSS sg13_lv_nmos ad=79.8f pd=0.8u as=0.1428p ps=1.52u w=0.42u l=0.13u
X3 a_4613_41738# a_4335_41975# a_4301_41167# VSS sg13_lv_nmos ad=0.2373p pd=1.97u as=79.8f ps=0.8u w=0.42u l=0.13u
X4 a_46234_67806# a_46475_67339# a_45763_67332# VSS sg13_lv_nmos ad=0.1428p pd=1.52u as=0.12665p ps=1.145u w=0.42u l=0.13u
X5 a_33777_68097# clk VSS VSS sg13_lv_nmos ad=0.2516p pd=2.16u as=2.0066p ps=12.72u w=0.74u l=0.13u
X6 X_uq272 a_77887_29041# VSS VSS sg13_lv_nmos ad=0.2886p pd=2.26u as=0.14875p ps=1.16u w=0.74u l=0.13u
X7 VSS a_31349_66194# a_31270_66097# VSS sg13_lv_nmos ad=1.8643p pd=11.96u as=0.27427p ps=2.28u w=0.795u l=0.13u
X8 Y_uq162 C_uq34 VSS VSS sg13_lv_nmos ad=0.2618p pd=2.22u as=0.1463p ps=1.15u w=0.77u l=0.13u
X9 a_42208_9173# X_uq144 Y_uq10 VDD sg13_lv_pmos ad=0.1176p pd=1.33u as=0.3808p ps=2.92u w=1.12u l=0.13u
X10 Y_uq68 D_uq7 VSS VSS sg13_lv_nmos ad=0.1406p pd=1.12u as=0.1406p ps=1.12u w=0.74u l=0.13u
X11 a_77047_25577# B1_uq1 B_uq51 VSS sg13_lv_nmos ad=0.1406p pd=1.12u as=0.2516p ps=2.16u w=0.74u l=0.13u
X12 a_32592_69948# a_32566_69853# VDD VDD sg13_lv_pmos ad=0.34p pd=2.68u as=0.36237p ps=2.605u w=1u l=0.13u
X13 a_43344_65860# a_43863_65867# a_44603_66217# VSS sg13_lv_nmos ad=0.3473p pd=2.71u as=0.12665p ps=1.145u w=0.74u l=0.13u
X14 B_uq76 Y_uq185 a_6591_35227# VSS sg13_lv_nmos ad=0.2516p pd=2.16u as=0.1406p ps=1.12u w=0.74u l=0.15u
X15 VSS a_5932_42743# a_6206_42358# VSS sg13_lv_nmos ad=79.8f pd=0.8u as=0.1428p ps=1.52u w=0.42u l=0.13u
X16 a_32024_67332# Q_uq39 VDD VDD sg13_lv_pmos ad=0.2856p pd=2.36u as=0.2114p ps=1.54u w=0.84u l=0.13u
X17 VDD a_42680_63546# q[18] VDD sg13_lv_pmos ad=0.2114p pd=1.54u as=0.42p ps=2.99u w=1.12u l=0.13u
X18 A_uq75 a_42078_8449# VDD VDD sg13_lv_pmos ad=0.42p pd=2.99u as=0.2114p ps=1.54u w=1.12u l=0.13u
X19 Y_uq185 Y_uq190 a_8133_36024# VSS sg13_lv_nmos ad=0.1406p pd=1.12u as=0.1406p ps=1.12u w=0.74u l=0.13u
X20 VSS a_51992_68844# A_uq37 VSS sg13_lv_nmos ad=0.14875p pd=1.16u as=0.2886p ps=2.26u w=0.74u l=0.13u
X21 C_uq1 A_N VDD VDD sg13_lv_pmos ad=0.2128p pd=1.5u as=0.3808p ps=2.92u w=1.12u l=0.13u
X22 a_29338_64467# a_29080_64782# VDD VDD sg13_lv_pmos ad=93.45f pd=0.865u as=1.4745p ps=9.07u w=0.42u l=0.13u
X23 a_79068_24446# clk VSS VSS sg13_lv_nmos ad=0.2516p pd=2.16u as=4.92377p ps=34.425u w=0.74u l=0.13u
X24 a_9934_41790# a_9594_41669# a_9583_42043# VDD sg13_lv_pmos ad=93.45f pd=0.865u as=0.2048p ps=1.63u w=0.42u l=0.13u
X25 a_3550_40458# clk VDD VDD sg13_lv_pmos ad=0.4088p pd=2.97u as=1.25632p ps=8.01u w=1.12u l=0.13u
X26 a_33744_64769# a_33975_64355# a_33430_64312# VSS sg13_lv_nmos ad=0.2373p pd=1.97u as=79.8f ps=0.8u w=0.42u l=0.13u
X27 VSS a_42058_9891# Y_uq18 VSS sg13_lv_nmos ad=0.17255p pd=1.25u as=0.1406p ps=1.12u w=0.74u l=0.13u
X28 VDD a_37378_7625# X_uq162 VDD sg13_lv_pmos ad=0.2114p pd=1.54u as=0.42p ps=2.99u w=1.12u l=0.13u
X29 a_77699_18383# din[31] VSS VSS sg13_lv_nmos ad=0.187p pd=1.78u as=0.14875p ps=1.16u w=0.55u l=0.13u
X30 a_49718_63880# Q_uq43 Y_uq243 VDD sg13_lv_pmos ad=0.1176p pd=1.33u as=0.3808p ps=2.92u w=1.12u l=0.13u
X31 VDD a_80189_22959# a_80301_23023# VDD sg13_lv_pmos ad=0.2254p pd=1.53u as=0.34p ps=2.68u w=1u l=0.5u
X32 a_41234_69630# a_42039_69752# a_41494_69853# VDD sg13_lv_pmos ad=0.1428p pd=1.52u as=79.8f ps=0.8u w=0.42u l=0.13u
X33 VDD Y_uq230 a_3571_39755# VDD sg13_lv_pmos ad=0.36237p pd=2.605u as=79.8f ps=0.8u w=0.42u l=0.13u
X34 a_36316_66098# L_HI_uq15 VDD VDD sg13_lv_pmos ad=79.8f pd=0.8u as=1.41367p ps=8.85u w=0.42u l=0.13u
X35 VDD a_48070_65062# a_47789_65284# VDD sg13_lv_pmos ad=0.1523p pd=1.38u as=0.34p ps=2.68u w=1u l=0.5u
X36 VSS a_35074_7625# B_uq12 VSS sg13_lv_nmos ad=0.14875p pd=1.16u as=0.2886p ps=2.26u w=0.74u l=0.13u
X37 a_10345_30929# Q_uq9 VDD VDD sg13_lv_pmos ad=0.2856p pd=2.36u as=0.2114p ps=1.54u w=0.84u l=0.13u
X38 C_uq36 a_7321_33423# VSS VSS sg13_lv_nmos ad=0.2351p pd=2.16u as=0.15745p ps=1.175u w=0.74u l=0.13u
X39 a_3962_32832# a_3550_32372# a_3580_33241# VDD sg13_lv_pmos ad=63f pd=0.72u as=79.8f ps=0.8u w=0.42u l=0.13u
X40 a_36336_67806# D_uq55 a_36242_67806# VSS sg13_lv_nmos ad=60.89999f pd=0.71u as=0.1428p ps=1.52u w=0.42u l=0.13u
X41 a_79045_28376# a_78787_28691# VDD VDD sg13_lv_pmos ad=93.45f pd=0.865u as=1.59725p ps=10.05u w=0.42u l=0.13u
X42 VSS Q_uq56 a_33364_63620# VSS sg13_lv_nmos ad=0.14875p pd=1.16u as=0.187p ps=1.78u w=0.55u l=0.13u
X43 VSS C_uq26 a_78208_25253# VSS sg13_lv_nmos ad=0.1045p pd=0.93u as=0.187p ps=1.78u w=0.55u l=0.13u
X44 VDD VSS VDD VDD sg13_lv_pmos ad=0.34p pd=2.68u as=0.45192n ps=1.25532m w=1u l=1u
X45 a_31132_69122# L_HI_uq32 VDD VDD sg13_lv_pmos ad=79.8f pd=0.8u as=1.42837p ps=8.61u w=0.42u l=0.13u
X46 a_80197_23984# a_80312_23983# VSS VSS sg13_lv_nmos ad=0.1428p pd=1.52u as=0.1426p ps=1.16u w=0.42u l=0.5u
X47 a_79982_28300# a_79286_28224# a_80076_28300# VSS sg13_lv_nmos ad=0.1296p pd=1.52u as=79.8f ps=0.8u w=0.42u l=0.13u
X48 VDD a_39622_63550# a_39341_63772# VDD sg13_lv_pmos ad=0.1523p pd=1.38u as=0.34p ps=2.68u w=1u l=0.5u
X49 VSS q[3] a_33918_8449# VSS sg13_lv_nmos ad=0.14875p pd=1.16u as=0.187p ps=1.78u w=0.55u l=0.13u
X50 VSS a_47576_63546# X_uq335 VSS sg13_lv_nmos ad=0.14875p pd=1.16u as=0.2886p ps=2.26u w=0.74u l=0.13u
X51 VDD A_uq97 a_32574_9173# VDD sg13_lv_pmos ad=0.2114p pd=1.54u as=0.2856p ps=2.36u w=0.84u l=0.13u
X52 a_9628_40311# a_9598_40746# a_10010_40686# VDD sg13_lv_pmos ad=79.8f pd=0.8u as=63f ps=0.72u w=0.42u l=0.13u
X53 VSS a_35093_63528# a_35014_63803# VSS sg13_lv_nmos ad=3.5825p pd=23.78u as=0.27427p ps=2.28u w=0.795u l=0.13u
X54 VDD a_42446_10067# A_uq74 VDD sg13_lv_pmos ad=0.2226p pd=1.535u as=0.3976p ps=2.95u w=1.12u l=0.13u
X55 VSS X_uq152 a_39780_9229# VSS sg13_lv_nmos ad=0.17255p pd=1.25u as=0.187p ps=1.78u w=0.55u l=0.13u
X56 X_uq90 a_33918_8449# VSS VSS sg13_lv_nmos ad=0.2886p pd=2.26u as=0.14875p ps=1.16u w=0.74u l=0.13u
X57 a_6893_34952# B_uq81 a_6893_34850# VDD sg13_lv_pmos ad=0.2464p pd=1.56u as=0.2128p ps=1.5u w=1.12u l=0.13u
X58 VSS a_78181_21632# X_uq201 VSS sg13_lv_nmos ad=0.1426p pd=1.16u as=0.2516p ps=2.16u w=0.74u l=0.13u
X59 a_29232_66281# a_28944_65860# a_29170_66281# VSS sg13_lv_nmos ad=0.1428p pd=1.52u as=37.8f ps=0.6u w=0.42u l=0.13u
X60 VSS a_48646_67332# a_48365_67634# VSS sg13_lv_nmos ad=79.8f pd=0.8u as=0.1428p ps=1.52u w=0.42u l=0.5u
X61 a_5809_37466# S_uq0 VDD VDD sg13_lv_pmos ad=0.2856p pd=2.36u as=0.2198p ps=1.53u w=0.84u l=0.13u
X62 Y_uq285 Q_uq49 a_49240_66904# VDD sg13_lv_pmos ad=0.3808p pd=2.92u as=0.1176p ps=1.33u w=1.12u l=0.13u
X63 VSS X_uq147 a_40452_9965# VSS sg13_lv_nmos ad=0.17255p pd=1.25u as=0.187p ps=1.78u w=0.55u l=0.13u
X64 VSS a_42274_10649# B_uq20 VSS sg13_lv_nmos ad=0.14875p pd=1.16u as=0.2886p ps=2.26u w=0.74u l=0.13u
X65 a_10347_42044# clk VDD VDD sg13_lv_pmos ad=0.4088p pd=2.97u as=1.12945p ps=7.155u w=1.12u l=0.13u
X66 a_10010_32928# a_9598_32468# a_9628_33337# VDD sg13_lv_pmos ad=63f pd=0.72u as=79.8f ps=0.8u w=0.42u l=0.13u
X67 a_28118_65392# Q_uq39 Y_uq271 VDD sg13_lv_pmos ad=0.1176p pd=1.33u as=0.3808p ps=2.92u w=1.12u l=0.13u
X68 X_uq220 a_7724_20395# VDD VDD sg13_lv_pmos ad=0.42p pd=2.99u as=0.2114p ps=1.54u w=1.12u l=0.13u
X69 a_77240_27089# Y_uq139 Y_uq142 VSS sg13_lv_nmos ad=0.1406p pd=1.12u as=0.1406p ps=1.12u w=0.74u l=0.13u
X70 a_33360_68436# a_33334_68341# VSS VSS sg13_lv_nmos ad=0.2516p pd=2.16u as=0.1626p ps=1.415u w=0.74u l=0.13u
X71 a_3778_22569# a_3579_22706# VSS VSS sg13_lv_nmos ad=0.27427p pd=2.28u as=1.6335p ps=10.61u w=0.795u l=0.13u
X72 VDD Y_uq219 a_8405_34993# VDD sg13_lv_pmos ad=0.4032p pd=2.96u as=0.1176p ps=1.33u w=1.12u l=0.13u
X73 X_uq69 a_32766_8449# VSS VSS sg13_lv_nmos ad=0.2886p pd=2.26u as=0.14875p ps=1.16u w=0.74u l=0.13u
X74 VSS X_uq251 A2_uq3 VSS sg13_lv_nmos ad=0.2516p pd=2.16u as=0.1406p ps=1.12u w=0.74u l=0.13u
X75 VSS X_uq435 Y_uq276 VSS sg13_lv_nmos ad=0.2618p pd=2.22u as=0.1694p ps=1.21u w=0.77u l=0.13u
X76 VDD Y_uq189 a_5092_34839# VDD sg13_lv_pmos ad=0.1563p pd=1.22u as=0.147p ps=1.54u w=0.42u l=0.13u
X77 a_6559_42573# a_6570_42533# a_6559_42907# VSS sg13_lv_nmos ad=0.3473p pd=2.71u as=0.12665p ps=1.145u w=0.74u l=0.13u
X78 VSS X_uq436 Y_uq270 VSS sg13_lv_nmos ad=0.2618p pd=2.22u as=0.1694p ps=1.21u w=0.77u l=0.13u
X79 a_43253_68064# a_43377_68161# VDD VDD sg13_lv_pmos ad=0.2442p pd=2.06u as=1.42837p ps=8.61u w=0.66u l=0.13u
X80 C_uq72 X_uq455 VSS VSS sg13_lv_nmos ad=0.1406p pd=1.12u as=0.2516p ps=2.16u w=0.74u l=0.13u
X81 a_5129_41075# X_uq324 a_5073_40834# VSS sg13_lv_nmos ad=81.6f pd=0.895u as=0.1216p ps=1.02u w=0.64u l=0.13u
X82 VDD X_uq137 a_44868_10301# VDD sg13_lv_pmos ad=0.2226p pd=1.535u as=0.1596p ps=1.22u w=0.84u l=0.13u
X83 B_uq81 a_5809_35317# VSS VSS sg13_lv_nmos ad=0.2516p pd=2.16u as=0.1426p ps=1.16u w=0.74u l=0.13u
X84 VDD Y_uq185 B_uq76 VDD sg13_lv_pmos ad=0.3808p pd=2.92u as=0.2128p ps=1.5u w=1.12u l=0.15u
X85 a_38530_8375# A_uq24 VSS VSS sg13_lv_nmos ad=0.187p pd=1.78u as=0.14875p ps=1.16u w=0.55u l=0.13u
X86 VSS B_uq68 a_76477_27517# VSS sg13_lv_nmos ad=0.2516p pd=2.16u as=0.1406p ps=1.12u w=0.74u l=0.13u
X87 VSS a_45826_10649# B_uq17 VSS sg13_lv_nmos ad=0.14875p pd=1.16u as=0.2886p ps=2.26u w=0.74u l=0.13u
X88 a_30033_67379# clk VSS VSS sg13_lv_nmos ad=0.2516p pd=2.16u as=2.0066p ps=12.72u w=0.74u l=0.13u
X89 a_29842_67793# L_HI_uq25 VSS VSS sg13_lv_nmos ad=37.8f pd=0.6u as=0.1701p ps=1.65u w=0.42u l=0.13u
X90 a_42417_63625# a_42417_63625# VSS VSS sg13_lv_nmos ad=0.111p pd=1.34u as=3.5825p ps=23.78u w=0.3u l=0.13u
X91 a_8869_32796# B_uq74 a_8869_32682# VDD sg13_lv_pmos ad=0.2128p pd=1.5u as=0.2464p ps=1.56u w=1.12u l=0.13u
X92 a_51144_65058# a_51275_65364# a_50563_65058# VDD sg13_lv_pmos ad=0.34p pd=2.68u as=0.2048p ps=1.63u w=1u l=0.13u
X93 a_4333_38353# B_uq92 Y_uq229 VDD sg13_lv_pmos ad=0.1176p pd=1.33u as=0.3808p ps=2.92u w=1.12u l=0.13u
X94 a_7321_32575# Y_uq162 VDD VDD sg13_lv_pmos ad=0.1428p pd=1.52u as=0.1523p ps=1.38u w=0.42u l=0.13u
X95 a_29616_68884# a_29590_68848# VSS VSS sg13_lv_nmos ad=0.2516p pd=2.16u as=0.1626p ps=1.415u w=0.74u l=0.13u
X96 VDD a_35002_69819# X_uq454 VDD sg13_lv_pmos ad=0.2254p pd=1.53u as=0.4256p ps=3u w=1.12u l=0.13u
X97 VDD Q_uq52 a_44884_66644# VDD sg13_lv_pmos ad=0.2114p pd=1.54u as=0.2856p ps=2.36u w=0.84u l=0.13u
X98 a_41746_69643# L_HI_uq36 VSS VSS sg13_lv_nmos ad=37.8f pd=0.6u as=0.1701p ps=1.65u w=0.42u l=0.13u
X99 a_38908_66098# a_38651_66217# a_39070_66294# VSS sg13_lv_nmos ad=0.1428p pd=1.52u as=37.8f ps=0.6u w=0.42u l=0.13u
X100 a_36160_8709# A_uq98 Y_uq5 VDD sg13_lv_pmos ad=0.1176p pd=1.33u as=0.3808p ps=2.92u w=1.12u l=0.13u
X101 a_76939_20229# A1 VDD VDD sg13_lv_pmos ad=0.2128p pd=1.5u as=0.3808p ps=2.92u w=1.12u l=0.13u
X102 VSS a_45944_63546# q[20] VSS sg13_lv_nmos ad=0.14875p pd=1.16u as=0.2886p ps=2.26u w=0.74u l=0.13u
X103 a_34608_66294# D_uq45 a_34514_66294# VSS sg13_lv_nmos ad=60.89999f pd=0.71u as=0.1428p ps=1.52u w=0.42u l=0.13u
X104 VSS din[0] a_76063_26741# VSS sg13_lv_nmos ad=0.14875p pd=1.16u as=0.187p ps=1.78u w=0.55u l=0.13u
X105 a_8992_37758# a_8871_37079# a_8833_38292# VDD sg13_lv_pmos ad=93.45f pd=0.865u as=0.2048p ps=1.63u w=0.42u l=0.13u
X106 a_3550_40458# clk VSS VSS sg13_lv_nmos ad=0.2516p pd=2.16u as=4.345p ps=28.205u w=0.74u l=0.13u
X107 a_6559_42907# a_6574_41610# a_6559_42573# VDD sg13_lv_pmos ad=0.2048p pd=1.63u as=0.34p ps=2.68u w=1u l=0.13u
X108 a_41627_66217# a_40785_65867# a_40368_65860# VDD sg13_lv_pmos ad=0.2048p pd=1.63u as=0.34p ps=2.68u w=1u l=0.13u
X109 VSS a_9583_39451# a_9583_39834# VSS sg13_lv_nmos ad=0.1406p pd=1.12u as=0.2516p ps=2.16u w=0.74u l=0.13u
X110 L_HI_uq12 a_31818_63834# VDD VDD sg13_lv_pmos ad=0.3927p pd=2.99u as=1.4745p ps=9.07u w=1.155u l=0.13u
X111 a_79043_25943# X_uq250 VDD VDD sg13_lv_pmos ad=0.2856p pd=2.36u as=0.2114p ps=1.54u w=0.84u l=0.13u
X112 a_8103_36475# Y_uq207 VSS VSS sg13_lv_nmos ad=0.1406p pd=1.12u as=0.1406p ps=1.12u w=0.74u l=0.15u
X113 Y_uq104 Q_uq2 VSS VSS sg13_lv_nmos ad=0.2516p pd=2.16u as=0.2516p ps=2.16u w=0.74u l=0.13u
X114 B_uq26 a_36606_10685# VSS VSS sg13_lv_nmos ad=0.2886p pd=2.26u as=0.14875p ps=1.16u w=0.74u l=0.13u
X115 VDD a_9583_42043# a_9583_42426# VDD sg13_lv_pmos ad=0.2128p pd=1.5u as=0.3864p ps=2.93u w=1.12u l=0.13u
X116 Q_uq34 a_39318_65856# VDD VDD sg13_lv_pmos ad=0.3808p pd=2.92u as=0.2128p ps=1.5u w=1.12u l=0.13u
X117 VDD a_5051_43135# a_5087_43067# VDD sg13_lv_pmos ad=0.1523p pd=1.38u as=0.34p ps=2.68u w=1u l=0.5u
X118 VSS a_31925_66552# a_31846_66827# VSS sg13_lv_nmos ad=1.8643p pd=11.96u as=0.27427p ps=2.28u w=0.795u l=0.13u
X119 VDD a_80675_28967# B_uq70 VDD sg13_lv_pmos ad=0.2114p pd=1.54u as=0.42p ps=2.99u w=1.12u l=0.13u
X120 a_36528_67372# a_36502_67336# VSS VSS sg13_lv_nmos ad=0.2516p pd=2.16u as=0.1626p ps=1.415u w=0.74u l=0.13u
X121 VSS C_uq21 Y_uq36 VSS sg13_lv_nmos ad=0.2516p pd=2.16u as=0.1406p ps=1.12u w=0.74u l=0.13u
X122 a_9628_37719# a_9598_38154# a_9619_37451# VSS sg13_lv_nmos ad=79.8f pd=0.8u as=0.1296p ps=1.52u w=0.42u l=0.13u
X123 Y_uq97 C_uq20 VSS VSS sg13_lv_nmos ad=0.1694p pd=1.21u as=0.1463p ps=1.15u w=0.77u l=0.13u
X124 VDD a_29138_63586# a_29250_63650# VDD sg13_lv_pmos ad=0.2254p pd=1.53u as=0.34p ps=2.68u w=1u l=0.5u
X125 a_32585_64344# C_uq46 Y_uq269 VDD sg13_lv_pmos ad=0.2128p pd=1.5u as=0.3808p ps=2.92u w=1.12u l=0.13u
X126 a_30768_65107# a_30480_65412# a_30706_65107# VSS sg13_lv_nmos ad=0.1428p pd=1.52u as=37.8f ps=0.6u w=0.42u l=0.13u
X127 D_uq0 C_uq29 VSS VSS sg13_lv_nmos ad=0.1694p pd=1.21u as=0.1463p ps=1.15u w=0.77u l=0.13u
X128 a_51334_65820# Q_uq52 VDD VDD sg13_lv_pmos ad=0.1428p pd=1.52u as=0.1523p ps=1.38u w=0.42u l=0.13u
X129 a_33777_68097# clk VDD VDD sg13_lv_pmos ad=0.4088p pd=2.97u as=1.39265p ps=8.395u w=1.12u l=0.13u
X130 a_79045_22643# a_79286_22176# a_78574_22169# VSS sg13_lv_nmos ad=0.1428p pd=1.52u as=0.12665p ps=1.145u w=0.42u l=0.13u
X131 a_3594_24581# D_uq8 VDD VDD sg13_lv_pmos ad=79.8f pd=0.8u as=0.1428p ps=1.52u w=0.42u l=0.13u
X132 a_43426_10649# X_uq335 VDD VDD sg13_lv_pmos ad=0.2856p pd=2.36u as=0.2114p ps=1.54u w=0.84u l=0.13u
X133 VDD S_uq0 a_5869_40067# VDD sg13_lv_pmos ad=0.253p pd=1.53u as=0.3325p ps=1.665u w=1u l=0.13u
X134 a_44470_68848# a_44913_68891# a_44210_69318# VSS sg13_lv_nmos ad=79.8f pd=0.8u as=0.1296p ps=1.52u w=0.42u l=0.13u
X135 a_32949_70021# a_32592_69948# VDD VDD sg13_lv_pmos ad=63f pd=0.72u as=0.1563p ps=1.22u w=0.42u l=0.13u
X136 VSS a_52661_66194# a_52582_66097# VSS sg13_lv_nmos ad=1.8643p pd=11.96u as=0.27427p ps=2.28u w=0.795u l=0.13u
X137 a_76171_27517# Y_uq149 VSS VSS sg13_lv_nmos ad=0.1406p pd=1.12u as=0.1406p ps=1.12u w=0.74u l=0.13u
X138 a_79068_24446# clk VDD VDD sg13_lv_pmos ad=0.4088p pd=2.97u as=1.59725p ps=10.05u w=1.12u l=0.13u
X139 VSS Q_uq43 Y_uq335 VSS sg13_lv_nmos ad=0.2516p pd=2.16u as=0.2516p ps=2.16u w=0.74u l=0.13u
X140 VDD a_80167_26983# a_80112_26864# VDD sg13_lv_pmos ad=2.04445p pd=13.405u as=93.45f ps=0.865u w=0.42u l=0.13u
X141 VDD X_uq137 a_45444_9149# VDD sg13_lv_pmos ad=0.2226p pd=1.535u as=0.1596p ps=1.22u w=0.84u l=0.13u
X142 a_28408_65856# a_28186_65912# VDD VDD sg13_lv_pmos ad=0.1176p pd=1.33u as=0.2618p ps=1.63u w=1.12u l=0.13u
X143 VDD a_42417_64355# a_42519_64355# VDD sg13_lv_pmos ad=1.4745p pd=9.07u as=0.3864p ps=2.93u w=1.12u l=0.13u
X144 a_37968_64348# a_37942_64312# VSS VSS sg13_lv_nmos ad=0.2516p pd=2.16u as=0.1626p ps=1.415u w=0.74u l=0.13u
X145 VSS VDD VSS VSS sg13_lv_nmos ad=79.8f pd=0.8u as=15.56817p ps=-2.87097m w=0.42u l=1u
X146 VSS X_uq446 a_49018_66648# VSS sg13_lv_nmos ad=0.17255p pd=1.25u as=0.187p ps=1.78u w=0.55u l=0.13u
X147 a_33456_64348# a_33975_64355# a_34715_64705# VSS sg13_lv_nmos ad=0.3473p pd=2.71u as=0.12665p ps=1.145u w=0.74u l=0.13u
X148 VDD a_49019_69707# a_49686_69928# VDD sg13_lv_pmos ad=0.2128p pd=1.5u as=0.3864p ps=2.93u w=1.12u l=0.13u
X149 VSS A_uq97 a_32574_9173# VSS sg13_lv_nmos ad=0.14875p pd=1.16u as=0.187p ps=1.78u w=0.55u l=0.13u
X150 B_uq64 Q_uq5 a_5840_25655# VDD sg13_lv_pmos ad=0.3808p pd=2.92u as=0.1176p ps=1.33u w=1.12u l=0.13u
X151 VDD a_8075_38617# X_uq305 VDD sg13_lv_pmos ad=0.2254p pd=1.53u as=0.4256p ps=3u w=1.12u l=0.13u
X152 Y_uq358 Q_uq53 VSS VSS sg13_lv_nmos ad=0.2516p pd=2.16u as=0.2516p ps=2.16u w=0.74u l=0.13u
X153 VSS a_29045_69218# a_28966_69121# VSS sg13_lv_nmos ad=2.01085p pd=12.81u as=0.27427p ps=2.28u w=0.795u l=0.13u
X154 VDD a_5523_21946# a_5780_22089# VDD sg13_lv_pmos ad=1.37097p pd=8.54u as=79.8f ps=0.8u w=0.42u l=0.13u
X155 VDD a_39226_63771# X_uq376 VDD sg13_lv_pmos ad=0.2254p pd=1.53u as=0.4256p ps=3u w=1.12u l=0.13u
X156 C_uq58 X_uq450 VSS VSS sg13_lv_nmos ad=0.1406p pd=1.12u as=0.2516p ps=2.16u w=0.74u l=0.13u
X157 a_39646_64782# L_HI_uq11 VSS VSS sg13_lv_nmos ad=37.8f pd=0.6u as=79.8f ps=0.8u w=0.42u l=0.13u
X158 Y_uq174 X_uq297 VDD VDD sg13_lv_pmos ad=0.3808p pd=2.92u as=0.3808p ps=2.92u w=1.12u l=0.13u
X159 a_7321_32187# a_7345_32295# VDD VDD sg13_lv_pmos ad=0.34p pd=2.68u as=0.2254p ps=1.53u w=1u l=0.5u
X160 a_36048_69630# D_uq63 a_35954_69630# VSS sg13_lv_nmos ad=60.89999f pd=0.71u as=0.1428p ps=1.52u w=0.42u l=0.13u
X161 VSS a_8071_33019# a_8071_33402# VSS sg13_lv_nmos ad=0.1406p pd=1.12u as=0.2516p ps=2.16u w=0.74u l=0.13u
X162 C_uq54 X_uq399 VSS VSS sg13_lv_nmos ad=0.1406p pd=1.12u as=0.2516p ps=2.16u w=0.74u l=0.13u
X163 a_44248_65392# X_uq397 C_uq48 VDD sg13_lv_pmos ad=0.1176p pd=1.33u as=0.3808p ps=2.92u w=1.12u l=0.13u
X164 a_79155_22566# a_79286_22176# a_78574_22169# VDD sg13_lv_pmos ad=0.34p pd=2.68u as=0.2048p ps=1.63u w=1u l=0.13u
X165 a_7261_23696# a_6319_23503# a_7059_23458# VDD sg13_lv_pmos ad=93.45f pd=0.865u as=0.2048p ps=1.63u w=0.42u l=0.13u
X166 a_3580_35319# a_3550_35754# a_3571_35051# VSS sg13_lv_nmos ad=79.8f pd=0.8u as=0.1296p ps=1.52u w=0.42u l=0.13u
X167 a_3625_22167# X_uq259 VDD VDD sg13_lv_pmos ad=0.2464p pd=1.56u as=0.3808p ps=2.92u w=1.12u l=0.13u
X168 D_uq42 C_uq47 VSS VSS sg13_lv_nmos ad=0.2618p pd=2.22u as=0.1463p ps=1.15u w=0.77u l=0.13u
X169 a_28310_66904# X_uq420 VDD VDD sg13_lv_pmos ad=0.1176p pd=1.33u as=0.4032p ps=2.96u w=1.12u l=0.13u
X170 a_5398_32766# a_5058_32645# a_5047_33019# VDD sg13_lv_pmos ad=93.45f pd=0.865u as=0.2048p ps=1.63u w=0.42u l=0.13u
X171 X_uq20 a_38622_6937# VSS VSS sg13_lv_nmos ad=0.2886p pd=2.26u as=0.14875p ps=1.16u w=0.74u l=0.13u
X172 a_5968_42654# a_5847_41975# a_5809_43188# VDD sg13_lv_pmos ad=93.45f pd=0.865u as=0.2048p ps=1.63u w=0.42u l=0.13u
X173 L_HI_uq17 a_52266_66858# VDD VDD sg13_lv_pmos ad=0.3927p pd=2.99u as=1.19383p ps=7.16u w=1.155u l=0.13u
X174 VDD a_28064_67332# a_28022_67368# VDD sg13_lv_pmos ad=0.2618p pd=1.63u as=0.1176p ps=1.33u w=1.12u l=0.13u
X175 VSS X_uq426 a_48148_68880# VSS sg13_lv_nmos ad=0.14875p pd=1.16u as=0.187p ps=1.78u w=0.55u l=0.13u
X176 X_uq36 a_32478_6937# VSS VSS sg13_lv_nmos ad=0.2886p pd=2.26u as=0.14875p ps=1.16u w=0.74u l=0.13u
X177 a_8405_34993# D_uq30 Y_uq176 VDD sg13_lv_pmos ad=0.1176p pd=1.33u as=0.3808p ps=2.92u w=1.12u l=0.13u
X178 VSS Y_uq337 D_uq61 VSS sg13_lv_nmos ad=0.1463p pd=1.15u as=0.1694p ps=1.21u w=0.77u l=0.13u
X179 Y_uq20 a_40452_9965# VSS VSS sg13_lv_nmos ad=0.1406p pd=1.12u as=0.17255p ps=1.25u w=0.74u l=0.13u
X180 VSS a_7346_24410# X_uq237 VSS sg13_lv_nmos ad=0.1426p pd=1.16u as=0.2516p ps=2.16u w=0.74u l=0.13u
X181 VDD a_78455_20980# Q_uq6 VDD sg13_lv_pmos ad=0.2128p pd=1.5u as=0.3808p ps=2.92u w=1.12u l=0.13u
X182 a_35202_9173# a_34980_9229# VDD VDD sg13_lv_pmos ad=0.1176p pd=1.33u as=0.2618p ps=1.63u w=1.12u l=0.13u
X183 VDD a_39490_7625# X_uq52 VDD sg13_lv_pmos ad=0.2114p pd=1.54u as=0.42p ps=2.99u w=1.12u l=0.13u
X184 D_uq38 a_41442_65162# VDD VDD sg13_lv_pmos ad=0.4256p pd=3u as=0.2254p ps=1.53u w=1.12u l=0.13u
X185 C_uq58 X_uq412 a_48758_66904# VDD sg13_lv_pmos ad=0.3808p pd=2.92u as=0.1176p ps=1.33u w=1.12u l=0.13u
X186 C_uq71 X_uq454 a_33974_68880# VDD sg13_lv_pmos ad=0.3808p pd=2.92u as=0.1176p ps=1.33u w=1.12u l=0.13u
X187 a_7705_34702# B_uq80 VSS VSS sg13_lv_nmos ad=0.1216p pd=1.02u as=0.1331p ps=1.12u w=0.64u l=0.13u
X188 VDD Y_uq54 a_10193_20111# VDD sg13_lv_pmos ad=0.2114p pd=1.54u as=0.2856p ps=2.36u w=0.84u l=0.13u
X189 a_32400_69630# D_uq64 a_32306_69630# VSS sg13_lv_nmos ad=60.89999f pd=0.71u as=0.1428p ps=1.52u w=0.42u l=0.13u
X190 VSS Q_uq3 a_77807_22959# VSS sg13_lv_nmos ad=79.8f pd=0.8u as=0.1428p ps=1.52u w=0.42u l=0.13u
X191 VDD a_43138_7625# X_uq61 VDD sg13_lv_pmos ad=0.2114p pd=1.54u as=0.42p ps=2.99u w=1.12u l=0.13u
X192 VDD a_40474_66795# D_uq48 VDD sg13_lv_pmos ad=0.2254p pd=1.53u as=0.4256p ps=3u w=1.12u l=0.13u
X193 VSS X_uq315 Y_uq209 VSS sg13_lv_nmos ad=0.2516p pd=2.16u as=0.1406p ps=1.12u w=0.74u l=0.13u
X194 VSS a_30586_63771# X_uq406 VSS sg13_lv_nmos ad=0.1426p pd=1.16u as=0.2516p ps=2.16u w=0.74u l=0.13u
X195 VDD a_43810_10649# B_uq18 VDD sg13_lv_pmos ad=0.2114p pd=1.54u as=0.42p ps=2.99u w=1.12u l=0.13u
X196 a_11763_22671# C_uq21 VDD VDD sg13_lv_pmos ad=0.1176p pd=1.33u as=0.4032p ps=2.96u w=1.12u l=0.13u
X197 VSS VDD VSS VSS sg13_lv_nmos ad=0.1428p pd=1.52u as=0 ps=-0 w=0.42u l=1u
X198 a_4168_24568# a_4399_24154# a_3854_24111# VSS sg13_lv_nmos ad=0.2373p pd=1.97u as=79.8f ps=0.8u w=0.42u l=0.13u
X199 a_44998_68086# Y_uq319 VDD VDD sg13_lv_pmos ad=0.1428p pd=1.52u as=0.1523p ps=1.38u w=0.42u l=0.13u
X200 VDD VSS VDD VDD sg13_lv_pmos ad=0.34p pd=2.68u as=0 ps=0 w=1u l=1u
X201 a_3584_40329# a_3535_41421# a_3584_40267# VSS sg13_lv_nmos ad=0.1428p pd=1.52u as=37.8f ps=0.6u w=0.42u l=0.13u
X202 VDD X_uq449 a_43738_68936# VDD sg13_lv_pmos ad=0.2618p pd=1.63u as=0.2856p ps=2.36u w=0.84u l=0.13u
X203 VDD D_uq62 a_40451_68927# VDD sg13_lv_pmos ad=0.1428p pd=1.52u as=79.8f ps=0.8u w=0.42u l=0.13u
X204 a_51107_66997# D_uq47 a_51854_66606# VSS sg13_lv_nmos ad=0.1428p pd=1.52u as=60.89999f ps=0.71u w=0.42u l=0.13u
X205 a_11104_25695# C_uq22 a_10990_25695# VDD sg13_lv_pmos ad=0.2128p pd=1.5u as=0.2464p ps=1.56u w=1.12u l=0.13u
X206 VSS B_uq33 a_10372_19391# VSS sg13_lv_nmos ad=0.14505p pd=1.15u as=0.187p ps=1.78u w=0.55u l=0.13u
X207 a_42000_64348# a_41974_64312# VSS VSS sg13_lv_nmos ad=0.2516p pd=2.16u as=0.1626p ps=1.415u w=0.74u l=0.13u
X208 VSS a_6563_39963# X_uq312 VSS sg13_lv_nmos ad=0.148p pd=1.14u as=0.4033p ps=2.57u w=0.74u l=0.13u
X209 X_uq22 a_37854_6937# VDD VDD sg13_lv_pmos ad=0.42p pd=2.99u as=0.2114p ps=1.54u w=1.12u l=0.13u
X210 VSS Q_uq44 Y_uq326 VSS sg13_lv_nmos ad=0.2516p pd=2.16u as=0.1406p ps=1.12u w=0.74u l=0.13u
X211 D_uq4 C_uq29 VSS VSS sg13_lv_nmos ad=0.1406p pd=1.12u as=0.2516p ps=2.16u w=0.74u l=0.13u
X212 D_uq10 A2_uq3 VSS VSS sg13_lv_nmos ad=0.1694p pd=1.21u as=0.2618p ps=2.22u w=0.77u l=0.13u
X213 Y_uq197 X_uq297 VDD VDD sg13_lv_pmos ad=0.3808p pd=2.92u as=0.3808p ps=2.92u w=1.12u l=0.13u
X214 a_79619_21407# B_uq68 VSS VSS sg13_lv_nmos ad=0.187p pd=1.78u as=0.14875p ps=1.16u w=0.55u l=0.13u
X215 Y_uq72 X_uq222 VSS VSS sg13_lv_nmos ad=0.2516p pd=2.16u as=0.2516p ps=2.16u w=0.74u l=0.13u
X216 VDD a_45932_64631# Q_uq32 VDD sg13_lv_pmos ad=0.2128p pd=1.5u as=0.3808p ps=2.92u w=1.12u l=0.13u
X217 a_5800_23699# a_5774_23604# VSS VSS sg13_lv_nmos ad=0.2516p pd=2.16u as=0.1626p ps=1.415u w=0.74u l=0.13u
X218 a_43678_64782# L_HI_uq10 VSS VSS sg13_lv_nmos ad=37.8f pd=0.6u as=79.8f ps=0.8u w=0.42u l=0.13u
X219 Q_uq21 a_9583_42426# VSS VSS sg13_lv_nmos ad=0.2516p pd=2.16u as=0.1406p ps=1.12u w=0.74u l=0.13u
X220 a_47387_66217# a_46545_65867# a_46128_65860# VDD sg13_lv_pmos ad=0.2048p pd=1.63u as=0.34p ps=2.68u w=1u l=0.13u
X221 VSS X_uq239 a_9329_24647# VSS sg13_lv_nmos ad=0.14875p pd=1.16u as=0.187p ps=1.78u w=0.55u l=0.13u
X222 X_uq236 a_8561_20899# VSS VSS sg13_lv_nmos ad=0.2886p pd=2.26u as=0.14875p ps=1.16u w=0.74u l=0.13u
X223 VDD a_44938_10649# a_44896_10685# VDD sg13_lv_pmos ad=0.2618p pd=1.63u as=0.1176p ps=1.33u w=1.12u l=0.13u
X224 VSS a_4681_21848# a_4783_21991# VSS sg13_lv_nmos ad=2.0486p pd=12.405u as=0.2516p ps=2.16u w=0.74u l=0.13u
X225 VSS B_uq42 Y_uq84 VSS sg13_lv_nmos ad=0.1463p pd=1.15u as=0.1694p ps=1.21u w=0.77u l=0.13u
X226 VDD a_8956_42551# a_8992_42462# VDD sg13_lv_pmos ad=1.5243p pd=9.795u as=93.45f ps=0.865u w=0.42u l=0.13u
X227 VDD a_37934_9489# X_uq84 VDD sg13_lv_pmos ad=0.2226p pd=1.535u as=0.3976p ps=2.95u w=1.12u l=0.13u
X228 VSS a_4297_34356# a_4297_34458# VSS sg13_lv_nmos ad=0.1406p pd=1.12u as=0.2516p ps=2.16u w=0.74u l=0.13u
X229 a_5514_24893# a_6319_25015# a_5774_25116# VDD sg13_lv_pmos ad=0.1428p pd=1.52u as=79.8f ps=0.8u w=0.42u l=0.13u
X230 X_uq242 a_75295_25229# VDD VDD sg13_lv_pmos ad=0.42p pd=2.99u as=0.2114p ps=1.54u w=1.12u l=0.13u
X231 a_3571_33467# a_3550_32372# a_3580_33241# VSS sg13_lv_nmos ad=0.1296p pd=1.52u as=79.8f ps=0.8u w=0.42u l=0.13u
X232 VSS a_44866_6863# X_uq4 VSS sg13_lv_nmos ad=0.14875p pd=1.16u as=0.2886p ps=2.26u w=0.74u l=0.13u
X233 D_uq4 B_uq48 a_78113_24765# VDD sg13_lv_pmos ad=0.3808p pd=2.92u as=0.1176p ps=1.33u w=1.12u l=0.13u
X234 Y_uq253 Q_uq48 VSS VSS sg13_lv_nmos ad=0.1406p pd=1.12u as=0.2516p ps=2.16u w=0.74u l=0.13u
X235 VSS B_uq78 Y_uq180 VSS sg13_lv_nmos ad=0.2618p pd=2.22u as=0.1694p ps=1.21u w=0.77u l=0.13u
X236 a_28562_69630# a_29367_69752# a_28822_69853# VDD sg13_lv_pmos ad=0.1428p pd=1.52u as=79.8f ps=0.8u w=0.42u l=0.13u
X237 a_41218_8375# Y_uq16 VDD VDD sg13_lv_pmos ad=0.2856p pd=2.36u as=0.2114p ps=1.54u w=0.84u l=0.13u
X238 VSS L_HI_uq31 a_49584_68118# VSS sg13_lv_nmos ad=0.1626p pd=1.415u as=60.89999f ps=0.71u w=0.42u l=0.13u
X239 VSS VDD VSS VSS sg13_lv_nmos ad=79.8f pd=0.8u as=0 ps=-0 w=0.42u l=1u
X240 VSS VDD VSS VSS sg13_lv_nmos ad=0.1428p pd=1.52u as=0 ps=-0 w=0.42u l=1u
X241 a_28944_65860# a_28918_65824# VDD VDD sg13_lv_pmos ad=0.34p pd=2.68u as=0.36237p ps=2.605u w=1u l=0.13u
X242 VDD a_42926_10067# A_uq72 VDD sg13_lv_pmos ad=0.2226p pd=1.535u as=0.3976p ps=2.95u w=1.12u l=0.13u
X243 a_33850_65283# a_33965_65284# VDD VDD sg13_lv_pmos ad=0.34p pd=2.68u as=0.2254p ps=1.53u w=1u l=0.5u
X244 VDD a_5051_41791# a_5087_41723# VDD sg13_lv_pmos ad=0.1523p pd=1.38u as=0.34p ps=2.68u w=1u l=0.5u
X245 X_uq173 a_8561_17875# VDD VDD sg13_lv_pmos ad=0.42p pd=2.99u as=0.2114p ps=1.54u w=1.12u l=0.13u
X246 a_32312_66570# Y_uq339 VDD VDD sg13_lv_pmos ad=0.2856p pd=2.36u as=0.2114p ps=1.54u w=0.84u l=0.13u
X247 VDD X_uq432 a_34804_68880# VDD sg13_lv_pmos ad=0.2114p pd=1.54u as=0.2856p ps=2.36u w=0.84u l=0.13u
X248 VDD Y_uq231 a_10428_41738# VDD sg13_lv_pmos ad=0.36237p pd=2.605u as=79.8f ps=0.8u w=0.42u l=0.13u
X249 a_79982_20740# D_uq0 a_80729_21131# VSS sg13_lv_nmos ad=0.1428p pd=1.52u as=60.89999f ps=0.71u w=0.42u l=0.13u
X250 VDD a_40545_68927# a_39624_69241# VDD sg13_lv_pmos ad=0.36237p pd=2.605u as=0.34p ps=2.68u w=1u l=0.13u
X251 a_49438_69630# L_HI_uq34 VSS VSS sg13_lv_nmos ad=37.8f pd=0.6u as=79.8f ps=0.8u w=0.42u l=0.13u
X252 C_uq19 a_9329_24647# VSS VSS sg13_lv_nmos ad=0.2886p pd=2.26u as=0.14875p ps=1.16u w=0.74u l=0.13u
X253 VSS a_50444_65269# Q_uq43 VSS sg13_lv_nmos ad=0.1406p pd=1.12u as=0.2516p ps=2.16u w=0.74u l=0.13u
X254 VSS Q_uq19 a_6591_38491# VSS sg13_lv_nmos ad=0.1406p pd=1.12u as=0.2516p ps=2.16u w=0.74u l=0.15u
X255 X_uq275 a_76735_29041# VSS VSS sg13_lv_nmos ad=0.2886p pd=2.26u as=0.14875p ps=1.16u w=0.74u l=0.13u
X256 Q_uq36 a_45270_65856# VSS VSS sg13_lv_nmos ad=0.2516p pd=2.16u as=0.1406p ps=1.12u w=0.74u l=0.13u
X257 X_uq56 a_32862_7661# VDD VDD sg13_lv_pmos ad=0.42p pd=2.99u as=0.2114p ps=1.54u w=1.12u l=0.13u
X258 a_9227_34047# X_uq286 VSS VSS sg13_lv_nmos ad=88.8f pd=0.98u as=0.15245p ps=1.17u w=0.74u l=0.13u
X259 VDD X_uq304 a_4297_37910# VDD sg13_lv_pmos ad=0.2198p pd=1.53u as=0.2856p ps=2.36u w=0.84u l=0.13u
X260 VSS X_uq404 Y_uq281 VSS sg13_lv_nmos ad=0.2516p pd=2.16u as=0.1406p ps=1.12u w=0.74u l=0.13u
X261 VDD a_50938_66123# X_uq383 VDD sg13_lv_pmos ad=0.2254p pd=1.53u as=0.4256p ps=3u w=1.12u l=0.13u
X262 a_78365_24467# a_79170_24589# a_78625_24690# VDD sg13_lv_pmos ad=0.1428p pd=1.52u as=79.8f ps=0.8u w=0.42u l=0.13u
X263 a_30471_64391# a_29579_64315# a_30369_64391# VDD sg13_lv_pmos ad=63f pd=0.72u as=79.8f ps=0.8u w=0.42u l=0.13u
X264 a_9619_33563# Y_uq165 VDD VDD sg13_lv_pmos ad=79.8f pd=0.8u as=0.36237p ps=2.605u w=0.42u l=0.13u
X265 VDD a_41884_66098# a_41829_65979# VDD sg13_lv_pmos ad=1.41367p pd=8.85u as=93.45f ps=0.865u w=0.42u l=0.13u
X266 VDD VSS VDD VDD sg13_lv_pmos ad=0.19p pd=1.38u as=0 ps=0 w=1u l=1u
X267 X_uq319 a_3535_34847# VDD VDD sg13_lv_pmos ad=0.42p pd=2.99u as=0.2114p ps=1.54u w=1.12u l=0.13u
X268 VSS B_uq91 Y_uq219 VSS sg13_lv_nmos ad=0.2516p pd=2.16u as=0.1406p ps=1.12u w=0.74u l=0.13u
X269 VDD X_uq88 a_36900_9229# VDD sg13_lv_pmos ad=0.2618p pd=1.63u as=0.2856p ps=2.36u w=0.84u l=0.13u
X270 a_46179_65392# Y_uq260 a_46065_65392# VDD sg13_lv_pmos ad=0.2128p pd=1.5u as=0.2464p ps=1.56u w=1.12u l=0.13u
X271 a_40474_66795# a_40589_66796# VSS VSS sg13_lv_nmos ad=0.1428p pd=1.52u as=0.1426p ps=1.16u w=0.42u l=0.5u
X272 a_49778_65098# a_49508_65098# VDD VDD sg13_lv_pmos ad=0.34p pd=2.68u as=0.1523p ps=1.38u w=1u l=0.5u
X273 VDD a_9628_33337# a_9583_31905# VDD sg13_lv_pmos ad=0.36237p pd=2.605u as=0.34p ps=2.68u w=1u l=0.13u
X274 a_52582_68086# Q_uq49 VDD VDD sg13_lv_pmos ad=0.1428p pd=1.52u as=0.1523p ps=1.38u w=0.42u l=0.13u
X275 a_11365_21623# A_N a_11263_21623# VDD sg13_lv_pmos ad=0.2128p pd=1.5u as=0.2128p ps=1.5u w=1.12u l=0.13u
X276 Y_uq98 C_uq19 VSS VSS sg13_lv_nmos ad=0.1694p pd=1.21u as=0.2618p ps=2.22u w=0.77u l=0.13u
X277 VSS SLN[7] a_33150_10685# VSS sg13_lv_nmos ad=0.14875p pd=1.16u as=0.187p ps=1.78u w=0.55u l=0.13u
X278 a_4337_32361# a_4301_32335# VDD VDD sg13_lv_pmos ad=0.34p pd=2.68u as=0.36237p ps=2.605u w=1u l=0.13u
X279 B_uq85 B_uq83 a_8103_36475# VSS sg13_lv_nmos ad=0.2516p pd=2.16u as=0.1406p ps=1.12u w=0.74u l=0.15u
X280 VSS a_78757_23984# B_uq48 VSS sg13_lv_nmos ad=0.1426p pd=1.16u as=0.2516p ps=2.16u w=0.74u l=0.13u
X281 a_7316_23601# a_7059_23458# a_7478_23381# VSS sg13_lv_nmos ad=0.1428p pd=1.52u as=37.8f ps=0.6u w=0.42u l=0.13u
X282 VDD a_44098_6863# X_uq6 VDD sg13_lv_pmos ad=0.2114p pd=1.54u as=0.42p ps=2.99u w=1.12u l=0.13u
X283 VSS L_HI_uq1 a_4072_21869# VSS sg13_lv_nmos ad=0.1626p pd=1.415u as=60.89999f ps=0.71u w=0.42u l=0.13u
X284 X_uq64 a_40646_8789# VSS VSS sg13_lv_nmos ad=0.2516p pd=2.16u as=0.1469p ps=1.155u w=0.74u l=0.13u
X285 Y_uq103 A1_uq9 a_79434_25577# VSS sg13_lv_nmos ad=0.1406p pd=1.12u as=0.1406p ps=1.12u w=0.74u l=0.13u
X286 VSS X_uq297 Y_uq167 VSS sg13_lv_nmos ad=0.2516p pd=2.16u as=0.2516p ps=2.16u w=0.74u l=0.13u
X287 VDD a_30875_69241# a_31542_68880# VDD sg13_lv_pmos ad=0.2128p pd=1.5u as=0.3864p ps=2.93u w=1.12u l=0.13u
X288 VSS a_39122_69634# a_39234_69698# VSS sg13_lv_nmos ad=0.1426p pd=1.16u as=0.1428p ps=1.52u w=0.42u l=0.5u
X289 VDD X_uq308 a_8869_39488# VDD sg13_lv_pmos ad=0.2128p pd=1.5u as=0.2128p ps=1.5u w=1.12u l=0.13u
X290 VDD a_39032_68082# X_uq432 VDD sg13_lv_pmos ad=0.2114p pd=1.54u as=0.42p ps=2.99u w=1.12u l=0.13u
X291 a_49784_68844# X_uq280 VDD VDD sg13_lv_pmos ad=0.2856p pd=2.36u as=0.2114p ps=1.54u w=0.84u l=0.13u
X292 VSS A2 a_77053_22981# VSS sg13_lv_nmos ad=0.2516p pd=2.16u as=0.1406p ps=1.12u w=0.74u l=0.13u
X293 a_3535_41591# a_3535_41755# a_3571_41719# VSS sg13_lv_nmos ad=0.1428p pd=1.52u as=37.8f ps=0.6u w=0.42u l=0.13u
X294 VSS a_8071_42811# a_8071_43194# VSS sg13_lv_nmos ad=0.1406p pd=1.12u as=0.2516p ps=2.16u w=0.74u l=0.13u
X295 VDD a_37787_67729# a_38454_67368# VDD sg13_lv_pmos ad=0.2128p pd=1.5u as=0.3864p ps=2.93u w=1.12u l=0.13u
X296 Y_uq109 D_uq7 VSS VSS sg13_lv_nmos ad=0.1406p pd=1.12u as=0.1406p ps=1.12u w=0.74u l=0.13u
X297 VDD a_36657_69609# a_36759_69752# VDD sg13_lv_pmos ad=1.6733p pd=10.405u as=0.3864p ps=2.93u w=1.12u l=0.13u
X298 VDD a_7059_21480# a_7316_21361# VDD sg13_lv_pmos ad=1.37097p pd=8.54u as=79.8f ps=0.8u w=0.42u l=0.13u
X299 VSS a_47480_66570# q[25] VSS sg13_lv_nmos ad=0.14875p pd=1.16u as=0.2886p ps=2.26u w=0.74u l=0.13u
X300 X_uq79 a_41414_9149# VSS VSS sg13_lv_nmos ad=0.2516p pd=2.16u as=0.1469p ps=1.155u w=0.74u l=0.13u
X301 VSS a_41794_7625# X_uq46 VSS sg13_lv_nmos ad=0.14875p pd=1.16u as=0.2886p ps=2.26u w=0.74u l=0.13u
X302 VDD a_42946_6863# X_uq9 VDD sg13_lv_pmos ad=0.2114p pd=1.54u as=0.42p ps=2.99u w=1.12u l=0.13u
X303 a_41321_66904# C_uq54 Y_uq294 VDD sg13_lv_pmos ad=0.2128p pd=1.5u as=0.3808p ps=2.92u w=1.12u l=0.13u
X304 a_7321_40826# A0 VDD VDD sg13_lv_pmos ad=0.2856p pd=2.36u as=0.2198p ps=1.53u w=0.84u l=0.13u
X305 a_36242_67806# a_37047_67379# a_36502_67336# VDD sg13_lv_pmos ad=0.1428p pd=1.52u as=79.8f ps=0.8u w=0.42u l=0.13u
X306 VDD a_4297_36991# a_4321_36711# VDD sg13_lv_pmos ad=0.1523p pd=1.38u as=0.34p ps=2.68u w=1u l=0.5u
X307 a_39227_64705# a_38385_64355# a_39133_64705# VSS sg13_lv_nmos ad=0.12665p pd=1.145u as=0.1428p ps=1.52u w=0.42u l=0.13u
X308 VSS Q_uq38 Y_uq252 VSS sg13_lv_nmos ad=0.2516p pd=2.16u as=0.1406p ps=1.12u w=0.74u l=0.13u
X309 a_5150_24861# Q_uq5 VDD VDD sg13_lv_pmos ad=0.1428p pd=1.52u as=0.1523p ps=1.38u w=0.42u l=0.13u
X310 VDD VSS VDD VDD sg13_lv_pmos ad=0.34p pd=2.68u as=0 ps=0 w=1u l=1u
X311 VDD a_5062_35274# a_5058_36197# VDD sg13_lv_pmos ad=1.86053p pd=12.055u as=0.3864p ps=2.93u w=1.12u l=0.13u
X312 a_36070_66574# Q_uq35 VDD VDD sg13_lv_pmos ad=0.1428p pd=1.52u as=0.1523p ps=1.38u w=0.42u l=0.13u
X313 VSS a_50552_63546# q[26] VSS sg13_lv_nmos ad=0.14875p pd=1.16u as=0.2886p ps=2.26u w=0.74u l=0.13u
X314 Y_uq189 X_uq297 VDD VDD sg13_lv_pmos ad=0.3808p pd=2.92u as=0.3808p ps=2.92u w=1.12u l=0.13u
X315 a_34619_68195# a_33777_68097# a_34525_68195# VSS sg13_lv_nmos ad=0.12665p pd=1.145u as=0.1428p ps=1.52u w=0.42u l=0.13u
X316 a_6913_38589# Q_uq19 VDD VDD sg13_lv_pmos ad=0.2128p pd=1.5u as=0.3808p ps=2.92u w=1.12u l=0.15u
X317 VDD a_28754_65098# a_28866_65162# VDD sg13_lv_pmos ad=0.2254p pd=1.53u as=0.34p ps=2.68u w=1u l=0.5u
X318 VSS X_uq448 a_46324_69668# VSS sg13_lv_nmos ad=0.14875p pd=1.16u as=0.187p ps=1.78u w=0.55u l=0.13u
X319 VDD a_39227_64705# a_39894_64344# VDD sg13_lv_pmos ad=0.2128p pd=1.5u as=0.3864p ps=2.93u w=1.12u l=0.13u
X320 a_52318_67806# L_HI_uq23 VSS VSS sg13_lv_nmos ad=37.8f pd=0.6u as=79.8f ps=0.8u w=0.42u l=0.13u
X321 VSS X_uq319 a_5047_40319# VSS sg13_lv_nmos ad=0.14875p pd=1.16u as=0.187p ps=1.78u w=0.55u l=0.13u
X322 VSS Y_uq84 a_79919_22959# VSS sg13_lv_nmos ad=79.8f pd=0.8u as=0.1428p ps=1.52u w=0.42u l=0.13u
X323 VSS a_34780_66826# a_34429_66683# VSS sg13_lv_nmos ad=79.8f pd=0.8u as=0.1428p ps=1.52u w=0.42u l=0.13u
X324 a_78651_26745# a_79170_26752# a_79910_27102# VSS sg13_lv_nmos ad=0.3473p pd=2.71u as=0.12665p ps=1.145u w=0.74u l=0.13u
X325 VSS a_45932_64631# Q_uq32 VSS sg13_lv_nmos ad=0.1406p pd=1.12u as=0.2516p ps=2.16u w=0.74u l=0.13u
X326 VSS Y_uq328 a_28388_68122# VSS sg13_lv_nmos ad=79.8f pd=0.8u as=0.1428p ps=1.52u w=0.42u l=0.13u
X327 VSS Q_uq29 a_37588_63620# VSS sg13_lv_nmos ad=0.14875p pd=1.16u as=0.187p ps=1.78u w=0.55u l=0.13u
X328 VDD L_HI_uq22 a_28918_65824# VDD sg13_lv_pmos ad=0.1563p pd=1.22u as=0.147p ps=1.54u w=0.42u l=0.13u
X329 a_33681_66585# clk VSS VSS sg13_lv_nmos ad=0.2516p pd=2.16u as=1.7977p ps=11.53u w=0.74u l=0.13u
X330 C_uq28 a_75583_29041# VDD VDD sg13_lv_pmos ad=0.42p pd=2.99u as=0.2114p ps=1.54u w=1.12u l=0.13u
X331 a_8107_32983# Y_uq163 VSS VSS sg13_lv_nmos ad=37.8f pd=0.6u as=79.8f ps=0.8u w=0.42u l=0.13u
X332 a_38385_64355# clk VSS VSS sg13_lv_nmos ad=0.2516p pd=2.16u as=4.19255p ps=26u w=0.74u l=0.13u
X333 VDD a_45250_7625# X_uq41 VDD sg13_lv_pmos ad=0.2114p pd=1.54u as=0.42p ps=2.99u w=1.12u l=0.13u
X334 VDD L_HI_uq2 a_5774_21087# VDD sg13_lv_pmos ad=0.1563p pd=1.22u as=0.147p ps=1.54u w=0.42u l=0.13u
X335 a_38182_65062# Y_uq266 VSS VSS sg13_lv_nmos ad=0.1428p pd=1.52u as=79.8f ps=0.8u w=0.42u l=0.13u
X336 a_78757_29192# a_78872_29193# VDD VDD sg13_lv_pmos ad=0.34p pd=2.68u as=0.2254p ps=1.53u w=1u l=0.5u
X337 VSS Q_uq38 a_36052_63620# VSS sg13_lv_nmos ad=0.14875p pd=1.16u as=0.187p ps=1.78u w=0.55u l=0.13u
X338 X_uq171 a_9329_17875# VSS VSS sg13_lv_nmos ad=0.2886p pd=2.26u as=0.14875p ps=1.16u w=0.74u l=0.13u
X339 X_uq144 a_41214_10685# VSS VSS sg13_lv_nmos ad=0.2886p pd=2.26u as=0.14875p ps=1.16u w=0.74u l=0.13u
X340 VDD Q_uq15 a_5809_34855# VDD sg13_lv_pmos ad=0.1523p pd=1.38u as=0.1428p ps=1.52u w=0.42u l=0.13u
X341 VSS Y_uq318 Y_uq286 VSS sg13_lv_nmos ad=0.1463p pd=1.15u as=0.1694p ps=1.21u w=0.77u l=0.13u
X342 L_HI_uq7 a_78837_27743# VDD VDD sg13_lv_pmos ad=0.3927p pd=2.99u as=1.59725p ps=10.05u w=1.155u l=0.13u
X343 X_uq263 a_75679_26741# VDD VDD sg13_lv_pmos ad=0.42p pd=2.99u as=0.2114p ps=1.54u w=1.12u l=0.13u
X344 a_50165_69218# a_50289_68917# VDD VDD sg13_lv_pmos ad=0.2442p pd=2.06u as=1.42837p ps=8.61u w=0.66u l=0.13u
X345 a_43248_67793# a_42960_67372# a_43186_67793# VSS sg13_lv_nmos ad=0.1428p pd=1.52u as=37.8f ps=0.6u w=0.42u l=0.13u
X346 VSS VDD VSS VSS sg13_lv_nmos ad=0.1428p pd=1.52u as=0 ps=-0 w=0.42u l=1u
X347 VSS a_6098_22898# D_uq6 VSS sg13_lv_nmos ad=0.1426p pd=1.16u as=0.2516p ps=2.16u w=0.74u l=0.13u
X348 a_46018_7625# X_uq73 VDD VDD sg13_lv_pmos ad=0.2856p pd=2.36u as=0.2114p ps=1.54u w=0.84u l=0.13u
X349 Q_uq1 a_7726_23679# VDD VDD sg13_lv_pmos ad=0.3808p pd=2.92u as=0.2128p ps=1.5u w=1.12u l=0.13u
X350 a_4152_22595# B_uq66 VDD VDD sg13_lv_pmos ad=0.2856p pd=2.36u as=0.2618p ps=1.63u w=0.84u l=0.13u
X351 VSS din[7] a_75583_29041# VSS sg13_lv_nmos ad=0.14875p pd=1.16u as=0.187p ps=1.78u w=0.55u l=0.13u
X352 VSS a_34619_68195# a_35286_68416# VSS sg13_lv_nmos ad=0.1406p pd=1.12u as=0.2516p ps=2.16u w=0.74u l=0.13u
X353 VDD a_34726_67332# a_34445_67634# VDD sg13_lv_pmos ad=0.1523p pd=1.38u as=0.34p ps=2.68u w=1u l=0.5u
X354 X_uq88 a_36126_9173# VDD VDD sg13_lv_pmos ad=0.42p pd=2.99u as=0.2114p ps=1.54u w=1.12u l=0.13u
X355 VSS din[17] a_75679_23717# VSS sg13_lv_nmos ad=0.14875p pd=1.16u as=0.187p ps=1.78u w=0.55u l=0.13u
X356 VSS a_33898_9137# Y_uq16 VSS sg13_lv_nmos ad=0.17255p pd=1.25u as=0.1406p ps=1.12u w=0.74u l=0.13u
X357 a_4238_22092# a_4681_21848# a_3978_21869# VSS sg13_lv_nmos ad=79.8f pd=0.8u as=0.1296p ps=1.52u w=0.42u l=0.13u
X358 X_uq164 a_33542_10661# VSS VSS sg13_lv_nmos ad=0.2516p pd=2.16u as=0.1469p ps=1.155u w=0.74u l=0.13u
X359 SLN[7] a_30100_63620# VDD VDD sg13_lv_pmos ad=0.42p pd=2.99u as=0.2114p ps=1.54u w=1.12u l=0.13u
X360 a_10345_31414# a_10345_31516# VDD VDD sg13_lv_pmos ad=0.3864p pd=2.93u as=0.2128p ps=1.5u w=1.12u l=0.13u
X361 VSS Y_uq172 a_3584_32987# VSS sg13_lv_nmos ad=0.1701p pd=1.65u as=37.8f ps=0.6u w=0.42u l=0.13u
X362 a_40342_65824# a_40785_65867# a_40082_66294# VSS sg13_lv_nmos ad=79.8f pd=0.8u as=0.1296p ps=1.52u w=0.42u l=0.13u
X363 VDD VSS VDD VDD sg13_lv_pmos ad=0.34p pd=2.68u as=0 ps=0 w=1u l=1u
X364 VSS X_uq431 a_41428_68880# VSS sg13_lv_nmos ad=0.14875p pd=1.16u as=0.187p ps=1.78u w=0.55u l=0.13u
X365 a_78852_19529# X_uq251 VDD VDD sg13_lv_pmos ad=0.1596p pd=1.22u as=0.2856p ps=2.36u w=0.84u l=0.13u
X366 a_6574_31914# clk VDD VDD sg13_lv_pmos ad=0.4088p pd=2.97u as=2.24605p ps=14.69u w=1.12u l=0.13u
X367 VDD Y_uq104 a_78404_25253# VDD sg13_lv_pmos ad=0.3822p pd=1.84u as=0.1575p ps=1.315u w=1u l=0.13u
X368 a_49251_65856# Y_uq285 a_49137_65856# VDD sg13_lv_pmos ad=0.2128p pd=1.5u as=0.2464p ps=1.56u w=1.12u l=0.13u
X369 a_6893_34031# X_uq294 VDD VDD sg13_lv_pmos ad=0.1176p pd=1.33u as=0.4032p ps=2.96u w=1.12u l=0.13u
X370 a_49760_63550# X_uq446 VSS VSS sg13_lv_nmos ad=0.187p pd=1.78u as=0.17255p ps=1.25u w=0.55u l=0.13u
X371 VSS a_46714_65283# X_uq373 VSS sg13_lv_nmos ad=0.1426p pd=1.16u as=0.2516p ps=2.16u w=0.74u l=0.13u
X372 a_43259_64705# a_42417_64355# a_43165_64705# VSS sg13_lv_nmos ad=0.12665p pd=1.145u as=0.1428p ps=1.52u w=0.42u l=0.13u
X373 Y_uq332 a_46810_68160# VSS VSS sg13_lv_nmos ad=0.1406p pd=1.12u as=0.17255p ps=1.25u w=0.74u l=0.13u
X374 a_43428_10301# B_uq16 a_43334_10301# VDD sg13_lv_pmos ad=0.1596p pd=1.22u as=0.2856p ps=2.36u w=0.84u l=0.13u
X375 VDD a_5051_34111# a_5087_34043# VDD sg13_lv_pmos ad=0.1523p pd=1.38u as=0.34p ps=2.68u w=1u l=0.5u
X376 a_39429_64467# a_38487_64355# a_39227_64705# VDD sg13_lv_pmos ad=93.45f pd=0.865u as=0.2048p ps=1.63u w=0.42u l=0.13u
X377 a_33264_66924# a_33238_66829# VSS VSS sg13_lv_nmos ad=0.2516p pd=2.16u as=0.1626p ps=1.415u w=0.74u l=0.13u
X378 VDD A2_uq3 a_75979_23253# VDD sg13_lv_pmos ad=0.3808p pd=2.92u as=0.2128p ps=1.5u w=1.12u l=0.13u
X379 VDD B_uq38 a_79044_21489# VDD sg13_lv_pmos ad=0.1918p pd=1.5u as=0.1596p ps=1.22u w=0.84u l=0.13u
X380 VSS B_uq67 a_76861_19529# VSS sg13_lv_nmos ad=0.2516p pd=2.16u as=0.1406p ps=1.12u w=0.74u l=0.13u
X381 VDD a_44792_69594# X_uq449 VDD sg13_lv_pmos ad=0.2114p pd=1.54u as=0.42p ps=2.99u w=1.12u l=0.13u
X382 SLN[0] a_27700_69668# VSS VSS sg13_lv_nmos ad=0.2886p pd=2.26u as=0.14875p ps=1.16u w=0.74u l=0.13u
X383 VDD a_43259_64705# a_43926_64344# VDD sg13_lv_pmos ad=0.2128p pd=1.5u as=0.3864p ps=2.93u w=1.12u l=0.13u
X384 Q_uq30 a_42294_65856# VDD VDD sg13_lv_pmos ad=0.3808p pd=2.92u as=0.2128p ps=1.5u w=1.12u l=0.13u
X385 X_uq188 a_76831_18457# VDD VDD sg13_lv_pmos ad=0.42p pd=2.99u as=0.2114p ps=1.54u w=1.12u l=0.13u
X386 VDD a_36994_7625# B_uq10 VDD sg13_lv_pmos ad=0.2114p pd=1.54u as=0.42p ps=2.99u w=1.12u l=0.13u
X387 a_5821_37924# S_uq0 VDD VDD sg13_lv_pmos ad=0.2716p pd=1.605u as=0.3808p ps=2.92u w=1.12u l=0.13u
X388 a_43058_66294# D_uq43 VDD VDD sg13_lv_pmos ad=79.8f pd=0.8u as=0.1428p ps=1.52u w=0.42u l=0.13u
X389 VDD A_uq75 a_43908_10301# VDD sg13_lv_pmos ad=0.2226p pd=1.535u as=0.1596p ps=1.22u w=0.84u l=0.13u
X390 X_uq447 a_41428_68880# VSS VSS sg13_lv_nmos ad=0.2886p pd=2.26u as=0.14875p ps=1.16u w=0.74u l=0.13u
X391 a_78188_24087# B_uq43 VSS VSS sg13_lv_nmos ad=0.1406p pd=1.12u as=0.1898p ps=1.36u w=0.74u l=0.13u
X392 VSS Q_uq58 Y_uq363 VSS sg13_lv_nmos ad=0.2516p pd=2.16u as=0.2516p ps=2.16u w=0.74u l=0.13u
X393 VSS a_34690_7625# B_uq13 VSS sg13_lv_nmos ad=0.14875p pd=1.16u as=0.2886p ps=2.26u w=0.74u l=0.13u
X394 Y_uq272 C_uq49 VSS VSS sg13_lv_nmos ad=0.2618p pd=2.22u as=0.1463p ps=1.15u w=0.77u l=0.13u
X395 VDD a_41866_10649# a_41824_10685# VDD sg13_lv_pmos ad=0.2618p pd=1.63u as=0.1176p ps=1.33u w=1.12u l=0.13u
X396 VDD a_44866_8375# X_uq74 VDD sg13_lv_pmos ad=0.2114p pd=1.54u as=0.42p ps=2.99u w=1.12u l=0.13u
X397 VSS a_4754_25082# X_uq260 VSS sg13_lv_nmos ad=0.1426p pd=1.16u as=0.2516p ps=2.16u w=0.74u l=0.13u
X398 a_28160_65062# X_uq420 VSS VSS sg13_lv_nmos ad=0.187p pd=1.78u as=0.17255p ps=1.25u w=0.55u l=0.13u
X399 VSS a_78077_22959# a_78189_23023# VSS sg13_lv_nmos ad=0.1426p pd=1.16u as=0.1428p ps=1.52u w=0.42u l=0.5u
X400 B2_uq9 X_uq266 VSS VSS sg13_lv_nmos ad=0.2516p pd=2.16u as=0.2516p ps=2.16u w=0.74u l=0.13u
X401 VSS a_33777_68097# a_33879_68240# VSS sg13_lv_nmos ad=2.08687p pd=13.23u as=0.2516p ps=2.16u w=0.74u l=0.13u
X402 Q_uq0 a_7726_21119# VSS VSS sg13_lv_nmos ad=0.2516p pd=2.16u as=0.1406p ps=1.12u w=0.74u l=0.13u
X403 a_41234_69630# D_uq61 VDD VDD sg13_lv_pmos ad=79.8f pd=0.8u as=0.1428p ps=1.52u w=0.42u l=0.13u
X404 X_uq150 a_39294_10685# VSS VSS sg13_lv_nmos ad=0.2886p pd=2.26u as=0.14875p ps=1.16u w=0.74u l=0.13u
X405 VDD Y_uq4 a_34398_6937# VDD sg13_lv_pmos ad=0.2114p pd=1.54u as=0.2856p ps=2.36u w=0.84u l=0.13u
X406 a_80076_20740# a_79134_20780# a_79982_20740# VDD sg13_lv_pmos ad=79.8f pd=0.8u as=0.1428p ps=1.52u w=0.42u l=0.13u
X407 a_76651_28253# Y_uq155 VDD VDD sg13_lv_pmos ad=0.2128p pd=1.5u as=0.3808p ps=2.92u w=1.12u l=0.13u
X408 a_4337_41193# a_4335_41975# a_4297_43188# VSS sg13_lv_nmos ad=0.3473p pd=2.71u as=0.12665p ps=1.145u w=0.74u l=0.13u
X409 VDD a_30875_69241# a_31132_69122# VDD sg13_lv_pmos ad=1.42837p pd=8.61u as=79.8f ps=0.8u w=0.42u l=0.13u
X410 a_35458_7625# A_uq6 VSS VSS sg13_lv_nmos ad=0.187p pd=1.78u as=0.14875p ps=1.16u w=0.55u l=0.13u
X411 a_3550_35754# clk VDD VDD sg13_lv_pmos ad=0.4088p pd=2.97u as=1.25632p ps=8.01u w=1.12u l=0.13u
X412 a_52186_68307# a_52301_68308# VDD VDD sg13_lv_pmos ad=0.34p pd=2.68u as=0.2254p ps=1.53u w=1u l=0.5u
X413 VDD C_uq21 a_10229_18135# VDD sg13_lv_pmos ad=0.4032p pd=2.96u as=0.1176p ps=1.33u w=1.12u l=0.13u
X414 VSS a_79068_24446# a_79170_24589# VSS sg13_lv_nmos ad=4.92377p pd=34.425u as=0.2516p ps=2.16u w=0.74u l=0.13u
X415 a_34053_69945# a_33111_69752# a_33851_69707# VDD sg13_lv_pmos ad=93.45f pd=0.865u as=0.2048p ps=1.63u w=0.42u l=0.13u
X416 a_37756_69850# L_HI_uq38 VDD VDD sg13_lv_pmos ad=79.8f pd=0.8u as=1.6733p ps=10.405u w=0.42u l=0.13u
X417 a_10742_32304# a_10347_32660# a_10345_31516# VSS sg13_lv_nmos ad=0.1428p pd=1.52u as=0.12665p ps=1.145u w=0.42u l=0.13u
X418 VSS X_uq397 Y_uq306 VSS sg13_lv_nmos ad=0.2516p pd=2.16u as=0.1406p ps=1.12u w=0.74u l=0.13u
X419 VDD VSS VDD VDD sg13_lv_pmos ad=0.34p pd=2.68u as=0 ps=0 w=1u l=1u
X420 a_6591_38491# A0 VSS VSS sg13_lv_nmos ad=0.1406p pd=1.12u as=0.1406p ps=1.12u w=0.74u l=0.15u
X421 VSS a_39227_64705# a_39894_64344# VSS sg13_lv_nmos ad=0.1406p pd=1.12u as=0.2516p ps=2.16u w=0.74u l=0.13u
X422 a_40334_9489# B_uq22 a_40476_9149# VDD sg13_lv_pmos ad=0.2856p pd=2.36u as=0.1596p ps=1.22u w=0.84u l=0.13u
X423 a_52266_66858# a_52067_66921# VSS VSS sg13_lv_nmos ad=0.27427p pd=2.28u as=1.8643p ps=11.96u w=0.795u l=0.13u
X424 a_10383_32686# a_10347_32660# VSS VSS sg13_lv_nmos ad=0.2516p pd=2.16u as=5.51925p ps=35.255u w=0.74u l=0.13u
X425 a_44512_9173# X_uq137 Y_uq8 VDD sg13_lv_pmos ad=0.1176p pd=1.33u as=0.3808p ps=2.92u w=1.12u l=0.13u
X426 VDD X_uq433 a_35194_68936# VDD sg13_lv_pmos ad=0.2618p pd=1.63u as=0.2856p ps=2.36u w=0.84u l=0.13u
X427 a_46018_8375# q[31] VDD VDD sg13_lv_pmos ad=0.2856p pd=2.36u as=0.2114p ps=1.54u w=0.84u l=0.13u
X428 VSS a_8075_33721# C_uq31 VSS sg13_lv_nmos ad=0.1426p pd=1.16u as=0.2516p ps=2.16u w=0.74u l=0.13u
X429 VSS X_uq458 a_32314_65912# VSS sg13_lv_nmos ad=0.17255p pd=1.25u as=0.187p ps=1.78u w=0.55u l=0.13u
X430 a_76555_19529# B2 VSS VSS sg13_lv_nmos ad=0.1406p pd=1.12u as=0.1406p ps=1.12u w=0.74u l=0.13u
X431 VSS a_10347_42044# a_10383_41975# VSS sg13_lv_nmos ad=5.51925p pd=35.255u as=0.2516p ps=2.16u w=0.74u l=0.13u
X432 a_37720_68880# a_37498_68936# VDD VDD sg13_lv_pmos ad=0.1176p pd=1.33u as=0.2618p ps=1.63u w=1.12u l=0.13u
X433 VSS a_51610_63771# X_uq444 VSS sg13_lv_nmos ad=0.1426p pd=1.16u as=0.2516p ps=2.16u w=0.74u l=0.13u
X434 a_33681_66585# clk VDD VDD sg13_lv_pmos ad=0.4088p pd=2.97u as=1.17087p ps=7.02u w=1.12u l=0.13u
X435 a_5381_39104# Y_uq208 Y_uq211 VDD sg13_lv_pmos ad=0.2128p pd=1.5u as=0.3808p ps=2.92u w=1.12u l=0.13u
X436 A1_uq9 a_78208_25253# VSS VSS sg13_lv_nmos ad=0.2516p pd=2.16u as=0.13395p ps=1.12u w=0.74u l=0.13u
X437 VSS VDD VSS VSS sg13_lv_nmos ad=0.1428p pd=1.52u as=0 ps=-0 w=0.42u l=1u
X438 VDD a_9598_40746# a_9594_41669# VDD sg13_lv_pmos ad=1.17462p pd=7.44u as=0.3864p ps=2.93u w=1.12u l=0.13u
X439 VDD VSS VDD VDD sg13_lv_pmos ad=0.34p pd=2.68u as=0 ps=0 w=1u l=1u
X440 a_43461_64467# a_42519_64355# a_43259_64705# VDD sg13_lv_pmos ad=93.45f pd=0.865u as=0.2048p ps=1.63u w=0.42u l=0.13u
X441 C_uq64 X_uq413 VSS VSS sg13_lv_nmos ad=0.1406p pd=1.12u as=0.2516p ps=2.16u w=0.74u l=0.13u
X442 X_uq248 a_9233_25435# VDD VDD sg13_lv_pmos ad=0.42p pd=2.99u as=0.2114p ps=1.54u w=1.12u l=0.13u
X443 VDD X_uq272 a_79026_27533# VDD sg13_lv_pmos ad=0.2198p pd=1.53u as=0.2856p ps=2.36u w=0.84u l=0.13u
X444 VSS a_10345_43188# a_10345_43290# VSS sg13_lv_nmos ad=0.1406p pd=1.12u as=0.2516p ps=2.16u w=0.74u l=0.13u
X445 VSS a_37378_7625# X_uq162 VSS sg13_lv_nmos ad=0.14875p pd=1.16u as=0.2886p ps=2.26u w=0.74u l=0.13u
X446 VDD X_uq458 a_33370_67424# VDD sg13_lv_pmos ad=0.2618p pd=1.63u as=0.2856p ps=2.36u w=0.84u l=0.13u
X447 Y_uq342 X_uq454 a_35416_68880# VDD sg13_lv_pmos ad=0.3808p pd=2.92u as=0.1176p ps=1.33u w=1.12u l=0.13u
X448 a_39042_8709# a_38820_8453# VDD VDD sg13_lv_pmos ad=0.1176p pd=1.33u as=0.2618p ps=1.63u w=1.12u l=0.13u
X449 a_76362_19957# B1_uq6 VSS VSS sg13_lv_nmos ad=0.1406p pd=1.12u as=0.2516p ps=2.16u w=0.74u l=0.13u
X450 VSS a_44476_67610# a_44125_67729# VSS sg13_lv_nmos ad=79.8f pd=0.8u as=0.1428p ps=1.52u w=0.42u l=0.13u
X451 VSS a_38651_66217# a_39318_65856# VSS sg13_lv_nmos ad=0.1406p pd=1.12u as=0.2516p ps=2.16u w=0.74u l=0.13u
X452 a_40930_10649# q[19] VDD VDD sg13_lv_pmos ad=0.2856p pd=2.36u as=0.2114p ps=1.54u w=0.84u l=0.13u
X453 VDD a_33634_8375# B_uq14 VDD sg13_lv_pmos ad=0.2114p pd=1.54u as=0.42p ps=2.99u w=1.12u l=0.13u
X454 VDD Y_uq203 a_5821_37924# VDD sg13_lv_pmos ad=0.3808p pd=2.92u as=0.2744p ps=1.61u w=1.12u l=0.13u
X455 a_5845_33032# S_uq0 a_5845_32930# VDD sg13_lv_pmos ad=0.2464p pd=1.56u as=0.2128p ps=1.5u w=1.12u l=0.13u
X456 VSS a_4297_36603# X_uq300 VSS sg13_lv_nmos ad=0.1426p pd=1.16u as=0.2516p ps=2.16u w=0.74u l=0.13u
X457 a_36316_66098# a_36059_66217# a_36478_66294# VSS sg13_lv_nmos ad=0.1428p pd=1.52u as=37.8f ps=0.6u w=0.42u l=0.13u
X458 a_35907_68880# Y_uq342 a_35793_68880# VDD sg13_lv_pmos ad=0.2128p pd=1.5u as=0.2464p ps=1.56u w=1.12u l=0.13u
X459 X_uq88 a_36126_9173# VSS VSS sg13_lv_nmos ad=0.2886p pd=2.26u as=0.14875p ps=1.16u w=0.74u l=0.13u
X460 a_3886_36798# a_3546_36677# a_3535_37051# VDD sg13_lv_pmos ad=93.45f pd=0.865u as=0.2048p ps=1.63u w=0.42u l=0.13u
X461 a_79134_20780# a_79286_20664# VDD VDD sg13_lv_pmos ad=0.3864p pd=2.93u as=2.04445p ps=13.405u w=1.12u l=0.13u
X462 a_76549_28253# C1_uq7 A2_uq6 VDD sg13_lv_pmos ad=0.2128p pd=1.5u as=0.3808p ps=2.92u w=1.12u l=0.13u
X463 VSS a_34246_65062# a_33965_65284# VSS sg13_lv_nmos ad=79.8f pd=0.8u as=0.1428p ps=1.52u w=0.42u l=0.5u
X464 VDD Y_uq45 a_76939_20229# VDD sg13_lv_pmos ad=0.3808p pd=2.92u as=0.2128p ps=1.5u w=1.12u l=0.13u
X465 a_12046_23135# C_uq19 VDD VDD sg13_lv_pmos ad=0.2464p pd=1.56u as=0.3808p ps=2.92u w=1.12u l=0.13u
X466 a_39374_9489# B_uq25 a_39516_9149# VDD sg13_lv_pmos ad=0.2856p pd=2.36u as=0.1596p ps=1.22u w=0.84u l=0.13u
X467 VSS a_31832_68082# A_uq8 VSS sg13_lv_nmos ad=0.14875p pd=1.16u as=0.2886p ps=2.26u w=0.74u l=0.13u
X468 VSS a_37838_8555# X_uq70 VSS sg13_lv_nmos ad=0.1469p pd=1.155u as=0.2516p ps=2.16u w=0.74u l=0.13u
X469 VSS X_uq455 a_27802_68936# VSS sg13_lv_nmos ad=0.17255p pd=1.25u as=0.187p ps=1.78u w=0.55u l=0.13u
X470 C_uq52 X_uq420 VSS VSS sg13_lv_nmos ad=0.1406p pd=1.12u as=0.2516p ps=2.16u w=0.74u l=0.13u
X471 a_10349_41167# a_10347_42044# a_10428_41738# VSS sg13_lv_nmos ad=79.8f pd=0.8u as=0.1296p ps=1.52u w=0.42u l=0.13u
X472 VDD Y_uq258 a_48644_65098# VDD sg13_lv_pmos ad=0.1523p pd=1.38u as=0.1428p ps=1.52u w=0.42u l=0.13u
X473 a_5774_23604# a_6217_23360# a_5514_23381# VSS sg13_lv_nmos ad=79.8f pd=0.8u as=0.1296p ps=1.52u w=0.42u l=0.13u
X474 VSS A_uq88 Y_uq23 VSS sg13_lv_nmos ad=0.2516p pd=2.16u as=0.1406p ps=1.12u w=0.74u l=0.13u
X475 VSS B_uq67 a_77698_21489# VSS sg13_lv_nmos ad=0.1331p pd=1.12u as=0.1216p ps=1.02u w=0.64u l=0.13u
X476 a_6608_31723# Y_uq169 VSS VSS sg13_lv_nmos ad=37.8f pd=0.6u as=0.1701p ps=1.65u w=0.42u l=0.13u
X477 B_uq89 A0 a_6913_38589# VDD sg13_lv_pmos ad=0.2128p pd=1.5u as=0.2128p ps=1.5u w=1.12u l=0.15u
X478 a_46102_65824# a_46545_65867# a_45842_66294# VSS sg13_lv_nmos ad=79.8f pd=0.8u as=0.1296p ps=1.52u w=0.42u l=0.13u
X479 Q_uq46 a_36726_65856# VDD VDD sg13_lv_pmos ad=0.3808p pd=2.92u as=0.2128p ps=1.5u w=1.12u l=0.13u
X480 VDD Q_uq52 Y_uq357 VDD sg13_lv_pmos ad=0.3808p pd=2.92u as=0.3808p ps=2.92u w=1.12u l=0.13u
X481 B_uq31 a_33150_8449# VDD VDD sg13_lv_pmos ad=0.42p pd=2.99u as=0.2114p ps=1.54u w=1.12u l=0.13u
X482 VDD VSS VDD VDD sg13_lv_pmos ad=0.19p pd=1.38u as=0 ps=0 w=1u l=1u
X483 VSS A_uq30 a_37374_8449# VSS sg13_lv_nmos ad=0.14875p pd=1.16u as=0.187p ps=1.78u w=0.55u l=0.13u
X484 a_43011_65392# Y_uq289 a_42897_65392# VDD sg13_lv_pmos ad=0.2128p pd=1.5u as=0.2464p ps=1.56u w=1.12u l=0.13u
X485 Y_uq21 A_uq87 a_40194_10221# VDD sg13_lv_pmos ad=0.3808p pd=2.92u as=0.1176p ps=1.33u w=1.12u l=0.13u
X486 VSS a_3535_41591# a_3571_41523# VSS sg13_lv_nmos ad=79.8f pd=0.8u as=0.1428p ps=1.52u w=0.42u l=0.13u
X487 VSS a_43259_64705# a_43926_64344# VSS sg13_lv_nmos ad=0.1406p pd=1.12u as=0.2516p ps=2.16u w=0.74u l=0.13u
X488 D_uq63 C_uq70 VSS VSS sg13_lv_nmos ad=0.2618p pd=2.22u as=0.1463p ps=1.15u w=0.77u l=0.13u
X489 a_3550_35754# clk VSS VSS sg13_lv_nmos ad=0.2516p pd=2.16u as=4.345p ps=28.205u w=0.74u l=0.13u
X490 VSS a_7321_32575# a_7345_32295# VSS sg13_lv_nmos ad=79.8f pd=0.8u as=0.1428p ps=1.52u w=0.42u l=0.5u
X491 a_10385_41193# a_10349_41167# VDD VDD sg13_lv_pmos ad=0.34p pd=2.68u as=0.36237p ps=2.605u w=1u l=0.13u
X492 a_32687_64344# Y_uq253 a_32585_64344# VDD sg13_lv_pmos ad=0.2464p pd=1.56u as=0.2128p ps=1.5u w=1.12u l=0.13u
X493 VDD A2_uq3 a_76651_26277# VDD sg13_lv_pmos ad=0.3808p pd=2.92u as=0.2128p ps=1.5u w=1.12u l=0.13u
X494 X_uq203 a_12593_21623# VDD VDD sg13_lv_pmos ad=0.42p pd=2.99u as=0.2114p ps=1.54u w=1.12u l=0.13u
X495 VDD clk a_10347_32660# VDD sg13_lv_pmos ad=1.12945p pd=7.155u as=0.4088p ps=2.97u w=1.12u l=0.13u
X496 VDD a_6559_33211# a_6559_33594# VDD sg13_lv_pmos ad=0.2128p pd=1.5u as=0.3864p ps=2.93u w=1.12u l=0.13u
X497 a_6215_37492# a_5809_37466# Y_uq196 VSS sg13_lv_nmos ad=0.1406p pd=1.12u as=0.333p ps=2.38u w=0.74u l=0.13u
X498 VDD D_uq2 a_79982_22252# VDD sg13_lv_pmos ad=0.1428p pd=1.52u as=79.8f ps=0.8u w=0.42u l=0.13u
X499 a_35110_65062# Y_uq276 VSS VSS sg13_lv_nmos ad=0.1428p pd=1.52u as=79.8f ps=0.8u w=0.42u l=0.13u
X500 a_28079_68416# Y_uq329 a_27977_68416# VDD sg13_lv_pmos ad=0.2464p pd=1.56u as=0.2128p ps=1.5u w=1.12u l=0.13u
X501 a_78017_19181# X_uq251 B1_uq7 VDD sg13_lv_pmos ad=0.1176p pd=1.33u as=0.3808p ps=2.92u w=1.12u l=0.13u
X502 VSS Y_uq21 a_39774_6937# VSS sg13_lv_nmos ad=0.14875p pd=1.16u as=0.187p ps=1.78u w=0.55u l=0.13u
X503 a_78787_21131# a_78574_20657# VDD VDD sg13_lv_pmos ad=79.8f pd=0.8u as=2.04445p ps=13.405u w=0.42u l=0.13u
X504 VSS Y_uq5 a_33630_6937# VSS sg13_lv_nmos ad=0.14875p pd=1.16u as=0.187p ps=1.78u w=0.55u l=0.13u
X505 Q_uq31 a_48054_65856# VDD VDD sg13_lv_pmos ad=0.3808p pd=2.92u as=0.2128p ps=1.5u w=1.12u l=0.13u
X506 VSS a_30682_66795# X_uq404 VSS sg13_lv_nmos ad=0.1426p pd=1.16u as=0.2516p ps=2.16u w=0.74u l=0.13u
X507 Y_uq267 a_38554_65136# VSS VSS sg13_lv_nmos ad=0.1406p pd=1.12u as=0.17255p ps=1.25u w=0.74u l=0.13u
X508 VSS a_9598_40746# a_9594_41669# VSS sg13_lv_nmos ad=4.17695p pd=26.495u as=0.2516p ps=2.16u w=0.74u l=0.13u
X509 VDD a_33777_68097# a_33879_68240# VDD sg13_lv_pmos ad=1.42837p pd=8.61u as=0.3864p ps=2.93u w=1.12u l=0.13u
X510 Q_uq57 a_30774_69928# VDD VDD sg13_lv_pmos ad=0.3808p pd=2.92u as=0.2128p ps=1.5u w=1.12u l=0.13u
X511 a_9632_33083# a_9583_31905# a_9632_32989# VSS sg13_lv_nmos ad=37.8f pd=0.6u as=0.1428p ps=1.52u w=0.42u l=0.13u
X512 D_uq21 C_uq37 a_9917_35471# VDD sg13_lv_pmos ad=0.3808p pd=2.92u as=0.1176p ps=1.33u w=1.12u l=0.13u
X513 VSS D_uq13 D_uq18 VSS sg13_lv_nmos ad=0.1406p pd=1.12u as=0.1406p ps=1.12u w=0.74u l=0.13u
X514 VSS B_uq12 a_34286_10067# VSS sg13_lv_nmos ad=0.187p pd=1.78u as=0.1045p ps=0.93u w=0.55u l=0.13u
X515 VDD a_43174_68339# L_HI_uq27 VDD sg13_lv_pmos ad=1.42837p pd=8.61u as=0.3927p ps=2.99u w=1.155u l=0.13u
X516 Y_uq4 X_uq162 a_36738_8709# VDD sg13_lv_pmos ad=0.3808p pd=2.92u as=0.1176p ps=1.33u w=1.12u l=0.13u
X517 a_51292_68338# L_HI_uq31 VDD VDD sg13_lv_pmos ad=79.8f pd=0.8u as=1.42837p ps=8.61u w=0.42u l=0.13u
X518 VDD a_79068_24446# a_79170_24589# VDD sg13_lv_pmos ad=1.59725p pd=10.05u as=0.3864p ps=2.93u w=1.12u l=0.13u
X519 a_38924_69167# a_39043_68844# VDD VDD sg13_lv_pmos ad=0.3864p pd=2.93u as=0.2128p ps=1.5u w=1.12u l=0.13u
X520 VDD VSS VDD VDD sg13_lv_pmos ad=0.19p pd=1.38u as=0 ps=0 w=1u l=1u
X521 VDD Y_uq113 a_8945_24647# VDD sg13_lv_pmos ad=0.2114p pd=1.54u as=0.2856p ps=2.36u w=0.84u l=0.13u
X522 a_51201_66764# a_50259_66824# a_51107_66997# VDD sg13_lv_pmos ad=79.8f pd=0.8u as=0.1428p ps=1.52u w=0.42u l=0.13u
X523 Y_uq62 X_uq197 VSS VSS sg13_lv_nmos ad=0.2516p pd=2.16u as=0.2516p ps=2.16u w=0.74u l=0.13u
X524 VDD a_31544_66570# A_uq6 VDD sg13_lv_pmos ad=0.2114p pd=1.54u as=0.42p ps=2.99u w=1.12u l=0.13u
X525 a_39514_69318# a_39755_68851# a_39043_68844# VSS sg13_lv_nmos ad=0.1428p pd=1.52u as=0.12665p ps=1.145u w=0.42u l=0.13u
X526 a_30194_65094# D_uq41 VDD VDD sg13_lv_pmos ad=79.8f pd=0.8u as=0.1428p ps=1.52u w=0.42u l=0.13u
X527 VSS q[29] a_45150_8449# VSS sg13_lv_nmos ad=0.14875p pd=1.16u as=0.187p ps=1.78u w=0.55u l=0.13u
X528 a_51854_66606# L_HI_uq18 VSS VSS sg13_lv_nmos ad=60.89999f pd=0.71u as=0.1626p ps=1.415u w=0.42u l=0.13u
X529 a_34108_69850# a_33851_69707# a_34270_69630# VSS sg13_lv_nmos ad=0.1428p pd=1.52u as=37.8f ps=0.6u w=0.42u l=0.13u
X530 a_40646_8789# B_uq21 VSS VSS sg13_lv_nmos ad=0.1045p pd=0.93u as=0.187p ps=1.78u w=0.55u l=0.13u
X531 VDD a_9583_41879# a_9934_41790# VDD sg13_lv_pmos ad=1.17462p pd=7.44u as=93.45f ps=0.865u w=0.42u l=0.13u
X532 VDD L_HI_uq38 a_36214_69853# VDD sg13_lv_pmos ad=0.1563p pd=1.22u as=0.147p ps=1.54u w=0.42u l=0.13u
X533 a_43330_6863# Y_uq2 VSS VSS sg13_lv_nmos ad=0.187p pd=1.78u as=0.14875p ps=1.16u w=0.55u l=0.13u
X534 a_37718_68416# Q_uq44 VDD VDD sg13_lv_pmos ad=0.1176p pd=1.33u as=0.4032p ps=2.96u w=1.12u l=0.13u
X535 a_6585_39650# X_uq314 VDD VDD sg13_lv_pmos ad=0.1596p pd=1.22u as=0.2856p ps=2.36u w=0.84u l=0.13u
X536 VDD L_HI_uq34 a_47474_69630# VDD sg13_lv_pmos ad=0.36237p pd=2.605u as=79.8f ps=0.8u w=0.42u l=0.13u
X537 a_43426_10649# X_uq335 VSS VSS sg13_lv_nmos ad=0.187p pd=1.78u as=0.14875p ps=1.16u w=0.55u l=0.13u
X538 a_47960_63546# Q_uq53 VSS VSS sg13_lv_nmos ad=0.187p pd=1.78u as=0.14875p ps=1.16u w=0.55u l=0.13u
X539 VSS a_79153_28971# a_78872_29193# VSS sg13_lv_nmos ad=79.8f pd=0.8u as=0.1428p ps=1.52u w=0.42u l=0.5u
X540 VDD a_3535_37051# a_3535_37434# VDD sg13_lv_pmos ad=0.2128p pd=1.5u as=0.3864p ps=2.93u w=1.12u l=0.13u
X541 C_uq21 C VDD VDD sg13_lv_pmos ad=0.2128p pd=1.5u as=0.3808p ps=2.92u w=1.12u l=0.13u
X542 D_uq27 C_uq37 VSS VSS sg13_lv_nmos ad=0.2618p pd=2.22u as=0.1463p ps=1.15u w=0.77u l=0.13u
X543 VSS C1_uq8 Y_uq181 VSS sg13_lv_nmos ad=0.1406p pd=1.12u as=0.2516p ps=2.16u w=0.74u l=0.13u
X544 VDD a_37126_68086# a_36845_68308# VDD sg13_lv_pmos ad=0.1523p pd=1.38u as=0.34p ps=2.68u w=1u l=0.5u
X545 a_39874_7625# A_uq81 VDD VDD sg13_lv_pmos ad=0.2856p pd=2.36u as=0.2114p ps=1.54u w=0.84u l=0.13u
X546 VSS X_uq430 Y_uq338 VSS sg13_lv_nmos ad=0.2516p pd=2.16u as=0.1406p ps=1.12u w=0.74u l=0.13u
X547 a_38076_9149# A_uq88 VDD VDD sg13_lv_pmos ad=0.1596p pd=1.22u as=0.2226p ps=1.535u w=0.84u l=0.13u
X548 VDD X_uq80 a_40158_6937# VDD sg13_lv_pmos ad=0.2114p pd=1.54u as=0.2856p ps=2.36u w=0.84u l=0.13u
X549 VSS VDD VSS VSS sg13_lv_nmos ad=79.8f pd=0.8u as=0 ps=-0 w=0.42u l=1u
X550 Y_uq252 Q_uq38 a_36952_64344# VDD sg13_lv_pmos ad=0.3808p pd=2.92u as=0.1176p ps=1.33u w=1.12u l=0.13u
X551 a_40790_65392# X_uq399 VDD VDD sg13_lv_pmos ad=0.1176p pd=1.33u as=0.4032p ps=2.96u w=1.12u l=0.13u
X552 X_uq429 a_37972_68156# VDD VDD sg13_lv_pmos ad=0.42p pd=2.99u as=0.2114p ps=1.54u w=1.12u l=0.13u
X553 Y_uq22 A_uq88 a_38274_10221# VDD sg13_lv_pmos ad=0.3808p pd=2.92u as=0.1176p ps=1.33u w=1.12u l=0.13u
X554 VDD L_HI_uq39 a_32566_69853# VDD sg13_lv_pmos ad=0.1563p pd=1.22u as=0.147p ps=1.54u w=0.42u l=0.13u
X555 VDD a_52065_65252# a_51144_65058# VDD sg13_lv_pmos ad=0.36237p pd=2.605u as=0.34p ps=2.68u w=1u l=0.13u
X556 a_49584_68118# D_uq53 a_49490_68118# VSS sg13_lv_nmos ad=60.89999f pd=0.71u as=0.1428p ps=1.52u w=0.42u l=0.13u
X557 a_41034_69882# a_40835_69945# VSS VSS sg13_lv_nmos ad=0.27427p pd=2.28u as=2.01085p ps=12.81u w=0.795u l=0.13u
X558 a_4297_25191# X_uq259 VDD VDD sg13_lv_pmos ad=0.2464p pd=1.56u as=0.3808p ps=2.92u w=1.12u l=0.13u
X559 Y_uq237 X_uq319 VDD VDD sg13_lv_pmos ad=0.3808p pd=2.92u as=0.3808p ps=2.92u w=1.12u l=0.13u
X560 a_8837_36271# a_8835_37148# a_8916_36654# VDD sg13_lv_pmos ad=79.8f pd=0.8u as=63f ps=0.72u w=0.42u l=0.13u
X561 VDD a_31132_67610# a_31077_67491# VDD sg13_lv_pmos ad=1.19383p pd=7.16u as=93.45f ps=0.865u w=0.42u l=0.13u
X562 a_38414_9489# A_uq88 VSS VSS sg13_lv_nmos ad=0.1045p pd=0.93u as=0.1469p ps=1.155u w=0.55u l=0.13u
X563 X_uq178 a_8849_18599# VSS VSS sg13_lv_nmos ad=0.2886p pd=2.26u as=0.14875p ps=1.16u w=0.74u l=0.13u
X564 VDD X_uq420 a_27706_64400# VDD sg13_lv_pmos ad=0.2618p pd=1.63u as=0.2856p ps=2.36u w=0.84u l=0.13u
X565 VSS a_28658_68122# a_28770_68186# VSS sg13_lv_nmos ad=0.1426p pd=1.16u as=0.1428p ps=1.52u w=0.42u l=0.5u
X566 VDD VSS VDD VDD sg13_lv_pmos ad=0.19p pd=1.38u as=0 ps=0 w=1u l=1u
X567 VSS a_5047_32855# a_5083_32787# VSS sg13_lv_nmos ad=79.8f pd=0.8u as=0.1428p ps=1.52u w=0.42u l=0.13u
X568 Y_uq119 C_uq21 a_11104_25695# VDD sg13_lv_pmos ad=0.3808p pd=2.92u as=0.2128p ps=1.5u w=1.12u l=0.13u
X569 VSS a_48728_65820# q[27] VSS sg13_lv_nmos ad=0.14875p pd=1.16u as=0.2886p ps=2.26u w=0.74u l=0.13u
X570 C_uq44 X_uq345 a_41750_63880# VDD sg13_lv_pmos ad=0.3808p pd=2.92u as=0.1176p ps=1.33u w=1.12u l=0.13u
X571 a_33334_68341# a_33777_68097# a_33717_68509# VDD sg13_lv_pmos ad=79.8f pd=0.8u as=63f ps=0.72u w=0.42u l=0.13u
X572 X_uq73 a_44870_9149# VDD VDD sg13_lv_pmos ad=0.3976p pd=2.95u as=0.2226p ps=1.535u w=1.12u l=0.13u
X573 VSS C_uq20 Y_uq35 VSS sg13_lv_nmos ad=0.2516p pd=2.16u as=0.1406p ps=1.12u w=0.74u l=0.13u
X574 VDD a_47387_66217# a_47644_66098# VDD sg13_lv_pmos ad=1.41367p pd=8.85u as=79.8f ps=0.8u w=0.42u l=0.13u
X575 Q_uq55 a_38166_69928# VDD VDD sg13_lv_pmos ad=0.3808p pd=2.92u as=0.2128p ps=1.5u w=1.12u l=0.13u
X576 VDD a_79910_27102# a_80577_26741# VDD sg13_lv_pmos ad=0.2128p pd=1.5u as=0.3864p ps=2.93u w=1.12u l=0.13u
X577 Y_uq186 X_uq297 VSS VSS sg13_lv_nmos ad=0.2516p pd=2.16u as=0.2516p ps=2.16u w=0.74u l=0.13u
X578 a_42674_67806# D_uq52 VDD VDD sg13_lv_pmos ad=79.8f pd=0.8u as=0.1428p ps=1.52u w=0.42u l=0.13u
X579 B_uq89 S a_6591_38491# VSS sg13_lv_nmos ad=0.2516p pd=2.16u as=0.1406p ps=1.12u w=0.74u l=0.15u
X580 VDD a_3535_41591# a_3886_41502# VDD sg13_lv_pmos ad=1.31615p pd=8.395u as=93.45f ps=0.865u w=0.42u l=0.13u
X581 VDD a_46594_10649# B_uq15 VDD sg13_lv_pmos ad=0.2114p pd=1.54u as=0.42p ps=2.99u w=1.12u l=0.13u
X582 VSS a_78455_20980# Q_uq6 VSS sg13_lv_nmos ad=0.1406p pd=1.12u as=0.2516p ps=2.16u w=0.74u l=0.13u
X583 a_9619_39415# Y_uq210 VSS VSS sg13_lv_nmos ad=37.8f pd=0.6u as=79.8f ps=0.8u w=0.42u l=0.13u
X584 a_38944_9173# A_uq88 Y_uq12 VDD sg13_lv_pmos ad=0.1176p pd=1.33u as=0.3808p ps=2.92u w=1.12u l=0.13u
X585 VSS a_39490_7625# X_uq52 VSS sg13_lv_nmos ad=0.14875p pd=1.16u as=0.2886p ps=2.26u w=0.74u l=0.13u
X586 VSS X_uq432 a_37972_68156# VSS sg13_lv_nmos ad=0.14875p pd=1.16u as=0.187p ps=1.78u w=0.55u l=0.13u
X587 A_uq94 a_33734_10301# VDD VDD sg13_lv_pmos ad=0.3976p pd=2.95u as=0.2226p ps=1.535u w=1.12u l=0.13u
X588 a_46018_6863# Y_uq8 VSS VSS sg13_lv_nmos ad=0.187p pd=1.78u as=0.14875p ps=1.16u w=0.55u l=0.13u
X589 VSS a_43138_7625# X_uq61 VSS sg13_lv_nmos ad=0.14875p pd=1.16u as=0.2886p ps=2.26u w=0.74u l=0.13u
X590 a_43042_10649# q[21] VDD VDD sg13_lv_pmos ad=0.2856p pd=2.36u as=0.2114p ps=1.54u w=0.84u l=0.13u
X591 a_4420_42743# Y_uq238 VDD VDD sg13_lv_pmos ad=79.8f pd=0.8u as=1.31615p ps=8.395u w=0.42u l=0.13u
X592 VSS a_43810_10649# B_uq18 VSS sg13_lv_nmos ad=0.14875p pd=1.16u as=0.2886p ps=2.26u w=0.74u l=0.13u
X593 VSS a_42293_63528# a_42214_63803# VSS sg13_lv_nmos ad=3.5825p pd=23.78u as=0.27427p ps=2.28u w=0.795u l=0.13u
X594 B_uq83 A0 VDD VDD sg13_lv_pmos ad=0.2128p pd=1.5u as=0.2128p ps=1.5u w=1.12u l=0.13u
X595 a_50193_68097# clk VSS VSS sg13_lv_nmos ad=0.2516p pd=2.16u as=2.0066p ps=12.72u w=0.74u l=0.13u
X596 VSS a_35002_69819# X_uq454 VSS sg13_lv_nmos ad=0.1426p pd=1.16u as=0.2516p ps=2.16u w=0.74u l=0.13u
X597 VSS VDD VSS VSS sg13_lv_nmos ad=0.1428p pd=1.52u as=0 ps=-0 w=0.42u l=1u
X598 VSS B_uq89 a_6641_39472# VSS sg13_lv_nmos ad=0.1331p pd=1.12u as=0.1216p ps=1.02u w=0.64u l=0.13u
X599 Q_uq56 a_34518_69928# VDD VDD sg13_lv_pmos ad=0.3808p pd=2.92u as=0.2128p ps=1.5u w=1.12u l=0.13u
X600 VDD B_uq63 C_uq8 VDD sg13_lv_pmos ad=0.2128p pd=1.5u as=0.2128p ps=1.5u w=1.12u l=0.13u
X601 Q_uq15 a_6559_33594# VSS VSS sg13_lv_nmos ad=0.2516p pd=2.16u as=0.1406p ps=1.12u w=0.74u l=0.13u
X602 VSS X_uq424 C_uq62 VSS sg13_lv_nmos ad=0.2516p pd=2.16u as=0.1406p ps=1.12u w=0.74u l=0.13u
X603 a_33730_7625# SL[0] VDD VDD sg13_lv_pmos ad=0.2856p pd=2.36u as=0.2114p ps=1.54u w=0.84u l=0.13u
X604 a_5096_31593# a_5058_32645# a_5092_31287# VSS sg13_lv_nmos ad=0.2373p pd=1.97u as=79.8f ps=0.8u w=0.42u l=0.13u
X605 a_4072_21869# D_uq3 a_3978_21869# VSS sg13_lv_nmos ad=60.89999f pd=0.71u as=0.1428p ps=1.52u w=0.42u l=0.13u
X606 a_28562_69630# D_uq65 VDD VDD sg13_lv_pmos ad=79.8f pd=0.8u as=0.1428p ps=1.52u w=0.42u l=0.13u
X607 VDD B_uq78 a_6893_34952# VDD sg13_lv_pmos ad=0.3808p pd=2.92u as=0.2464p ps=1.56u w=1.12u l=0.13u
X608 a_76438_22597# B1_uq6 VSS VSS sg13_lv_nmos ad=0.13875p pd=1.115u as=0.2553p ps=2.17u w=0.74u l=0.13u
X609 a_29590_67336# a_30033_67379# a_29330_67806# VSS sg13_lv_nmos ad=79.8f pd=0.8u as=0.1296p ps=1.52u w=0.42u l=0.13u
X610 a_11957_20111# C_uq4 Y_uq54 VDD sg13_lv_pmos ad=0.1176p pd=1.33u as=0.3808p ps=2.92u w=1.12u l=0.13u
X611 X_uq27 a_35934_6937# VSS VSS sg13_lv_nmos ad=0.2886p pd=2.26u as=0.14875p ps=1.16u w=0.74u l=0.13u
X612 C_uq5 B_uq63 VDD VDD sg13_lv_pmos ad=0.2128p pd=1.5u as=0.2128p ps=1.5u w=1.12u l=0.13u
X613 a_8115_37211# A0 a_8115_37109# VSS sg13_lv_nmos ad=0.1406p pd=1.12u as=0.1406p ps=1.12u w=0.74u l=0.13u
X614 a_47553_64391# a_46611_64431# a_47414_64624# VSS sg13_lv_nmos ad=79.8f pd=0.8u as=0.2373p ps=1.97u w=0.42u l=0.13u
X615 VSS Q_uq31 Y_uq289 VSS sg13_lv_nmos ad=0.2516p pd=2.16u as=0.1406p ps=1.12u w=0.74u l=0.13u
X616 VDD a_8956_37847# a_8992_37758# VDD sg13_lv_pmos ad=1.5243p pd=9.795u as=93.45f ps=0.865u w=0.42u l=0.13u
X617 a_78651_24785# a_79170_24589# a_79910_24544# VSS sg13_lv_nmos ad=0.3473p pd=2.71u as=0.12665p ps=1.145u w=0.74u l=0.13u
X618 C_uq42 X_uq382 VSS VSS sg13_lv_nmos ad=0.1406p pd=1.12u as=0.2516p ps=2.16u w=0.74u l=0.13u
X619 Q_uq22 a_3535_42138# VDD VDD sg13_lv_pmos ad=0.3808p pd=2.92u as=0.2128p ps=1.5u w=1.12u l=0.13u
X620 a_30586_63771# a_30701_63772# VDD VDD sg13_lv_pmos ad=0.34p pd=2.68u as=0.2254p ps=1.53u w=1u l=0.5u
X621 VSS Y_uq232 a_9307_40809# VSS sg13_lv_nmos ad=0.1626p pd=1.415u as=60.89999f ps=0.71u w=0.42u l=0.13u
X622 a_46594_10649# q[26] VDD VDD sg13_lv_pmos ad=0.2856p pd=2.36u as=0.2114p ps=1.54u w=0.84u l=0.13u
X623 a_37329_64344# X_uq435 VDD VDD sg13_lv_pmos ad=0.2464p pd=1.56u as=0.3808p ps=2.92u w=1.12u l=0.13u
X624 VDD a_52067_66687# a_52067_66921# VDD sg13_lv_pmos ad=1.19383p pd=7.16u as=0.2442p ps=2.06u w=0.66u l=0.13u
X625 a_42680_63546# Q_uq33 VSS VSS sg13_lv_nmos ad=0.187p pd=1.78u as=0.14875p ps=1.16u w=0.55u l=0.13u
X626 a_80197_23984# a_80312_23983# VDD VDD sg13_lv_pmos ad=0.34p pd=2.68u as=0.2254p ps=1.53u w=1u l=0.5u
X627 a_9840_24671# C_uq19 a_9746_24671# VDD sg13_lv_pmos ad=0.19p pd=1.38u as=0.34p ps=2.68u w=1u l=0.13u
X628 Y_uq107 C_uq15 VSS VSS sg13_lv_nmos ad=0.1406p pd=1.12u as=0.2516p ps=2.16u w=0.74u l=0.13u
X629 a_34523_66683# a_33681_66585# a_34429_66683# VSS sg13_lv_nmos ad=0.12665p pd=1.145u as=0.1428p ps=1.52u w=0.42u l=0.13u
X630 VDD a_4299_42044# a_4335_41975# VDD sg13_lv_pmos ad=1.31615p pd=8.395u as=0.3864p ps=2.93u w=1.12u l=0.13u
X631 VSS Y_uq35 a_9233_18599# VSS sg13_lv_nmos ad=0.14875p pd=1.16u as=0.187p ps=1.78u w=0.55u l=0.13u
X632 a_50354_67806# D_uq50 VDD VDD sg13_lv_pmos ad=79.8f pd=0.8u as=0.1428p ps=1.52u w=0.42u l=0.13u
X633 a_6595_41001# D_uq31 a_6595_40907# VSS sg13_lv_nmos ad=60.89999f pd=0.71u as=0.1428p ps=1.52u w=0.42u l=0.13u
X634 VDD C_uq24 a_10852_23191# VDD sg13_lv_pmos ad=0.2198p pd=1.53u as=0.2856p ps=2.36u w=0.84u l=0.13u
X635 VSS C_uq22 Y_uq122 VSS sg13_lv_nmos ad=0.1463p pd=1.15u as=0.1694p ps=1.21u w=0.77u l=0.13u
X636 WL_REF a_7321_43295# VDD VDD sg13_lv_pmos ad=0.42p pd=2.99u as=0.2114p ps=1.54u w=1.12u l=0.13u
X637 a_79758_23717# B_uq42 a_79644_23717# VDD sg13_lv_pmos ad=0.2128p pd=1.5u as=0.2464p ps=1.56u w=1.12u l=0.13u
X638 VSS X_uq399 C_uq59 VSS sg13_lv_nmos ad=0.2516p pd=2.16u as=0.1406p ps=1.12u w=0.74u l=0.13u
X639 VDD B_uq33 a_10343_18965# VDD sg13_lv_pmos ad=0.2198p pd=1.53u as=0.2856p ps=2.36u w=0.84u l=0.13u
X640 C_uq16 a_10289_21623# VSS VSS sg13_lv_nmos ad=0.2886p pd=2.26u as=0.14875p ps=1.16u w=0.74u l=0.13u
X641 a_6986_41550# a_6559_42573# VDD VDD sg13_lv_pmos ad=63f pd=0.72u as=0.1563p ps=1.22u w=0.42u l=0.13u
X642 a_39874_8375# Y_uq15 VDD VDD sg13_lv_pmos ad=0.2856p pd=2.36u as=0.2114p ps=1.54u w=0.84u l=0.13u
X643 a_29434_65283# a_29549_65284# VDD VDD sg13_lv_pmos ad=0.34p pd=2.68u as=0.2254p ps=1.53u w=1u l=0.5u
X644 VDD X_uq163 a_34116_10741# VDD sg13_lv_pmos ad=0.2618p pd=1.63u as=0.2856p ps=2.36u w=0.84u l=0.13u
X645 a_4420_33911# a_4297_34356# a_4771_34039# VSS sg13_lv_nmos ad=0.1428p pd=1.52u as=37.8f ps=0.6u w=0.42u l=0.13u
X646 a_43344_65860# a_43318_65824# VDD VDD sg13_lv_pmos ad=0.34p pd=2.68u as=0.36237p ps=2.605u w=1u l=0.13u
X647 VDD S B_uq89 VDD sg13_lv_pmos ad=0.3808p pd=2.92u as=0.2128p ps=1.5u w=1.12u l=0.15u
X648 a_43248_67793# a_43479_67379# a_42934_67336# VSS sg13_lv_nmos ad=0.2373p pd=1.97u as=79.8f ps=0.8u w=0.42u l=0.13u
X649 a_38662_66574# Q_uq38 VDD VDD sg13_lv_pmos ad=0.1428p pd=1.52u as=0.1523p ps=1.38u w=0.42u l=0.13u
X650 a_11467_21623# D_uq7 a_11365_21623# VDD sg13_lv_pmos ad=0.2128p pd=1.5u as=0.2128p ps=1.5u w=1.12u l=0.13u
X651 VDD a_47960_63546# q[22] VDD sg13_lv_pmos ad=0.2114p pd=1.54u as=0.42p ps=2.99u w=1.12u l=0.13u
X652 D_uq49 X_uq436 VSS VSS sg13_lv_nmos ad=0.1694p pd=1.21u as=0.2618p ps=2.22u w=0.77u l=0.13u
X653 VSS a_44860_66098# a_44509_66217# VSS sg13_lv_nmos ad=79.8f pd=0.8u as=0.1428p ps=1.52u w=0.42u l=0.13u
X654 Y_uq324 X_uq435 VSS VSS sg13_lv_nmos ad=0.1694p pd=1.21u as=0.2618p ps=2.22u w=0.77u l=0.13u
X655 VSS din[18] a_75295_22993# VSS sg13_lv_nmos ad=0.14875p pd=1.16u as=0.187p ps=1.78u w=0.55u l=0.13u
X656 VDD a_51707_64705# a_51964_64586# VDD sg13_lv_pmos ad=1.4745p pd=9.07u as=79.8f ps=0.8u w=0.42u l=0.13u
X657 Y_uq349 a_27802_68936# VSS VSS sg13_lv_nmos ad=0.1406p pd=1.12u as=0.17255p ps=1.25u w=0.74u l=0.13u
X658 a_43377_68161# a_43377_68161# VSS VSS sg13_lv_nmos ad=0.111p pd=1.34u as=2.08687p ps=13.23u w=0.3u l=0.13u
X659 a_49778_65856# a_49508_65897# VSS VSS sg13_lv_nmos ad=0.1428p pd=1.52u as=79.8f ps=0.8u w=0.42u l=0.5u
X660 a_36945_67379# clk VSS VSS sg13_lv_nmos ad=0.2516p pd=2.16u as=2.0066p ps=12.72u w=0.74u l=0.13u
X661 VDD X_uq200 a_8561_20899# VDD sg13_lv_pmos ad=0.2114p pd=1.54u as=0.2856p ps=2.36u w=0.84u l=0.13u
X662 VDD a_7742_21837# a_7461_22059# VDD sg13_lv_pmos ad=0.1523p pd=1.38u as=0.34p ps=2.68u w=1u l=0.5u
X663 VSS X_uq432 a_34804_68880# VSS sg13_lv_nmos ad=0.14875p pd=1.16u as=0.187p ps=1.78u w=0.55u l=0.13u
X664 a_10567_18965# C_uq16 VSS VSS sg13_lv_nmos ad=0.1406p pd=1.12u as=0.18575p ps=1.26u w=0.74u l=0.13u
X665 VDD a_10345_37044# a_10468_36599# VDD sg13_lv_pmos ad=1.17462p pd=7.44u as=79.8f ps=0.8u w=0.42u l=0.13u
X666 a_34514_66294# a_35319_65867# a_34774_65824# VDD sg13_lv_pmos ad=0.1428p pd=1.52u as=79.8f ps=0.8u w=0.42u l=0.13u
X667 VSS a_34523_66683# a_35190_66904# VSS sg13_lv_nmos ad=0.1406p pd=1.12u as=0.2516p ps=2.16u w=0.74u l=0.13u
X668 Y_uq358 Q_uq53 VDD VDD sg13_lv_pmos ad=0.3808p pd=2.92u as=0.3808p ps=2.92u w=1.12u l=0.13u
X669 a_32896_10221# X_uq168 Y_uq26 VDD sg13_lv_pmos ad=0.1176p pd=1.33u as=0.3808p ps=2.92u w=1.12u l=0.13u
X670 a_4771_32169# D_uq15 a_4380_32906# VSS sg13_lv_nmos ad=60.89999f pd=0.71u as=0.1428p ps=1.52u w=0.42u l=0.13u
X671 C_uq9 Y_uq52 a_76939_19957# VSS sg13_lv_nmos ad=0.2516p pd=2.16u as=0.1406p ps=1.12u w=0.74u l=0.13u
X672 VDD a_40859_67729# a_41526_67368# VDD sg13_lv_pmos ad=0.2128p pd=1.5u as=0.3864p ps=2.93u w=1.12u l=0.13u
X673 X_uq56 a_32862_7661# VSS VSS sg13_lv_nmos ad=0.2886p pd=2.26u as=0.14875p ps=1.16u w=0.74u l=0.13u
X674 VDD a_5047_32855# a_5398_32766# VDD sg13_lv_pmos ad=1.86053p pd=12.055u as=93.45f ps=0.865u w=0.42u l=0.13u
X675 VDD a_32792_68082# X_uq458 VDD sg13_lv_pmos ad=0.2114p pd=1.54u as=0.42p ps=2.99u w=1.12u l=0.13u
X676 B_uq81 a_5809_35317# VDD VDD sg13_lv_pmos ad=0.4256p pd=3u as=0.2254p ps=1.53u w=1.12u l=0.13u
X677 VSS Y_uq306 D_uq52 VSS sg13_lv_nmos ad=0.1463p pd=1.15u as=0.1694p ps=1.21u w=0.77u l=0.13u
X678 VDD a_40334_9489# X_uq80 VDD sg13_lv_pmos ad=0.2226p pd=1.535u as=0.3976p ps=2.95u w=1.12u l=0.13u
X679 VDD a_80167_24687# a_80112_24782# VDD sg13_lv_pmos ad=1.59725p pd=10.05u as=93.45f ps=0.865u w=0.42u l=0.13u
X680 a_5381_39104# B_uq93 VDD VDD sg13_lv_pmos ad=0.3808p pd=2.92u as=0.2128p ps=1.5u w=1.12u l=0.13u
X681 a_35770_65283# a_35885_65284# VSS VSS sg13_lv_nmos ad=0.1428p pd=1.52u as=0.1426p ps=1.16u w=0.42u l=0.5u
X682 Y_uq76 X_uq236 VSS VSS sg13_lv_nmos ad=0.1694p pd=1.21u as=0.2618p ps=2.22u w=0.77u l=0.13u
X683 Y_uq20 A_uq87 a_40674_10221# VDD sg13_lv_pmos ad=0.3808p pd=2.92u as=0.1176p ps=1.33u w=1.12u l=0.13u
X684 VSS a_42178_6863# X_uq11 VSS sg13_lv_nmos ad=0.14875p pd=1.16u as=0.2886p ps=2.26u w=0.74u l=0.13u
X685 VSS VDD VSS VSS sg13_lv_nmos ad=79.8f pd=0.8u as=0 ps=-0 w=0.42u l=1u
X686 a_4264_22187# a_4783_21991# a_5523_21946# VSS sg13_lv_nmos ad=0.3473p pd=2.71u as=0.12665p ps=1.145u w=0.74u l=0.13u
X687 VDD a_33536_68844# a_33494_68880# VDD sg13_lv_pmos ad=0.2618p pd=1.63u as=0.1176p ps=1.33u w=1.12u l=0.13u
X688 a_41361_64344# X_uq447 VDD VDD sg13_lv_pmos ad=0.2464p pd=1.56u as=0.3808p ps=2.92u w=1.12u l=0.13u
X689 VSS VDD VSS VSS sg13_lv_nmos ad=79.8f pd=0.8u as=0 ps=-0 w=0.42u l=1u
X690 a_44496_68884# a_44470_68848# VSS VSS sg13_lv_nmos ad=0.2516p pd=2.16u as=0.1626p ps=1.415u w=0.74u l=0.13u
X691 VDD a_38338_7625# X_uq112 VDD sg13_lv_pmos ad=0.2114p pd=1.54u as=0.42p ps=2.99u w=1.12u l=0.13u
X692 a_48341_63528# a_48465_63625# VDD VDD sg13_lv_pmos ad=0.2442p pd=2.06u as=1.4745p ps=9.07u w=0.66u l=0.13u
X693 a_50928_67793# a_51159_67379# a_50614_67336# VSS sg13_lv_nmos ad=0.2373p pd=1.97u as=79.8f ps=0.8u w=0.42u l=0.13u
X694 a_5047_32855# a_5047_33019# a_5083_32983# VSS sg13_lv_nmos ad=0.1428p pd=1.52u as=37.8f ps=0.6u w=0.42u l=0.13u
X695 a_78365_27179# D_uq10 VDD VDD sg13_lv_pmos ad=79.8f pd=0.8u as=0.1428p ps=1.52u w=0.42u l=0.13u
X696 B_uq55 a_9746_24671# VDD VDD sg13_lv_pmos ad=0.3808p pd=2.92u as=0.3822p ps=1.84u w=1.12u l=0.13u
X697 VDD X_uq455 a_28378_67424# VDD sg13_lv_pmos ad=0.2618p pd=1.63u as=0.2856p ps=2.36u w=0.84u l=0.13u
X698 a_39158_66904# X_uq400 Y_uq308 VDD sg13_lv_pmos ad=0.1176p pd=1.33u as=0.3808p ps=2.92u w=1.12u l=0.13u
X699 Y_uq139 X_uq273 VSS VSS sg13_lv_nmos ad=0.2516p pd=2.16u as=0.2516p ps=2.16u w=0.74u l=0.13u
X700 VDD VSS VDD VDD sg13_lv_pmos ad=0.19p pd=1.38u as=0 ps=0 w=1u l=1u
X701 a_49240_66904# a_49018_66648# VDD VDD sg13_lv_pmos ad=0.1176p pd=1.33u as=0.2618p ps=1.63u w=1.12u l=0.13u
X702 VSS a_6494_22595# a_6213_22897# VSS sg13_lv_nmos ad=79.8f pd=0.8u as=0.1428p ps=1.52u w=0.42u l=0.5u
X703 a_49776_68436# a_49750_68341# VDD VDD sg13_lv_pmos ad=0.34p pd=2.68u as=0.36237p ps=2.605u w=1u l=0.13u
X704 Y_uq80 Q_uq6 VSS VSS sg13_lv_nmos ad=0.1406p pd=1.12u as=0.2516p ps=2.16u w=0.74u l=0.13u
X705 a_7742_24107# Q_uq4 VDD VDD sg13_lv_pmos ad=0.1428p pd=1.52u as=0.1523p ps=1.38u w=0.42u l=0.13u
X706 a_46174_69318# L_HI_uq35 VSS VSS sg13_lv_nmos ad=37.8f pd=0.6u as=79.8f ps=0.8u w=0.42u l=0.13u
X707 a_46306_9887# q[27] VSS VSS sg13_lv_nmos ad=0.187p pd=1.78u as=0.14875p ps=1.16u w=0.55u l=0.13u
X708 a_30897_65073# clk VDD VDD sg13_lv_pmos ad=0.4088p pd=2.97u as=1.37835p ps=8.63u w=1.12u l=0.13u
X709 VSS a_30875_69241# a_31542_68880# VSS sg13_lv_nmos ad=0.1406p pd=1.12u as=0.2516p ps=2.16u w=0.74u l=0.13u
X710 Y_uq11 A_uq87 a_40002_9173# VDD sg13_lv_pmos ad=0.3808p pd=2.92u as=0.1176p ps=1.33u w=1.12u l=0.13u
X711 D_uq32 C_uq37 a_8849_39933# VDD sg13_lv_pmos ad=0.2128p pd=1.5u as=0.2128p ps=1.5u w=1.12u l=0.15u
X712 a_29361_65867# clk VSS VSS sg13_lv_nmos ad=0.2516p pd=2.16u as=1.7977p ps=11.53u w=0.74u l=0.13u
X713 VSS B_uq70 B1_uq2 VSS sg13_lv_nmos ad=0.2516p pd=2.16u as=0.2516p ps=2.16u w=0.74u l=0.13u
X714 D_uq46 X_uq436 VSS VSS sg13_lv_nmos ad=0.1694p pd=1.21u as=0.2618p ps=2.22u w=0.77u l=0.13u
X715 VSS a_42406_65062# a_42125_65284# VSS sg13_lv_nmos ad=79.8f pd=0.8u as=0.1428p ps=1.52u w=0.42u l=0.5u
X716 a_45634_7625# X_uq96 VDD VDD sg13_lv_pmos ad=0.2856p pd=2.36u as=0.2114p ps=1.54u w=0.84u l=0.13u
X717 a_6595_40907# a_6570_42533# a_6604_41175# VDD sg13_lv_pmos ad=0.1428p pd=1.52u as=79.8f ps=0.8u w=0.42u l=0.13u
X718 a_49784_68844# X_uq280 VSS VSS sg13_lv_nmos ad=0.187p pd=1.78u as=0.14875p ps=1.16u w=0.55u l=0.13u
X719 VDD B_uq79 a_5845_33032# VDD sg13_lv_pmos ad=0.3808p pd=2.92u as=0.2464p ps=1.56u w=1.12u l=0.13u
X720 VSS a_6585_34382# B_uq79 VSS sg13_lv_nmos ad=0.1331p pd=1.12u as=0.2516p ps=2.16u w=0.74u l=0.13u
X721 VSS a_78059_19145# B1_uq7 VSS sg13_lv_nmos ad=0.17255p pd=1.25u as=0.1406p ps=1.12u w=0.74u l=0.13u
X722 a_37499_69707# a_36657_69609# a_37405_69707# VSS sg13_lv_nmos ad=0.12665p pd=1.145u as=0.1428p ps=1.52u w=0.42u l=0.13u
X723 a_52661_66194# a_52785_65893# VDD VDD sg13_lv_pmos ad=0.2442p pd=2.06u as=1.41367p ps=8.85u w=0.66u l=0.13u
X724 a_37786_65283# a_37901_65284# VSS VSS sg13_lv_nmos ad=0.1428p pd=1.52u as=0.1426p ps=1.16u w=0.42u l=0.5u
X725 a_77138_26741# C1_uq4 Y_uq142 VDD sg13_lv_pmos ad=0.2128p pd=1.5u as=0.3808p ps=2.92u w=1.12u l=0.13u
X726 a_50193_68097# clk VDD VDD sg13_lv_pmos ad=0.4088p pd=2.97u as=1.39265p ps=8.395u w=1.12u l=0.13u
X727 a_4337_41193# a_4301_41167# VSS VSS sg13_lv_nmos ad=0.2516p pd=2.16u as=0.1626p ps=1.415u w=0.74u l=0.13u
X728 VSS a_33681_66585# a_33783_66728# VSS sg13_lv_nmos ad=1.8643p pd=11.96u as=0.2516p ps=2.16u w=0.74u l=0.13u
X729 VSS a_38385_64355# a_38487_64355# VSS sg13_lv_nmos ad=4.5737p pd=28.36u as=0.2516p ps=2.16u w=0.74u l=0.13u
X730 VSS a_41627_66217# a_42294_65856# VSS sg13_lv_nmos ad=0.1406p pd=1.12u as=0.2516p ps=2.16u w=0.74u l=0.13u
X731 X_uq281 a_8833_31967# VDD VDD sg13_lv_pmos ad=0.42p pd=2.99u as=0.2114p ps=1.54u w=1.12u l=0.13u
X732 X_uq240 a_8945_24647# VSS VSS sg13_lv_nmos ad=0.2886p pd=2.26u as=0.14875p ps=1.16u w=0.74u l=0.13u
X733 VDD a_39374_9489# X_uq82 VDD sg13_lv_pmos ad=0.2226p pd=1.535u as=0.3976p ps=2.95u w=1.12u l=0.13u
X734 VSS a_39490_8375# X_uq81 VSS sg13_lv_nmos ad=0.14875p pd=1.16u as=0.2886p ps=2.26u w=0.74u l=0.13u
X735 a_6563_39963# X_uq314 a_6893_40095# VDD sg13_lv_pmos ad=0.2225p pd=1.445u as=0.2975p ps=1.595u w=1u l=0.13u
X736 D_uq34 C_uq43 a_45411_64344# VDD sg13_lv_pmos ad=0.3808p pd=2.92u as=0.2128p ps=1.5u w=1.12u l=0.13u
X737 D_uq31 D_uq25 VSS VSS sg13_lv_nmos ad=0.2618p pd=2.22u as=0.1463p ps=1.15u w=0.77u l=0.13u
X738 Y_uq65 D_uq1 a_12256_21623# VDD sg13_lv_pmos ad=0.3808p pd=2.92u as=0.2128p ps=1.5u w=1.12u l=0.13u
X739 a_31818_63834# a_31619_63897# VSS VSS sg13_lv_nmos ad=0.27427p pd=2.28u as=3.5825p ps=23.78u w=0.795u l=0.13u
X740 VSS C_uq20 Y_uq39 VSS sg13_lv_nmos ad=0.2516p pd=2.16u as=0.1406p ps=1.12u w=0.74u l=0.13u
X741 VDD C C_uq20 VDD sg13_lv_pmos ad=0.2128p pd=1.5u as=0.2128p ps=1.5u w=1.12u l=0.13u
X742 a_7357_31815# C_uq31 a_7357_31713# VDD sg13_lv_pmos ad=0.2128p pd=1.5u as=0.2128p ps=1.5u w=1.12u l=0.13u
X743 Y_uq243 Q_uq43 VSS VSS sg13_lv_nmos ad=0.1406p pd=1.12u as=0.2516p ps=2.16u w=0.74u l=0.13u
X744 a_9917_37212# D_uq24 a_9917_37098# VDD sg13_lv_pmos ad=0.2128p pd=1.5u as=0.2464p ps=1.56u w=1.12u l=0.13u
X745 a_52006_63550# Q_uq40 VDD VDD sg13_lv_pmos ad=0.1428p pd=1.52u as=0.1523p ps=1.38u w=0.42u l=0.13u
X746 Y_uq339 Q_uq57 VDD VDD sg13_lv_pmos ad=0.3808p pd=2.92u as=0.3808p ps=2.92u w=1.12u l=0.13u
X747 Y_uq72 X_uq222 VDD VDD sg13_lv_pmos ad=0.3808p pd=2.92u as=0.3808p ps=2.92u w=1.12u l=0.13u
X748 VSS a_48245_68064# a_48166_68339# VSS sg13_lv_nmos ad=2.08687p pd=13.23u as=0.27427p ps=2.28u w=0.795u l=0.13u
X749 a_5087_38335# B_uq88 VSS VSS sg13_lv_nmos ad=0.1406p pd=1.12u as=0.2516p ps=2.16u w=0.74u l=0.13u
X750 VSS X_uq448 a_46330_68160# VSS sg13_lv_nmos ad=0.17255p pd=1.25u as=0.187p ps=1.78u w=0.55u l=0.13u
X751 Y_uq25 X_uq162 VSS VSS sg13_lv_nmos ad=0.1406p pd=1.12u as=0.2516p ps=2.16u w=0.74u l=0.13u
X752 D_uq64 C_uq71 a_33123_68880# VDD sg13_lv_pmos ad=0.3808p pd=2.92u as=0.2128p ps=1.5u w=1.12u l=0.13u
X753 VSS Y_uq360 a_38852_69634# VSS sg13_lv_nmos ad=79.8f pd=0.8u as=0.1428p ps=1.52u w=0.42u l=0.13u
X754 a_39490_8375# q[15] VSS VSS sg13_lv_nmos ad=0.187p pd=1.78u as=0.14875p ps=1.16u w=0.55u l=0.13u
X755 X_uq221 a_75679_23717# VDD VDD sg13_lv_pmos ad=0.42p pd=2.99u as=0.2114p ps=1.54u w=1.12u l=0.13u
X756 a_6217_24872# clk VSS VSS sg13_lv_nmos ad=0.2516p pd=2.16u as=2.36857p ps=14.835u w=0.74u l=0.13u
X757 VDD a_44792_64308# X_uq362 VDD sg13_lv_pmos ad=0.2114p pd=1.54u as=0.42p ps=2.99u w=1.12u l=0.13u
X758 a_30875_69241# a_30033_68891# a_30781_69241# VSS sg13_lv_nmos ad=0.12665p pd=1.145u as=0.1428p ps=1.52u w=0.42u l=0.13u
X759 VSS a_45250_7625# X_uq41 VSS sg13_lv_nmos ad=0.14875p pd=1.16u as=0.2886p ps=2.26u w=0.74u l=0.13u
X760 VDD a_46402_6863# X VDD sg13_lv_pmos ad=0.2114p pd=1.54u as=0.42p ps=2.99u w=1.12u l=0.13u
X761 VDD X_uq236 a_10791_24647# VDD sg13_lv_pmos ad=0.3808p pd=2.92u as=0.2128p ps=1.5u w=1.12u l=0.13u
X762 VSS C1_uq4 Y_uq82 VSS sg13_lv_nmos ad=0.1406p pd=1.12u as=0.2516p ps=2.16u w=0.74u l=0.13u
X763 B_uq60 a_4562_23423# VSS VSS sg13_lv_nmos ad=0.1406p pd=1.12u as=0.17255p ps=1.25u w=0.74u l=0.13u
X764 Y_uq127 X_uq263 VSS VSS sg13_lv_nmos ad=0.2516p pd=2.16u as=0.2516p ps=2.16u w=0.74u l=0.13u
X765 Y_uq9 X_uq137 a_44130_9173# VDD sg13_lv_pmos ad=0.3808p pd=2.92u as=0.1176p ps=1.33u w=1.12u l=0.13u
X766 D_uq24 D_uq25 VDD VDD sg13_lv_pmos ad=0.3808p pd=2.92u as=0.3808p ps=2.92u w=1.12u l=0.13u
X767 VSS Q_uq2 a_77248_23741# VSS sg13_lv_nmos ad=0.13395p pd=1.12u as=0.198p ps=1.27u w=0.55u l=0.13u
X768 X_uq297 a_4297_35327# VDD VDD sg13_lv_pmos ad=0.42p pd=2.99u as=0.2114p ps=1.54u w=1.12u l=0.13u
X769 a_33898_9137# X_uq93 VDD VDD sg13_lv_pmos ad=0.2856p pd=2.36u as=0.2618p ps=1.63u w=0.84u l=0.13u
X770 X_uq263 a_75679_26741# VSS VSS sg13_lv_nmos ad=0.2886p pd=2.26u as=0.14875p ps=1.16u w=0.74u l=0.13u
X771 a_27695_65392# Y_uq271 a_27593_65392# VDD sg13_lv_pmos ad=0.2464p pd=1.56u as=0.2128p ps=1.5u w=1.12u l=0.13u
X772 a_3571_33467# Y_uq172 VDD VDD sg13_lv_pmos ad=79.8f pd=0.8u as=0.36237p ps=2.605u w=0.42u l=0.13u
X773 a_50170_66606# a_50411_66876# a_49699_66570# VSS sg13_lv_nmos ad=0.1428p pd=1.52u as=0.12665p ps=1.145u w=0.42u l=0.13u
X774 a_46018_7625# X_uq73 VSS VSS sg13_lv_nmos ad=0.187p pd=1.78u as=0.14875p ps=1.16u w=0.55u l=0.13u
X775 a_4297_36991# Y_uq195 VSS VSS sg13_lv_nmos ad=0.1428p pd=1.52u as=79.8f ps=0.8u w=0.42u l=0.13u
X776 Y_uq271 Q_uq39 VSS VSS sg13_lv_nmos ad=0.1406p pd=1.12u as=0.2516p ps=2.16u w=0.74u l=0.13u
X777 VSS D_uq14 D_uq18 VSS sg13_lv_nmos ad=0.23757p pd=2.16u as=0.1406p ps=1.12u w=0.74u l=0.13u
X778 VSS Q_uq27 a_3535_43295# VSS sg13_lv_nmos ad=0.14875p pd=1.16u as=0.187p ps=1.78u w=0.55u l=0.13u
X779 B_uq60 B_uq49 a_4784_23679# VDD sg13_lv_pmos ad=0.3808p pd=2.92u as=0.1176p ps=1.33u w=1.12u l=0.13u
X780 VDD a_3580_33241# a_3535_31809# VDD sg13_lv_pmos ad=0.36237p pd=2.605u as=0.34p ps=2.68u w=1u l=0.13u
X781 a_50736_64769# a_50967_64355# a_50422_64312# VSS sg13_lv_nmos ad=0.2373p pd=1.97u as=79.8f ps=0.8u w=0.42u l=0.13u
X782 a_44792_64308# Y_uq247 VDD VDD sg13_lv_pmos ad=0.2856p pd=2.36u as=0.2114p ps=1.54u w=0.84u l=0.13u
X783 VSS Y_uq194 a_3571_35145# VSS sg13_lv_nmos ad=0.1626p pd=1.415u as=60.89999f ps=0.71u w=0.42u l=0.13u
X784 VSS a_46421_63528# a_46342_63803# VSS sg13_lv_nmos ad=3.5825p pd=23.78u as=0.27427p ps=2.28u w=0.795u l=0.13u
X785 a_46418_66610# a_46148_66610# VSS VSS sg13_lv_nmos ad=0.1428p pd=1.52u as=79.8f ps=0.8u w=0.42u l=0.5u
X786 a_76765_24493# Y_uq105 B2_uq7 VSS sg13_lv_nmos ad=0.1406p pd=1.12u as=0.2516p ps=2.16u w=0.74u l=0.13u
X787 VSS a_3535_41755# a_3535_42138# VSS sg13_lv_nmos ad=0.1406p pd=1.12u as=0.2516p ps=2.16u w=0.74u l=0.13u
X788 a_44698_65283# a_44813_65284# VDD VDD sg13_lv_pmos ad=0.34p pd=2.68u as=0.2254p ps=1.53u w=1u l=0.5u
X789 a_41116_67610# a_40859_67729# a_41278_67806# VSS sg13_lv_nmos ad=0.1428p pd=1.52u as=37.8f ps=0.6u w=0.42u l=0.13u
X790 VSS a_79886_21524# a_79886_21524# VSS sg13_lv_nmos ad=2.61888p pd=17.445u as=0.111p ps=1.34u w=0.3u l=0.13u
X791 VDD a_5139_24504# a_5396_24385# VDD sg13_lv_pmos ad=1.02937p pd=6.325u as=79.8f ps=0.8u w=0.42u l=0.13u
X792 VDD a_9598_38154# a_9594_39077# VDD sg13_lv_pmos ad=1.17462p pd=7.44u as=0.3864p ps=2.93u w=1.12u l=0.13u
X793 VSS B_uq60 D_uq8 VSS sg13_lv_nmos ad=0.1463p pd=1.15u as=0.1694p ps=1.21u w=0.77u l=0.13u
X794 Y_uq133 C_uq18 a_6427_24143# VDD sg13_lv_pmos ad=0.3808p pd=2.92u as=0.2128p ps=1.5u w=1.12u l=0.13u
X795 VDD a_30033_67379# a_30135_67379# VDD sg13_lv_pmos ad=1.19383p pd=7.16u as=0.3864p ps=2.93u w=1.12u l=0.13u
X796 a_39314_67806# D_uq54 VDD VDD sg13_lv_pmos ad=79.8f pd=0.8u as=0.1428p ps=1.52u w=0.42u l=0.13u
X797 a_39122_69634# a_38852_69634# VDD VDD sg13_lv_pmos ad=0.34p pd=2.68u as=0.1523p ps=1.38u w=1u l=0.5u
X798 VSS VDD VSS VSS sg13_lv_nmos ad=79.8f pd=0.8u as=0 ps=-0 w=0.42u l=1u
X799 VDD a_34520_68844# X_uq435 VDD sg13_lv_pmos ad=0.2114p pd=1.54u as=0.42p ps=2.99u w=1.12u l=0.13u
X800 VDD a_4297_30929# X_uq282 VDD sg13_lv_pmos ad=0.2114p pd=1.54u as=0.42p ps=2.99u w=1.12u l=0.13u
X801 a_5840_25655# a_5618_25711# VDD VDD sg13_lv_pmos ad=0.1176p pd=1.33u as=0.2618p ps=1.63u w=1.12u l=0.13u
X802 a_6157_25284# a_5800_25211# VDD VDD sg13_lv_pmos ad=63f pd=0.72u as=0.1563p ps=1.22u w=0.42u l=0.13u
X803 VDD a_78638_27572# a_78638_27806# VDD sg13_lv_pmos ad=1.59725p pd=10.05u as=0.2442p ps=2.06u w=0.66u l=0.13u
X804 X_uq185 a_9617_19387# VSS VSS sg13_lv_nmos ad=0.2886p pd=2.26u as=0.14875p ps=1.16u w=0.74u l=0.13u
X805 VDD a_41410_7625# X_uq47 VDD sg13_lv_pmos ad=0.2114p pd=1.54u as=0.42p ps=2.99u w=1.12u l=0.13u
X806 a_45634_8375# q[30] VDD VDD sg13_lv_pmos ad=0.2856p pd=2.36u as=0.2114p ps=1.54u w=0.84u l=0.13u
X807 a_38194_64769# L_HI_uq11 VSS VSS sg13_lv_nmos ad=37.8f pd=0.6u as=0.1701p ps=1.65u w=0.42u l=0.13u
X808 C_uq3 B_uq66 VSS VSS sg13_lv_nmos ad=0.1406p pd=1.12u as=0.2516p ps=2.16u w=0.74u l=0.13u
X809 Y_uq181 B_uq79 a_7705_35257# VSS sg13_lv_nmos ad=0.2516p pd=2.16u as=0.1406p ps=1.12u w=0.74u l=0.13u
X810 VSS a_8086_41514# a_8082_42437# VSS sg13_lv_nmos ad=7.58903p pd=50.18u as=0.2516p ps=2.16u w=0.74u l=0.13u
X811 a_77972_20693# C_uq6 D_uq0 VDD sg13_lv_pmos ad=0.2128p pd=1.5u as=0.3808p ps=2.92u w=1.12u l=0.13u
X812 a_37989_67491# a_37047_67379# a_37787_67729# VDD sg13_lv_pmos ad=93.45f pd=0.865u as=0.2048p ps=1.63u w=0.42u l=0.13u
X813 X_uq172 a_8945_17875# VSS VSS sg13_lv_nmos ad=0.2886p pd=2.26u as=0.14875p ps=1.16u w=0.74u l=0.13u
X814 VDD a_4297_37910# B_uq88 VDD sg13_lv_pmos ad=0.3808p pd=2.92u as=0.2128p ps=1.5u w=1.12u l=0.13u
X815 a_36214_69853# a_36657_69609# a_35954_69630# VSS sg13_lv_nmos ad=79.8f pd=0.8u as=0.1296p ps=1.52u w=0.42u l=0.13u
X816 a_4301_41167# a_4299_42044# a_4380_41550# VDD sg13_lv_pmos ad=79.8f pd=0.8u as=63f ps=0.72u w=0.42u l=0.13u
X817 Y_uq52 C1_uq4 a_76556_20693# VDD sg13_lv_pmos ad=0.3808p pd=2.92u as=0.2128p ps=1.5u w=1.12u l=0.13u
X818 X_uq264 a_75295_26741# VDD VDD sg13_lv_pmos ad=0.42p pd=2.99u as=0.2114p ps=1.54u w=1.12u l=0.13u
X819 a_10504_42654# a_10383_41975# a_10345_43188# VDD sg13_lv_pmos ad=93.45f pd=0.865u as=0.2048p ps=1.63u w=0.42u l=0.13u
X820 C_uq4 a_10727_20907# VDD VDD sg13_lv_pmos ad=0.3808p pd=2.92u as=0.2128p ps=1.5u w=1.12u l=0.13u
X821 Y_uq47 B1_uq7 a_76555_19529# VSS sg13_lv_nmos ad=0.2516p pd=2.16u as=0.1406p ps=1.12u w=0.74u l=0.13u
X822 Y_uq2 A_uq75 VSS VSS sg13_lv_nmos ad=0.1406p pd=1.12u as=0.2516p ps=2.16u w=0.74u l=0.13u
X823 a_6217_24872# clk VDD VDD sg13_lv_pmos ad=0.4088p pd=2.97u as=1.17282p ps=7.015u w=1.12u l=0.13u
X824 a_8120_41385# a_8082_42437# a_8116_41079# VSS sg13_lv_nmos ad=0.2373p pd=1.97u as=79.8f ps=0.8u w=0.42u l=0.13u
X825 VSS a_36070_66574# a_35789_66796# VSS sg13_lv_nmos ad=79.8f pd=0.8u as=0.1428p ps=1.52u w=0.42u l=0.5u
X826 VSS a_36994_7625# B_uq10 VSS sg13_lv_nmos ad=0.14875p pd=1.16u as=0.2886p ps=2.26u w=0.74u l=0.13u
X827 a_40545_68927# L_HI_uq37 VDD VDD sg13_lv_pmos ad=0.147p pd=1.54u as=0.1563p ps=1.22u w=0.42u l=0.13u
X828 VDD din[22] a_75295_20693# VDD sg13_lv_pmos ad=0.2114p pd=1.54u as=0.2856p ps=2.36u w=0.84u l=0.13u
X829 X_uq325 a_9583_43295# VSS VSS sg13_lv_nmos ad=0.2886p pd=2.26u as=0.14875p ps=1.16u w=0.74u l=0.13u
X830 VSS Y_uq66 D VSS sg13_lv_nmos ad=0.1463p pd=1.15u as=0.1694p ps=1.21u w=0.77u l=0.13u
X831 VDD a_29338_68307# X_uq438 VDD sg13_lv_pmos ad=0.2254p pd=1.53u as=0.4256p ps=3u w=1.12u l=0.13u
X832 a_7705_36275# Y_uq190 a_7321_35905# VSS sg13_lv_nmos ad=81.6f pd=0.895u as=0.1216p ps=1.02u w=0.64u l=0.13u
X833 C_uq3 B_uq40 a_7470_20655# VDD sg13_lv_pmos ad=0.3808p pd=2.92u as=0.1176p ps=1.33u w=1.12u l=0.13u
X834 a_9583_42043# a_9598_40746# a_9619_41811# VSS sg13_lv_nmos ad=0.12665p pd=1.145u as=0.1428p ps=1.52u w=0.42u l=0.13u
X835 VDD a_42058_9891# a_42016_10221# VDD sg13_lv_pmos ad=0.2618p pd=1.63u as=0.1176p ps=1.33u w=1.12u l=0.13u
X836 C_uq44 X_uq399 VSS VSS sg13_lv_nmos ad=0.1406p pd=1.12u as=0.2516p ps=2.16u w=0.74u l=0.13u
X837 VSS a_36059_66217# a_36726_65856# VSS sg13_lv_nmos ad=0.1406p pd=1.12u as=0.2516p ps=2.16u w=0.74u l=0.13u
X838 a_41937_69609# clk VSS VSS sg13_lv_nmos ad=0.2516p pd=2.16u as=1.9335p ps=12.315u w=0.74u l=0.13u
X839 a_33813_64391# a_33456_64348# VDD VDD sg13_lv_pmos ad=63f pd=0.72u as=0.1563p ps=1.22u w=0.42u l=0.13u
X840 a_30875_67729# a_30033_67379# a_29616_67372# VDD sg13_lv_pmos ad=0.2048p pd=1.63u as=0.34p ps=2.68u w=1u l=0.13u
X841 VSS din[16] a_75295_23717# VSS sg13_lv_nmos ad=0.14875p pd=1.16u as=0.187p ps=1.78u w=0.55u l=0.13u
X842 a_45936_66294# D_uq42 a_45842_66294# VSS sg13_lv_nmos ad=60.89999f pd=0.71u as=0.1428p ps=1.52u w=0.42u l=0.13u
X843 a_37212_10661# X_uq162 VDD VDD sg13_lv_pmos ad=0.1596p pd=1.22u as=0.2226p ps=1.535u w=0.84u l=0.13u
X844 a_5047_33019# a_5062_31722# a_5047_32685# VDD sg13_lv_pmos ad=0.2048p pd=1.63u as=0.34p ps=2.68u w=1u l=0.13u
X845 Y_uq1 A_uq75 a_43170_8709# VDD sg13_lv_pmos ad=0.3808p pd=2.92u as=0.1176p ps=1.33u w=1.12u l=0.13u
X846 a_33238_66829# a_33681_66585# a_33621_66997# VDD sg13_lv_pmos ad=79.8f pd=0.8u as=63f ps=0.72u w=0.42u l=0.13u
X847 VDD a_8086_31722# a_8082_32645# VDD sg13_lv_pmos ad=1.5243p pd=9.795u as=0.3864p ps=2.93u w=1.12u l=0.13u
X848 VSS a_33170_65098# a_33282_65162# VSS sg13_lv_nmos ad=0.1426p pd=1.16u as=0.1428p ps=1.52u w=0.42u l=0.5u
X849 X_uq90 a_33918_8449# VDD VDD sg13_lv_pmos ad=0.42p pd=2.99u as=0.2114p ps=1.54u w=1.12u l=0.13u
X850 a_33170_64782# D_uq40 VDD VDD sg13_lv_pmos ad=79.8f pd=0.8u as=0.1428p ps=1.52u w=0.42u l=0.13u
X851 a_30203_66217# a_29361_65867# a_28944_65860# VDD sg13_lv_pmos ad=0.2048p pd=1.63u as=0.34p ps=2.68u w=1u l=0.13u
X852 VDD a_33681_66585# a_33783_66728# VDD sg13_lv_pmos ad=1.19383p pd=7.16u as=0.3864p ps=2.93u w=1.12u l=0.13u
X853 VSS X_uq167 a_35076_8453# VSS sg13_lv_nmos ad=0.17255p pd=1.25u as=0.187p ps=1.78u w=0.55u l=0.13u
X854 VSS a_31132_69122# a_30781_69241# VSS sg13_lv_nmos ad=79.8f pd=0.8u as=0.1428p ps=1.52u w=0.42u l=0.13u
X855 VSS a_6936_21837# Y_uq93 VSS sg13_lv_nmos ad=0.17255p pd=1.25u as=0.1406p ps=1.12u w=0.74u l=0.13u
X856 a_76172_25229# Y_uq116 VDD VDD sg13_lv_pmos ad=0.2128p pd=1.5u as=0.2128p ps=1.5u w=1.12u l=0.13u
X857 D_uq31 D_uq25 a_7357_39708# VDD sg13_lv_pmos ad=0.3808p pd=2.92u as=0.2128p ps=1.5u w=1.12u l=0.13u
X858 VSS X_uq319 Y_uq172 VSS sg13_lv_nmos ad=0.2516p pd=2.16u as=0.2516p ps=2.16u w=0.74u l=0.13u
X859 a_49490_68118# a_50295_68240# a_49750_68341# VDD sg13_lv_pmos ad=0.1428p pd=1.52u as=79.8f ps=0.8u w=0.42u l=0.13u
X860 a_77699_18383# din[31] VDD VDD sg13_lv_pmos ad=0.2856p pd=2.36u as=0.2114p ps=1.54u w=0.84u l=0.13u
X861 VSS a_47387_66217# a_48054_65856# VSS sg13_lv_nmos ad=0.1406p pd=1.12u as=0.2516p ps=2.16u w=0.74u l=0.13u
X862 a_42960_67372# a_42934_67336# VDD VDD sg13_lv_pmos ad=0.34p pd=2.68u as=0.36237p ps=2.605u w=1u l=0.13u
X863 VSS VDD VSS VSS sg13_lv_nmos ad=79.8f pd=0.8u as=0 ps=-0 w=0.42u l=1u
X864 X_uq184 a_10001_19387# VSS VSS sg13_lv_nmos ad=0.2886p pd=2.26u as=0.14875p ps=1.16u w=0.74u l=0.13u
X865 C_uq22 a_10009_25775# VDD VDD sg13_lv_pmos ad=0.3976p pd=2.95u as=0.2226p ps=1.535u w=1.12u l=0.13u
X866 a_52065_65252# a_51123_65312# a_51971_65485# VDD sg13_lv_pmos ad=79.8f pd=0.8u as=0.1428p ps=1.52u w=0.42u l=0.13u
X867 a_33648_68131# a_33879_68240# a_33334_68341# VSS sg13_lv_nmos ad=0.2373p pd=1.97u as=79.8f ps=0.8u w=0.42u l=0.13u
X868 VSS a_44792_64308# X_uq362 VSS sg13_lv_nmos ad=0.14875p pd=1.16u as=0.2886p ps=2.26u w=0.74u l=0.13u
X869 a_36166_65062# Q_uq46 VSS VSS sg13_lv_nmos ad=0.1428p pd=1.52u as=79.8f ps=0.8u w=0.42u l=0.13u
X870 VDD a_4420_33911# a_4456_33822# VDD sg13_lv_pmos ad=1.31615p pd=8.395u as=93.45f ps=0.865u w=0.42u l=0.13u
X871 a_29265_69609# clk VDD VDD sg13_lv_pmos ad=0.4088p pd=2.97u as=1.621p ps=10.08u w=1.12u l=0.13u
X872 X_uq69 a_32766_8449# VDD VDD sg13_lv_pmos ad=0.42p pd=2.99u as=0.2114p ps=1.54u w=1.12u l=0.13u
X873 Y_uq130 C_uq21 VSS VSS sg13_lv_nmos ad=0.1406p pd=1.12u as=0.2516p ps=2.16u w=0.74u l=0.13u
X874 SL[0] a_27316_69668# VSS VSS sg13_lv_nmos ad=0.2886p pd=2.26u as=0.14875p ps=1.16u w=0.74u l=0.13u
X875 VDD a_47674_65283# X_uq372 VDD sg13_lv_pmos ad=0.2254p pd=1.53u as=0.4256p ps=3u w=1.12u l=0.13u
X876 a_47553_64391# L_HI_uq9 VDD VDD sg13_lv_pmos ad=0.147p pd=1.54u as=0.1563p ps=1.22u w=0.42u l=0.13u
X877 SLN[5] a_31732_65856# VDD VDD sg13_lv_pmos ad=0.42p pd=2.99u as=0.2114p ps=1.54u w=1.12u l=0.13u
X878 VDD q[3] a_33918_8449# VDD sg13_lv_pmos ad=0.2114p pd=1.54u as=0.2856p ps=2.36u w=0.84u l=0.13u
X879 a_3880_24147# a_4399_24154# a_5139_24504# VSS sg13_lv_nmos ad=0.3473p pd=2.71u as=0.12665p ps=1.145u w=0.74u l=0.13u
X880 VSS a_9598_38154# a_9594_39077# VSS sg13_lv_nmos ad=4.17695p pd=26.495u as=0.2516p ps=2.16u w=0.74u l=0.13u
X881 a_45350_9149# B_uq1 VSS VSS sg13_lv_nmos ad=0.1045p pd=0.93u as=0.187p ps=1.78u w=0.55u l=0.13u
X882 VDD VSS VDD VDD sg13_lv_pmos ad=0.19p pd=1.38u as=0 ps=0 w=1u l=1u
X883 VSS A2_uq3 a_76957_26005# VSS sg13_lv_nmos ad=0.2516p pd=2.16u as=0.1406p ps=1.12u w=0.74u l=0.13u
X884 a_46402_6863# Y_uq28 VDD VDD sg13_lv_pmos ad=0.2856p pd=2.36u as=0.2114p ps=1.54u w=0.84u l=0.13u
X885 a_35398_69598# Q_uq56 VSS VSS sg13_lv_nmos ad=0.1428p pd=1.52u as=79.8f ps=0.8u w=0.42u l=0.13u
X886 a_39574_67336# a_40017_67379# a_39957_67415# VDD sg13_lv_pmos ad=79.8f pd=0.8u as=63f ps=0.72u w=0.42u l=0.13u
X887 VDD q[13] a_35838_10685# VDD sg13_lv_pmos ad=0.2114p pd=1.54u as=0.2856p ps=2.36u w=0.84u l=0.13u
X888 a_79153_23681# Y_uq85 VSS VSS sg13_lv_nmos ad=0.1428p pd=1.52u as=79.8f ps=0.8u w=0.42u l=0.13u
X889 Y_uq288 Q_uq50 VSS VSS sg13_lv_nmos ad=0.2516p pd=2.16u as=0.2516p ps=2.16u w=0.74u l=0.13u
X890 a_51986_65856# a_51716_65897# VDD VDD sg13_lv_pmos ad=0.34p pd=2.68u as=0.1523p ps=1.38u w=1u l=0.5u
X891 a_4380_32718# a_4337_32361# VDD VDD sg13_lv_pmos ad=63f pd=0.72u as=0.1563p ps=1.22u w=0.42u l=0.13u
X892 VDD L_HI_uq25 a_29590_67336# VDD sg13_lv_pmos ad=0.1563p pd=1.22u as=0.147p ps=1.54u w=0.42u l=0.13u
X893 a_4552_21882# a_4264_22187# a_4490_21882# VSS sg13_lv_nmos ad=0.1428p pd=1.52u as=37.8f ps=0.6u w=0.42u l=0.13u
X894 VDD C_uq39 D_uq32 VDD sg13_lv_pmos ad=0.3808p pd=2.92u as=0.2128p ps=1.5u w=1.12u l=0.15u
X895 VSS a_29265_69609# a_29367_69752# VSS sg13_lv_nmos ad=2.01085p pd=12.81u as=0.2516p ps=2.16u w=0.74u l=0.13u
X896 VSS a_43738_68307# X_uq413 VSS sg13_lv_nmos ad=0.1426p pd=1.16u as=0.2516p ps=2.16u w=0.74u l=0.13u
X897 a_40930_10649# q[19] VSS VSS sg13_lv_nmos ad=0.187p pd=1.78u as=0.14875p ps=1.16u w=0.55u l=0.13u
X898 B_uq42 a_79053_23023# VSS VSS sg13_lv_nmos ad=0.2516p pd=2.16u as=0.1426p ps=1.16u w=0.74u l=0.13u
X899 VSS Y_uq308 Y_uq322 VSS sg13_lv_nmos ad=0.1463p pd=1.15u as=0.1694p ps=1.21u w=0.77u l=0.13u
X900 VSS a_3535_36887# a_3571_36819# VSS sg13_lv_nmos ad=79.8f pd=0.8u as=0.1428p ps=1.52u w=0.42u l=0.13u
X901 a_44792_64308# Y_uq247 VSS VSS sg13_lv_nmos ad=0.187p pd=1.78u as=0.14875p ps=1.16u w=0.55u l=0.13u
X902 VSS X_uq251 a_77029_20749# VSS sg13_lv_nmos ad=0.17255p pd=1.25u as=0.187p ps=1.78u w=0.55u l=0.13u
X903 X_uq190 a_75679_19969# VDD VDD sg13_lv_pmos ad=0.42p pd=2.99u as=0.2114p ps=1.54u w=1.12u l=0.13u
X904 VSS X_uq267 Y_uq148 VSS sg13_lv_nmos ad=0.2516p pd=2.16u as=0.2516p ps=2.16u w=0.74u l=0.13u
X905 Y_uq24 X_uq162 a_37314_10221# VDD sg13_lv_pmos ad=0.3808p pd=2.92u as=0.1176p ps=1.33u w=1.12u l=0.13u
X906 VSS Q_uq33 Y_uq292 VSS sg13_lv_nmos ad=0.2516p pd=2.16u as=0.2516p ps=2.16u w=0.74u l=0.13u
X907 VDD a_42634_8379# a_42592_8709# VDD sg13_lv_pmos ad=0.2618p pd=1.63u as=0.1176p ps=1.33u w=1.12u l=0.13u
X908 VSS L_HI_uq37 a_40802_69305# VSS sg13_lv_nmos ad=0.1701p pd=1.65u as=37.8f ps=0.6u w=0.42u l=0.13u
X909 a_45891_66904# Y_uq318 a_45777_66904# VDD sg13_lv_pmos ad=0.2128p pd=1.5u as=0.2464p ps=1.56u w=1.12u l=0.13u
X910 Y_uq318 a_46330_68160# VSS VSS sg13_lv_nmos ad=0.1406p pd=1.12u as=0.17255p ps=1.25u w=0.74u l=0.13u
X911 a_34714_65283# a_34829_65284# VSS VSS sg13_lv_nmos ad=0.1428p pd=1.52u as=0.1426p ps=1.16u w=0.42u l=0.5u
X912 a_39108_10301# B_uq24 a_39014_10301# VDD sg13_lv_pmos ad=0.1596p pd=1.22u as=0.2856p ps=2.36u w=0.84u l=0.13u
X913 a_7705_37294# B_uq83 VSS VSS sg13_lv_nmos ad=0.1216p pd=1.02u as=0.1331p ps=1.12u w=0.64u l=0.13u
X914 VSS Y_uq34 a_9329_17875# VSS sg13_lv_nmos ad=0.14875p pd=1.16u as=0.187p ps=1.78u w=0.55u l=0.13u
X915 a_50640_67372# a_50614_67336# VDD VDD sg13_lv_pmos ad=0.34p pd=2.68u as=0.36237p ps=2.605u w=1u l=0.13u
X916 a_5800_25211# a_6319_25015# a_7059_24970# VSS sg13_lv_nmos ad=0.3473p pd=2.71u as=0.12665p ps=1.145u w=0.74u l=0.13u
X917 a_50448_64348# a_50967_64355# a_51707_64705# VSS sg13_lv_nmos ad=0.3473p pd=2.71u as=0.12665p ps=1.145u w=0.74u l=0.13u
X918 Y_uq339 Q_uq57 VSS VSS sg13_lv_nmos ad=0.2516p pd=2.16u as=0.2516p ps=2.16u w=0.74u l=0.13u
X919 VSS C_uq50 Y_uq276 VSS sg13_lv_nmos ad=0.1463p pd=1.15u as=0.2618p ps=2.22u w=0.77u l=0.13u
X920 VSS a_9583_42737# VEVAL1 VSS sg13_lv_nmos ad=0.14875p pd=1.16u as=0.2886p ps=2.26u w=0.74u l=0.13u
X921 a_34876_68338# a_34619_68195# a_35038_68118# VSS sg13_lv_nmos ad=0.1428p pd=1.52u as=37.8f ps=0.6u w=0.42u l=0.13u
X922 a_8837_36271# a_8835_37148# a_8916_36842# VSS sg13_lv_nmos ad=79.8f pd=0.8u as=0.1296p ps=1.52u w=0.42u l=0.13u
X923 a_38530_8375# A_uq24 VDD VDD sg13_lv_pmos ad=0.2856p pd=2.36u as=0.2114p ps=1.54u w=0.84u l=0.13u
X924 a_45898_9891# X_uq95 VSS VSS sg13_lv_nmos ad=0.187p pd=1.78u as=0.17255p ps=1.25u w=0.55u l=0.13u
X925 VDD din[21] a_75295_21481# VDD sg13_lv_pmos ad=0.2114p pd=1.54u as=0.2856p ps=2.36u w=0.84u l=0.13u
X926 VSS B_uq63 a_10660_21679# VSS sg13_lv_nmos ad=0.14505p pd=1.15u as=0.187p ps=1.78u w=0.55u l=0.13u
X927 A_uq7 a_27796_65856# VDD VDD sg13_lv_pmos ad=0.42p pd=2.99u as=0.2114p ps=1.54u w=1.12u l=0.13u
X928 a_46012_69122# a_45755_69241# a_46174_69318# VSS sg13_lv_nmos ad=0.1428p pd=1.52u as=37.8f ps=0.6u w=0.42u l=0.13u
X929 VDD a_51035_68195# a_51292_68338# VDD sg13_lv_pmos ad=1.42837p pd=8.61u as=79.8f ps=0.8u w=0.42u l=0.13u
X930 q[7] a_32980_63620# VSS VSS sg13_lv_nmos ad=0.2886p pd=2.26u as=0.14875p ps=1.16u w=0.74u l=0.13u
X931 a_34286_10067# B_uq12 a_34428_10301# VDD sg13_lv_pmos ad=0.2856p pd=2.36u as=0.1596p ps=1.22u w=0.84u l=0.13u
X932 VDD X_uq433 a_33784_65856# VDD sg13_lv_pmos ad=0.4032p pd=2.96u as=0.1176p ps=1.33u w=1.12u l=0.13u
X933 a_29338_68307# a_29453_68308# VSS VSS sg13_lv_nmos ad=0.1428p pd=1.52u as=0.1426p ps=1.16u w=0.42u l=0.5u
X934 VSS X_uq162 Y_uq4 VSS sg13_lv_nmos ad=0.2516p pd=2.16u as=0.1406p ps=1.12u w=0.74u l=0.13u
X935 D_uq11 C_uq29 a_78401_29301# VDD sg13_lv_pmos ad=0.3808p pd=2.92u as=0.1176p ps=1.33u w=1.12u l=0.13u
X936 VSS L_HI_uq18 a_50006_66606# VSS sg13_lv_nmos ad=79.8f pd=0.8u as=37.8f ps=0.6u w=0.42u l=0.13u
X937 VSS C_uq15 Y_uq54 VSS sg13_lv_nmos ad=0.2516p pd=2.16u as=0.1406p ps=1.12u w=0.74u l=0.13u
X938 VSS Q_uq5 B_uq64 VSS sg13_lv_nmos ad=0.2516p pd=2.16u as=0.1406p ps=1.12u w=0.74u l=0.13u
X939 a_8422_42558# a_8082_42437# a_8071_42811# VDD sg13_lv_pmos ad=93.45f pd=0.865u as=0.2048p ps=1.63u w=0.42u l=0.13u
X940 D_uq64 X_uq435 VSS VSS sg13_lv_nmos ad=0.1694p pd=1.21u as=0.2618p ps=2.22u w=0.77u l=0.13u
X941 VSS a_5062_31722# a_5058_32645# VSS sg13_lv_nmos ad=5.0377p pd=32.285u as=0.2516p ps=2.16u w=0.74u l=0.13u
X942 a_7735_37687# Y_uq201 C_uq39 VSS sg13_lv_nmos ad=0.1406p pd=1.12u as=0.2516p ps=2.16u w=0.74u l=0.15u
X943 a_10345_30929# Q_uq9 VSS VSS sg13_lv_nmos ad=0.187p pd=1.78u as=0.14875p ps=1.16u w=0.55u l=0.13u
X944 a_9217_34835# Y_uq219 a_8833_34465# VSS sg13_lv_nmos ad=81.6f pd=0.895u as=0.1216p ps=1.02u w=0.64u l=0.13u
X945 a_35189_67706# a_35313_67405# VDD VDD sg13_lv_pmos ad=0.2442p pd=2.06u as=1.19383p ps=7.16u w=0.66u l=0.13u
X946 C_uq24 a_8561_23923# VDD VDD sg13_lv_pmos ad=0.42p pd=2.99u as=0.2114p ps=1.54u w=1.12u l=0.13u
X947 a_38776_65392# a_38554_65136# VDD VDD sg13_lv_pmos ad=0.1176p pd=1.33u as=0.2618p ps=1.63u w=1.12u l=0.13u
X948 VDD Q_uq58 Y_uq363 VDD sg13_lv_pmos ad=0.3808p pd=2.92u as=0.3808p ps=2.92u w=1.12u l=0.13u
X949 VDD a_78941_22959# a_79053_23023# VDD sg13_lv_pmos ad=0.2254p pd=1.53u as=0.34p ps=2.68u w=1u l=0.5u
X950 VDD a_5809_43188# a_5932_42743# VDD sg13_lv_pmos ad=1.86053p pd=12.055u as=79.8f ps=0.8u w=0.42u l=0.13u
X951 VDD L_HI_uq27 a_42934_67336# VDD sg13_lv_pmos ad=0.1563p pd=1.22u as=0.147p ps=1.54u w=0.42u l=0.13u
X952 VDD X_uq449 a_42904_68416# VDD sg13_lv_pmos ad=0.4032p pd=2.96u as=0.1176p ps=1.33u w=1.12u l=0.13u
X953 VSS A_uq87 Y_uq21 VSS sg13_lv_nmos ad=0.2516p pd=2.16u as=0.1406p ps=1.12u w=0.74u l=0.13u
X954 a_8075_38143# Y_uq212 VSS VSS sg13_lv_nmos ad=0.1428p pd=1.52u as=79.8f ps=0.8u w=0.42u l=0.13u
X955 a_48646_67332# Q_uq51 VDD VDD sg13_lv_pmos ad=0.1428p pd=1.52u as=0.1523p ps=1.38u w=0.42u l=0.13u
X956 VSS X_uq448 a_46810_68160# VSS sg13_lv_nmos ad=0.17255p pd=1.25u as=0.187p ps=1.78u w=0.55u l=0.13u
X957 VSS a_29818_66795# X_uq405 VSS sg13_lv_nmos ad=0.1426p pd=1.16u as=0.2516p ps=2.16u w=0.74u l=0.13u
X958 VSS C_uq2 Y_uq64 VSS sg13_lv_nmos ad=0.1463p pd=1.15u as=0.2618p ps=2.22u w=0.77u l=0.13u
X959 Y_uq13 a_36900_9229# VSS VSS sg13_lv_nmos ad=0.1406p pd=1.12u as=0.17255p ps=1.25u w=0.74u l=0.13u
X960 a_4380_32906# a_4335_33143# a_4301_32335# VDD sg13_lv_pmos ad=0.1428p pd=1.52u as=79.8f ps=0.8u w=0.42u l=0.13u
X961 VSS a_31739_65171# a_32406_65392# VSS sg13_lv_nmos ad=0.1406p pd=1.12u as=0.2516p ps=2.16u w=0.74u l=0.13u
X962 a_46234_67806# a_45976_67806# VSS VSS sg13_lv_nmos ad=0.1428p pd=1.52u as=79.8f ps=0.8u w=0.42u l=0.13u
X963 a_35534_9489# B_uq5 a_35676_9149# VDD sg13_lv_pmos ad=0.2856p pd=2.36u as=0.1596p ps=1.22u w=0.84u l=0.13u
X964 a_43750_65062# Y_uq261 VSS VSS sg13_lv_nmos ad=0.1428p pd=1.52u as=79.8f ps=0.8u w=0.42u l=0.13u
X965 VSS a_32312_66570# SLN[1] VSS sg13_lv_nmos ad=0.14875p pd=1.16u as=0.2886p ps=2.26u w=0.74u l=0.13u
X966 a_76650_21041# B1_uq6 VSS VSS sg13_lv_nmos ad=0.1406p pd=1.12u as=0.2516p ps=2.16u w=0.74u l=0.13u
X967 a_10819_31823# a_10345_31516# a_10468_31961# VSS sg13_lv_nmos ad=37.8f pd=0.6u as=0.1428p ps=1.52u w=0.42u l=0.13u
X968 VDD Y_uq254 a_32116_64344# VDD sg13_lv_pmos ad=0.2114p pd=1.54u as=0.2856p ps=2.36u w=0.84u l=0.13u
X969 X_uq210 a_75295_22993# VDD VDD sg13_lv_pmos ad=0.42p pd=2.99u as=0.2114p ps=1.54u w=1.12u l=0.13u
X970 a_9917_35471# C_uq39 VDD VDD sg13_lv_pmos ad=0.1176p pd=1.33u as=0.4032p ps=2.96u w=1.12u l=0.13u
X971 VDD a_30202_68307# X_uq437 VDD sg13_lv_pmos ad=0.2254p pd=1.53u as=0.4256p ps=3u w=1.12u l=0.13u
X972 X_uq183 a_10865_19387# VDD VDD sg13_lv_pmos ad=0.42p pd=2.99u as=0.2114p ps=1.54u w=1.12u l=0.13u
X973 VDD B_uq81 a_6893_35857# VDD sg13_lv_pmos ad=0.4032p pd=2.96u as=0.1176p ps=1.33u w=1.12u l=0.13u
X974 a_33536_68844# X_uq432 VDD VDD sg13_lv_pmos ad=0.2856p pd=2.36u as=0.2618p ps=1.63u w=0.84u l=0.13u
X975 VSS Q_uq39 Y_uq283 VSS sg13_lv_nmos ad=0.2516p pd=2.16u as=0.2516p ps=2.16u w=0.74u l=0.13u
X976 a_38924_69167# a_39043_68844# VSS VSS sg13_lv_nmos ad=0.2516p pd=2.16u as=0.1406p ps=1.12u w=0.74u l=0.13u
X977 A_N a_10481_23135# VDD VDD sg13_lv_pmos ad=0.42p pd=2.99u as=0.2114p ps=1.54u w=1.12u l=0.13u
X978 VSS a_9583_31222# Q_uq9 VSS sg13_lv_nmos ad=0.1406p pd=1.12u as=0.2516p ps=2.16u w=0.74u l=0.13u
X979 B_uq75 B_uq81 a_8111_34591# VSS sg13_lv_nmos ad=0.2516p pd=2.16u as=0.1406p ps=1.12u w=0.74u l=0.13u
X980 VSS X_uq70 a_37086_6937# VSS sg13_lv_nmos ad=0.14875p pd=1.16u as=0.187p ps=1.78u w=0.55u l=0.13u
X981 a_51123_65312# a_51275_65364# VDD VDD sg13_lv_pmos ad=0.3864p pd=2.93u as=1.41367p ps=8.85u w=1.12u l=0.13u
X982 VSS A_uq75 a_43334_10301# VSS sg13_lv_nmos ad=0.1469p pd=1.155u as=0.1045p ps=0.93u w=0.55u l=0.13u
X983 VDD A2_uq1 a_79340_25229# VDD sg13_lv_pmos ad=0.2128p pd=1.5u as=0.3808p ps=2.92u w=1.12u l=0.13u
X984 a_77444_23741# Y_uq86 a_77342_23741# VDD sg13_lv_pmos ad=0.1575p pd=1.315u as=0.19p ps=1.38u w=1u l=0.13u
X985 VSS a_4297_40155# X_uq315 VSS sg13_lv_nmos ad=0.1426p pd=1.16u as=0.2516p ps=2.16u w=0.74u l=0.13u
X986 VDD Y_uq165 a_9583_31769# VDD sg13_lv_pmos ad=1.17462p pd=7.44u as=79.8f ps=0.8u w=0.42u l=0.13u
X987 a_37106_66294# D_uq44 VDD VDD sg13_lv_pmos ad=79.8f pd=0.8u as=0.1428p ps=1.52u w=0.42u l=0.13u
X988 a_34780_66826# L_HI_uq24 VDD VDD sg13_lv_pmos ad=79.8f pd=0.8u as=1.19383p ps=7.16u w=0.42u l=0.13u
X989 a_45634_6863# Y_uq9 VSS VSS sg13_lv_nmos ad=0.187p pd=1.78u as=0.14875p ps=1.16u w=0.55u l=0.13u
X990 VDD a_79155_28614# a_80178_28300# VDD sg13_lv_pmos ad=0.1563p pd=1.22u as=63f ps=0.72u w=0.42u l=0.13u
X991 a_7705_38313# C_uq36 VSS VSS sg13_lv_nmos ad=0.1216p pd=1.02u as=0.1371p ps=1.12u w=0.64u l=0.13u
X992 a_79164_25266# a_79164_25266# VSS VSS sg13_lv_nmos ad=0.111p pd=1.34u as=5.79397p ps=37.885u w=0.3u l=0.13u
X993 a_8799_33220# B_uq80 a_8845_33355# VDD sg13_lv_pmos ad=0.2856p pd=2.36u as=0.1596p ps=1.22u w=0.84u l=0.13u
X994 VDD Y_uq230 a_3580_40023# VDD sg13_lv_pmos ad=0.1563p pd=1.22u as=0.147p ps=1.54u w=0.42u l=0.13u
X995 Y_uq229 B_uq92 VSS VSS sg13_lv_nmos ad=0.1406p pd=1.12u as=0.2516p ps=2.16u w=0.74u l=0.13u
X996 VSS X_uq311 D_uq28 VSS sg13_lv_nmos ad=0.2516p pd=2.16u as=0.1406p ps=1.12u w=0.74u l=0.13u
X997 a_9583_42737# Y_uq233 VSS VSS sg13_lv_nmos ad=0.187p pd=1.78u as=0.14875p ps=1.16u w=0.55u l=0.13u
X998 C_uq33 a_5809_34453# VSS VSS sg13_lv_nmos ad=0.2516p pd=2.16u as=0.1426p ps=1.16u w=0.74u l=0.13u
X999 a_9235_35265# D_uq30 a_9235_35163# VSS sg13_lv_nmos ad=0.1406p pd=1.12u as=0.1406p ps=1.12u w=0.74u l=0.13u
X1000 Q_uq28 a_4297_43290# VDD VDD sg13_lv_pmos ad=0.3808p pd=2.92u as=0.2128p ps=1.5u w=1.12u l=0.13u
X1001 a_6559_42573# a_6604_41175# VSS VSS sg13_lv_nmos ad=0.2516p pd=2.16u as=0.1626p ps=1.415u w=0.74u l=0.13u
X1002 VSS C_uq29 D_uq11 VSS sg13_lv_nmos ad=0.2516p pd=2.16u as=0.1406p ps=1.12u w=0.74u l=0.13u
X1003 VSS L_HI_uq20 a_37200_66294# VSS sg13_lv_nmos ad=0.1626p pd=1.415u as=60.89999f ps=0.71u w=0.42u l=0.13u
X1004 B1 B1_uq6 a_76438_22181# VDD sg13_lv_pmos ad=0.2128p pd=1.5u as=0.2716p ps=1.605u w=1.12u l=0.13u
X1005 Y_uq51 X_uq195 VDD VDD sg13_lv_pmos ad=0.3808p pd=2.92u as=0.3808p ps=2.92u w=1.12u l=0.13u
X1006 a_39874_7625# A_uq81 VSS VSS sg13_lv_nmos ad=0.187p pd=1.78u as=0.14875p ps=1.16u w=0.55u l=0.13u
X1007 a_5809_37466# S_uq0 VSS VSS sg13_lv_nmos ad=0.187p pd=1.78u as=0.14505p ps=1.15u w=0.55u l=0.13u
X1008 VDD a_3535_36887# a_3886_36798# VDD sg13_lv_pmos ad=1.31615p pd=8.395u as=93.45f ps=0.865u w=0.42u l=0.13u
X1009 a_35722_8379# X_uq68 VSS VSS sg13_lv_nmos ad=0.187p pd=1.78u as=0.17255p ps=1.25u w=0.55u l=0.13u
X1010 VSS X_uq429 a_38554_65136# VSS sg13_lv_nmos ad=0.17255p pd=1.25u as=0.187p ps=1.78u w=0.55u l=0.13u
X1011 a_12684_24183# C_uq20 a_12582_24183# VDD sg13_lv_pmos ad=0.2464p pd=1.56u as=0.2128p ps=1.5u w=1.12u l=0.13u
X1012 VSS X_uq272 a_79026_27533# VSS sg13_lv_nmos ad=0.14505p pd=1.15u as=0.187p ps=1.78u w=0.55u l=0.13u
X1013 D_uq13 S_uq0 VSS VSS sg13_lv_nmos ad=0.1406p pd=1.12u as=0.2516p ps=2.16u w=0.74u l=0.13u
X1014 X_uq17 a_39774_6937# VDD VDD sg13_lv_pmos ad=0.42p pd=2.99u as=0.2114p ps=1.54u w=1.12u l=0.13u
X1015 X_uq256 a_7340_25655# VDD VDD sg13_lv_pmos ad=0.42p pd=2.99u as=0.2114p ps=1.54u w=1.12u l=0.13u
X1016 VSS VDD VSS VSS sg13_lv_nmos ad=79.8f pd=0.8u as=0 ps=-0 w=0.42u l=1u
X1017 a_8075_38143# Y_uq212 VDD VDD sg13_lv_pmos ad=0.1428p pd=1.52u as=0.1523p ps=1.38u w=0.42u l=0.13u
X1018 VSS S_uq0 D_uq20 VSS sg13_lv_nmos ad=0.1463p pd=1.15u as=0.1694p ps=1.21u w=0.77u l=0.13u
X1019 VDD a_8075_39865# X_uq308 VDD sg13_lv_pmos ad=0.2254p pd=1.53u as=0.4256p ps=3u w=1.12u l=0.13u
X1020 Q_uq17 a_10345_37146# VDD VDD sg13_lv_pmos ad=0.3808p pd=2.92u as=0.2128p ps=1.5u w=1.12u l=0.13u
X1021 VDD Y_uq39 a_10865_19387# VDD sg13_lv_pmos ad=0.2114p pd=1.54u as=0.2856p ps=2.36u w=0.84u l=0.13u
X1022 a_3575_39179# a_3539_39079# VDD VDD sg13_lv_pmos ad=0.34p pd=2.68u as=0.1523p ps=1.38u w=1u l=0.5u
X1023 a_38256_64769# a_37968_64348# a_38194_64769# VSS sg13_lv_nmos ad=0.1428p pd=1.52u as=37.8f ps=0.6u w=0.42u l=0.13u
X1024 VDD a_32696_66570# X_uq436 VDD sg13_lv_pmos ad=0.2114p pd=1.54u as=0.42p ps=2.99u w=1.12u l=0.13u
X1025 Y_uq33 C_uq1 VSS VSS sg13_lv_nmos ad=0.1406p pd=1.12u as=0.2516p ps=2.16u w=0.74u l=0.13u
X1026 VSS S a_6599_40417# VSS sg13_lv_nmos ad=0.18945p pd=1.27u as=0.13135p ps=1.095u w=0.74u l=0.13u
X1027 a_39514_69003# a_39256_69318# VDD VDD sg13_lv_pmos ad=93.45f pd=0.865u as=1.42837p ps=8.61u w=0.42u l=0.13u
X1028 VSS a_50193_68097# a_50295_68240# VSS sg13_lv_nmos ad=2.08687p pd=13.23u as=0.2516p ps=2.16u w=0.74u l=0.13u
X1029 VSS a_3580_33241# a_3535_31809# VSS sg13_lv_nmos ad=0.1626p pd=1.415u as=0.2516p ps=2.16u w=0.74u l=0.13u
X1030 a_4613_41738# a_4337_41193# a_4758_41419# VSS sg13_lv_nmos ad=0.1428p pd=1.52u as=37.8f ps=0.6u w=0.42u l=0.13u
X1031 Q_uq12 a_5047_33402# VDD VDD sg13_lv_pmos ad=0.3808p pd=2.92u as=0.2128p ps=1.5u w=1.12u l=0.13u
X1032 VDD Q_uq8 a_76154_28253# VDD sg13_lv_pmos ad=0.3808p pd=2.92u as=0.2464p ps=1.56u w=1.12u l=0.13u
X1033 a_4299_33212# clk VSS VSS sg13_lv_nmos ad=0.2516p pd=2.16u as=4.1981p ps=26.905u w=0.74u l=0.13u
X1034 a_31448_68082# Q_uq57 VSS VSS sg13_lv_nmos ad=0.187p pd=1.78u as=0.14875p ps=1.16u w=0.55u l=0.13u
X1035 VSS a_79910_27102# a_80577_26741# VSS sg13_lv_nmos ad=0.1406p pd=1.12u as=0.2516p ps=2.16u w=0.74u l=0.13u
X1036 a_10349_33537# a_10383_32686# a_10661_32879# VSS sg13_lv_nmos ad=79.8f pd=0.8u as=0.2373p ps=1.97u w=0.42u l=0.13u
X1037 VSS a_46594_10649# B_uq15 VSS sg13_lv_nmos ad=0.14875p pd=1.16u as=0.2886p ps=2.26u w=0.74u l=0.13u
X1038 a_41508_10301# B_uq20 a_41414_10301# VDD sg13_lv_pmos ad=0.1596p pd=1.22u as=0.2856p ps=2.36u w=0.84u l=0.13u
X1039 Q_uq53 a_44886_67368# VSS VSS sg13_lv_nmos ad=0.2516p pd=2.16u as=0.1406p ps=1.12u w=0.74u l=0.13u
X1040 Y_uq122 C_uq20 VSS VSS sg13_lv_nmos ad=0.2618p pd=2.22u as=0.1463p ps=1.15u w=0.77u l=0.13u
X1041 a_10951_20869# C_uq24 VSS VSS sg13_lv_nmos ad=0.1406p pd=1.12u as=0.18575p ps=1.26u w=0.74u l=0.13u
X1042 a_11659_24183# D_uq7 a_11557_24183# VDD sg13_lv_pmos ad=0.2128p pd=1.5u as=0.2128p ps=1.5u w=1.12u l=0.13u
X1043 VSS a_44326_69598# a_44045_69820# VSS sg13_lv_nmos ad=79.8f pd=0.8u as=0.1428p ps=1.52u w=0.42u l=0.5u
X1044 a_5523_21946# a_4681_21848# a_4264_22187# VDD sg13_lv_pmos ad=0.2048p pd=1.63u as=0.34p ps=2.68u w=1u l=0.13u
X1045 a_43042_10649# q[21] VSS VSS sg13_lv_nmos ad=0.187p pd=1.78u as=0.14875p ps=1.16u w=0.55u l=0.13u
X1046 a_80197_26168# a_80312_26169# VSS VSS sg13_lv_nmos ad=0.1428p pd=1.52u as=0.1426p ps=1.16u w=0.42u l=0.5u
X1047 a_3571_35145# D_uq22 a_3571_35051# VSS sg13_lv_nmos ad=60.89999f pd=0.71u as=0.1428p ps=1.52u w=0.42u l=0.13u
X1048 a_10349_41167# a_10347_42044# a_10428_41550# VDD sg13_lv_pmos ad=79.8f pd=0.8u as=63f ps=0.72u w=0.42u l=0.13u
X1049 a_45644_67655# a_45763_67332# VDD VDD sg13_lv_pmos ad=0.3864p pd=2.93u as=0.2128p ps=1.5u w=1.12u l=0.13u
X1050 q[12] a_36532_65132# VDD VDD sg13_lv_pmos ad=0.42p pd=2.99u as=0.2114p ps=1.54u w=1.12u l=0.13u
X1051 VSS Y_uq257 a_49508_65098# VSS sg13_lv_nmos ad=79.8f pd=0.8u as=0.1428p ps=1.52u w=0.42u l=0.13u
X1052 X_uq21 a_38238_6937# VSS VSS sg13_lv_nmos ad=0.2886p pd=2.26u as=0.14875p ps=1.16u w=0.74u l=0.13u
X1053 VDD Q_uq46 a_32980_63620# VDD sg13_lv_pmos ad=0.2114p pd=1.54u as=0.2856p ps=2.36u w=0.84u l=0.13u
X1054 VDD a_51899_67729# a_52156_67610# VDD sg13_lv_pmos ad=1.19383p pd=7.16u as=79.8f ps=0.8u w=0.42u l=0.13u
X1055 a_6910_32958# a_6570_32837# a_6559_33211# VDD sg13_lv_pmos ad=93.45f pd=0.865u as=0.2048p ps=1.63u w=0.42u l=0.13u
X1056 a_33730_7625# SL[0] VSS VSS sg13_lv_nmos ad=0.187p pd=1.78u as=0.14875p ps=1.16u w=0.55u l=0.13u
X1057 X_uq175 a_12593_18599# VSS VSS sg13_lv_nmos ad=0.2886p pd=2.26u as=0.14875p ps=1.16u w=0.74u l=0.13u
X1058 D_uq49 C_uq51 a_33027_65856# VDD sg13_lv_pmos ad=0.3808p pd=2.92u as=0.2128p ps=1.5u w=1.12u l=0.13u
X1059 VDD SLN[6] a_32766_10685# VDD sg13_lv_pmos ad=0.2114p pd=1.54u as=0.2856p ps=2.36u w=0.84u l=0.13u
X1060 VSS C_uq14 C1_uq2 VSS sg13_lv_nmos ad=0.1463p pd=1.15u as=0.2618p ps=2.22u w=0.77u l=0.13u
X1061 VDD a_8075_37753# D_uq25 VDD sg13_lv_pmos ad=0.2254p pd=1.53u as=0.4256p ps=3u w=1.12u l=0.13u
X1062 a_46594_10649# q[26] VSS VSS sg13_lv_nmos ad=0.187p pd=1.78u as=0.14875p ps=1.16u w=0.55u l=0.13u
X1063 Y_uq246 a_44602_63624# VSS VSS sg13_lv_nmos ad=0.1406p pd=1.12u as=0.17255p ps=1.25u w=0.74u l=0.13u
X1064 VSS X_uq200 a_8561_20899# VSS sg13_lv_nmos ad=0.14875p pd=1.16u as=0.187p ps=1.78u w=0.55u l=0.13u
X1065 a_39600_67372# a_39574_67336# VDD VDD sg13_lv_pmos ad=0.34p pd=2.68u as=0.36237p ps=2.605u w=1u l=0.13u
X1066 a_44602_68307# a_44717_68308# VSS VSS sg13_lv_nmos ad=0.1428p pd=1.52u as=0.1426p ps=1.16u w=0.42u l=0.5u
X1067 a_77347_21741# B_uq67 C_uq6 VDD sg13_lv_pmos ad=0.1176p pd=1.33u as=0.3808p ps=2.92u w=1.12u l=0.13u
X1068 Q_uq35 a_35190_66904# VSS VSS sg13_lv_nmos ad=0.2516p pd=2.16u as=0.1406p ps=1.12u w=0.74u l=0.13u
X1069 a_29130_66858# a_28931_66921# VSS VSS sg13_lv_nmos ad=0.27427p pd=2.28u as=1.8643p ps=11.96u w=0.795u l=0.13u
X1070 a_42435_67368# Y_uq306 a_42321_67368# VDD sg13_lv_pmos ad=0.2128p pd=1.5u as=0.2464p ps=1.56u w=1.12u l=0.13u
X1071 VDD a_37070_11001# X_uq160 VDD sg13_lv_pmos ad=0.2226p pd=1.535u as=0.3976p ps=2.95u w=1.12u l=0.13u
X1072 VDD a_5809_43188# a_5809_43290# VDD sg13_lv_pmos ad=0.2128p pd=1.5u as=0.3864p ps=2.93u w=1.12u l=0.13u
X1073 A_uq57 a_33748_63620# VDD VDD sg13_lv_pmos ad=0.42p pd=2.99u as=0.2114p ps=1.54u w=1.12u l=0.13u
X1074 VSS Y_uq254 a_32116_64344# VSS sg13_lv_nmos ad=0.14875p pd=1.16u as=0.187p ps=1.78u w=0.55u l=0.13u
X1075 VSS a_41794_6863# X_uq12 VSS sg13_lv_nmos ad=0.14875p pd=1.16u as=0.2886p ps=2.26u w=0.74u l=0.13u
X1076 VSS a_45644_67655# Q_uq51 VSS sg13_lv_nmos ad=0.1406p pd=1.12u as=0.2516p ps=2.16u w=0.74u l=0.13u
X1077 a_7742_21837# Q_uq0 VDD VDD sg13_lv_pmos ad=0.1428p pd=1.52u as=0.1523p ps=1.38u w=0.42u l=0.13u
X1078 VSS L_HI_uq26 a_47522_67793# VSS sg13_lv_nmos ad=0.1701p pd=1.65u as=37.8f ps=0.6u w=0.42u l=0.13u
X1079 a_9583_42043# a_9598_40746# a_9583_41709# VDD sg13_lv_pmos ad=0.2048p pd=1.63u as=0.34p ps=2.68u w=1u l=0.13u
X1080 a_47265_67415# a_46323_67455# a_47126_67648# VSS sg13_lv_nmos ad=79.8f pd=0.8u as=0.2373p ps=1.97u w=0.42u l=0.13u
X1081 a_79045_22643# a_78787_22643# VSS VSS sg13_lv_nmos ad=0.1428p pd=1.52u as=79.8f ps=0.8u w=0.42u l=0.13u
X1082 a_4297_36991# Y_uq195 VDD VDD sg13_lv_pmos ad=0.1428p pd=1.52u as=0.1523p ps=1.38u w=0.42u l=0.13u
X1083 D_uq52 C_uq64 VSS VSS sg13_lv_nmos ad=0.2618p pd=2.22u as=0.1463p ps=1.15u w=0.77u l=0.13u
X1084 A_N a_10481_23135# VSS VSS sg13_lv_nmos ad=0.2886p pd=2.26u as=0.14875p ps=1.16u w=0.74u l=0.13u
X1085 VDD VSS VDD VDD sg13_lv_pmos ad=0.19p pd=1.38u as=0 ps=0 w=1u l=1u
X1086 Y_uq5 A_uq98 VSS VSS sg13_lv_nmos ad=0.1406p pd=1.12u as=0.2516p ps=2.16u w=0.74u l=0.13u
X1087 VDD a_42250_9137# a_42208_9173# VDD sg13_lv_pmos ad=0.2618p pd=1.63u as=0.1176p ps=1.33u w=1.12u l=0.13u
X1088 VSS VDD VSS VSS sg13_lv_nmos ad=79.8f pd=0.8u as=0 ps=-0 w=0.42u l=1u
X1089 a_42288_64769# a_42000_64348# a_42226_64769# VSS sg13_lv_nmos ad=0.1428p pd=1.52u as=37.8f ps=0.6u w=0.42u l=0.13u
X1090 a_10229_18135# C_uq5 Y_uq31 VDD sg13_lv_pmos ad=0.1176p pd=1.33u as=0.3808p ps=2.92u w=1.12u l=0.13u
X1091 VSS X_uq458 a_33370_67424# VSS sg13_lv_nmos ad=0.17255p pd=1.25u as=0.187p ps=1.78u w=0.55u l=0.13u
X1092 a_76741_25229# B1_uq1 a_76953_25229# VDD sg13_lv_pmos ad=0.2128p pd=1.5u as=0.3808p ps=2.92u w=1.12u l=0.13u
X1093 VDD a_7059_24970# a_7316_25113# VDD sg13_lv_pmos ad=1.17282p pd=7.015u as=79.8f ps=0.8u w=0.42u l=0.13u
X1094 a_5892_41550# a_5849_41193# VDD VDD sg13_lv_pmos ad=63f pd=0.72u as=0.1563p ps=1.22u w=0.42u l=0.13u
X1095 VSS a_80197_26168# X_uq250 VSS sg13_lv_nmos ad=0.1426p pd=1.16u as=0.2516p ps=2.16u w=0.74u l=0.13u
X1096 VSS X_uq159 a_37092_9965# VSS sg13_lv_nmos ad=0.17255p pd=1.25u as=0.187p ps=1.78u w=0.55u l=0.13u
X1097 a_43318_65824# a_43761_65867# a_43701_65903# VDD sg13_lv_pmos ad=79.8f pd=0.8u as=63f ps=0.72u w=0.42u l=0.13u
X1098 VSS a_44021_66552# a_43942_66827# VSS sg13_lv_nmos ad=1.8643p pd=11.96u as=0.27427p ps=2.28u w=0.795u l=0.13u
X1099 a_36566_66904# X_uq433 VDD VDD sg13_lv_pmos ad=0.1176p pd=1.33u as=0.4032p ps=2.96u w=1.12u l=0.13u
X1100 VSS a_38986_9137# Y_uq12 VSS sg13_lv_nmos ad=0.17255p pd=1.25u as=0.1406p ps=1.12u w=0.74u l=0.13u
X1101 VDD Y_uq328 a_28388_68122# VDD sg13_lv_pmos ad=0.1523p pd=1.38u as=0.1428p ps=1.52u w=0.42u l=0.13u
X1102 a_50168_69594# Y_uq356 VSS VSS sg13_lv_nmos ad=0.187p pd=1.78u as=0.14875p ps=1.16u w=0.55u l=0.13u
X1103 VDD Y_uq70 a_9905_21623# VDD sg13_lv_pmos ad=0.2114p pd=1.54u as=0.2856p ps=2.36u w=0.84u l=0.13u
X1104 a_9746_24671# B_uq63 VSS VSS sg13_lv_nmos ad=0.198p pd=1.27u as=0.1045p ps=0.93u w=0.55u l=0.13u
X1105 a_6088_24906# a_5800_25211# a_6026_24906# VSS sg13_lv_nmos ad=0.1428p pd=1.52u as=37.8f ps=0.6u w=0.42u l=0.13u
X1106 VSS a_41330_65098# a_41442_65162# VSS sg13_lv_nmos ad=0.1426p pd=1.16u as=0.1428p ps=1.52u w=0.42u l=0.5u
X1107 a_51034_65094# a_51275_65364# a_50563_65058# VSS sg13_lv_nmos ad=0.1428p pd=1.52u as=0.12665p ps=1.145u w=0.42u l=0.13u
X1108 a_28658_68122# a_28388_68122# VDD VDD sg13_lv_pmos ad=0.34p pd=2.68u as=0.1523p ps=1.38u w=1u l=0.5u
X1109 Y_uq23 A_uq88 a_37794_10221# VDD sg13_lv_pmos ad=0.3808p pd=2.92u as=0.1176p ps=1.33u w=1.12u l=0.13u
X1110 Y_uq234 X_uq323 VDD VDD sg13_lv_pmos ad=0.3808p pd=2.92u as=0.3808p ps=2.92u w=1.12u l=0.13u
X1111 a_5800_21123# a_5774_21087# VSS VSS sg13_lv_nmos ad=0.2516p pd=2.16u as=0.1626p ps=1.415u w=0.74u l=0.13u
X1112 Y_uq94 X_uq226 VSS VSS sg13_lv_nmos ad=0.1406p pd=1.12u as=0.2516p ps=2.16u w=0.74u l=0.13u
X1113 a_78588_26277# A2_uq3 VDD VDD sg13_lv_pmos ad=0.2464p pd=1.56u as=0.3808p ps=2.92u w=1.12u l=0.13u
X1114 VDD a_43036_69850# a_42981_69945# VDD sg13_lv_pmos ad=1.6733p pd=10.405u as=93.45f ps=0.865u w=0.42u l=0.13u
X1115 VDD VSS VDD VDD sg13_lv_pmos ad=0.34p pd=2.68u as=0 ps=0 w=1u l=1u
X1116 a_8079_37083# S VDD VDD sg13_lv_pmos ad=0.2856p pd=2.36u as=0.2198p ps=1.53u w=0.84u l=0.13u
X1117 VSS X_uq303 a_7735_37687# VSS sg13_lv_nmos ad=0.1406p pd=1.12u as=0.1406p ps=1.12u w=0.74u l=0.15u
X1118 VDD D_uq30 Y_uq178 VDD sg13_lv_pmos ad=0.2128p pd=1.5u as=0.2128p ps=1.5u w=1.12u l=0.13u
X1119 a_39588_10301# B_uq23 a_39494_10301# VDD sg13_lv_pmos ad=0.1596p pd=1.22u as=0.2856p ps=2.36u w=0.84u l=0.13u
X1120 VDD clk a_3550_32372# VDD sg13_lv_pmos ad=1.25632p pd=8.01u as=0.4088p ps=2.97u w=1.12u l=0.13u
X1121 VSS a_52582_68086# a_52301_68308# VSS sg13_lv_nmos ad=79.8f pd=0.8u as=0.1428p ps=1.52u w=0.42u l=0.5u
X1122 a_11957_19647# C_uq4 Y_uq55 VDD sg13_lv_pmos ad=0.1176p pd=1.33u as=0.3808p ps=2.92u w=1.12u l=0.13u
X1123 a_5051_41791# X_uq321 VSS VSS sg13_lv_nmos ad=0.1428p pd=1.52u as=79.8f ps=0.8u w=0.42u l=0.13u
X1124 VSS C_uq57 Y_uq240 VSS sg13_lv_nmos ad=0.1463p pd=1.15u as=0.2618p ps=2.22u w=0.77u l=0.13u
X1125 a_28867_64308# a_29427_64431# a_29338_64467# VDD sg13_lv_pmos ad=0.2048p pd=1.63u as=93.45f ps=0.865u w=0.42u l=0.13u
X1126 a_46210_10649# q[25] VDD VDD sg13_lv_pmos ad=0.2856p pd=2.36u as=0.2114p ps=1.54u w=0.84u l=0.13u
X1127 VDD Y_uq32 a_8561_17875# VDD sg13_lv_pmos ad=0.2114p pd=1.54u as=0.2856p ps=2.36u w=0.84u l=0.13u
X1128 a_7478_21557# L_HI_uq2 VSS VSS sg13_lv_nmos ad=37.8f pd=0.6u as=79.8f ps=0.8u w=0.42u l=0.13u
X1129 a_50928_67793# a_50640_67372# a_50866_67793# VSS sg13_lv_nmos ad=0.1428p pd=1.52u as=37.8f ps=0.6u w=0.42u l=0.13u
X1130 VDD VSS VDD VDD sg13_lv_pmos ad=0.19p pd=1.38u as=0 ps=0 w=1u l=1u
X1131 a_3978_21869# a_4783_21991# a_4238_22092# VDD sg13_lv_pmos ad=0.1428p pd=1.52u as=79.8f ps=0.8u w=0.42u l=0.13u
X1132 C_uq60 X_uq434 a_32630_67368# VDD sg13_lv_pmos ad=0.3808p pd=2.92u as=0.1176p ps=1.33u w=1.12u l=0.13u
X1133 X_uq200 a_6572_20395# VSS VSS sg13_lv_nmos ad=0.2886p pd=2.26u as=0.14875p ps=1.16u w=0.74u l=0.13u
X1134 VSS a_6559_42907# a_6559_43290# VSS sg13_lv_nmos ad=0.1406p pd=1.12u as=0.2516p ps=2.16u w=0.74u l=0.13u
X1135 VDD a_29361_65867# a_29463_65867# VDD sg13_lv_pmos ad=1.41367p pd=8.85u as=0.3864p ps=2.93u w=1.12u l=0.13u
X1136 VDD a_9583_42043# a_9583_41879# VDD sg13_lv_pmos ad=1.17462p pd=7.44u as=79.8f ps=0.8u w=0.42u l=0.13u
X1137 VDD a_30897_65073# a_30999_65216# VDD sg13_lv_pmos ad=1.41367p pd=8.85u as=0.3864p ps=2.93u w=1.12u l=0.13u
X1138 a_7742_24107# Q_uq4 VSS VSS sg13_lv_nmos ad=0.1428p pd=1.52u as=79.8f ps=0.8u w=0.42u l=0.13u
X1139 X_uq176 a_12209_18599# VDD VDD sg13_lv_pmos ad=0.42p pd=2.99u as=0.2114p ps=1.54u w=1.12u l=0.13u
X1140 VSS L_HI_uq0 a_78881_21131# VSS sg13_lv_nmos ad=79.8f pd=0.8u as=37.8f ps=0.6u w=0.42u l=0.13u
X1141 VSS a_49760_63550# Y_uq243 VSS sg13_lv_nmos ad=0.17255p pd=1.25u as=0.1406p ps=1.12u w=0.74u l=0.13u
X1142 A_uq95 a_33254_10301# VDD VDD sg13_lv_pmos ad=0.3976p pd=2.95u as=0.2226p ps=1.535u w=1.12u l=0.13u
X1143 X_uq205 a_9905_21623# VSS VSS sg13_lv_nmos ad=0.2886p pd=2.26u as=0.14875p ps=1.16u w=0.74u l=0.13u
X1144 VSS a_80076_20740# a_79155_21054# VSS sg13_lv_nmos ad=0.1626p pd=1.415u as=0.2516p ps=2.16u w=0.74u l=0.13u
X1145 VSS a_38338_7625# X_uq112 VSS sg13_lv_nmos ad=0.14875p pd=1.16u as=0.2886p ps=2.26u w=0.74u l=0.13u
X1146 VDD a_50193_68097# a_50295_68240# VDD sg13_lv_pmos ad=1.42837p pd=8.61u as=0.3864p ps=2.93u w=1.12u l=0.13u
X1147 a_43761_65867# clk VSS VSS sg13_lv_nmos ad=0.2516p pd=2.16u as=1.7977p ps=11.53u w=0.74u l=0.13u
X1148 a_35298_8709# a_35076_8453# VDD VDD sg13_lv_pmos ad=0.1176p pd=1.33u as=0.2618p ps=1.63u w=1.12u l=0.13u
X1149 a_76534_26717# Y_uq148 VDD VDD sg13_lv_pmos ad=0.2716p pd=1.605u as=0.3808p ps=2.92u w=1.12u l=0.13u
X1150 a_46632_64705# a_46763_64315# a_46051_64308# VDD sg13_lv_pmos ad=0.34p pd=2.68u as=0.2048p ps=1.63u w=1u l=0.13u
X1151 VDD Y_uq197 a_8916_36842# VDD sg13_lv_pmos ad=0.36237p pd=2.605u as=79.8f ps=0.8u w=0.42u l=0.13u
X1152 VSS a_39610_66795# X_uq400 VSS sg13_lv_nmos ad=0.1426p pd=1.16u as=0.2516p ps=2.16u w=0.74u l=0.13u
X1153 VSS VDD VSS VSS sg13_lv_nmos ad=0.1428p pd=1.52u as=0 ps=-0 w=0.42u l=1u
X1154 VDD X_uq236 a_10289_21623# VDD sg13_lv_pmos ad=0.2114p pd=1.54u as=0.2856p ps=2.36u w=0.84u l=0.13u
X1155 VSS B_uq49 B_uq60 VSS sg13_lv_nmos ad=0.2516p pd=2.16u as=0.1406p ps=1.12u w=0.74u l=0.13u
X1156 VSS Y_uq230 a_3571_39849# VSS sg13_lv_nmos ad=0.1626p pd=1.415u as=60.89999f ps=0.71u w=0.42u l=0.13u
X1157 a_45634_7625# X_uq96 VSS VSS sg13_lv_nmos ad=0.187p pd=1.78u as=0.14875p ps=1.16u w=0.55u l=0.13u
X1158 a_3535_41755# a_3550_40458# a_3571_41523# VSS sg13_lv_nmos ad=0.12665p pd=1.145u as=0.1428p ps=1.52u w=0.42u l=0.13u
X1159 a_8071_32685# a_8116_31287# VDD VDD sg13_lv_pmos ad=0.34p pd=2.68u as=0.36237p ps=2.605u w=1u l=0.13u
X1160 a_5892_41738# a_5847_41975# a_5813_41167# VDD sg13_lv_pmos ad=0.1428p pd=1.52u as=79.8f ps=0.8u w=0.42u l=0.13u
X1161 a_80729_21131# L_HI_uq0 VSS VSS sg13_lv_nmos ad=60.89999f pd=0.71u as=0.1626p ps=1.415u w=0.42u l=0.13u
X1162 VDD X_uq448 a_46324_69668# VDD sg13_lv_pmos ad=0.2114p pd=1.54u as=0.2856p ps=2.36u w=0.84u l=0.13u
X1163 VDD a_36202_8379# a_36160_8709# VDD sg13_lv_pmos ad=0.2618p pd=1.63u as=0.1176p ps=1.33u w=1.12u l=0.13u
X1164 VSS a_28160_65062# Y_uq271 VSS sg13_lv_nmos ad=0.17255p pd=1.25u as=0.1406p ps=1.12u w=0.74u l=0.13u
X1165 VDD a_4094_25896# L_HI_uq6 VDD sg13_lv_pmos ad=1.17282p pd=7.015u as=0.3927p ps=2.99u w=1.155u l=0.13u
X1166 VSS a_6217_24872# a_6319_25015# VSS sg13_lv_nmos ad=3.1581p pd=19.78u as=0.2516p ps=2.16u w=0.74u l=0.13u
X1167 a_79155_21054# a_79286_20664# a_78574_20657# VDD sg13_lv_pmos ad=0.34p pd=2.68u as=0.2048p ps=1.63u w=1u l=0.13u
X1168 a_75979_23253# Y_uq88 a_75877_23253# VDD sg13_lv_pmos ad=0.2128p pd=1.5u as=0.2128p ps=1.5u w=1.12u l=0.13u
X1169 VDD VSS VDD VDD sg13_lv_pmos ad=0.34p pd=2.68u as=0 ps=0 w=1u l=1u
X1170 VDD Y_uq163 a_8107_31019# VDD sg13_lv_pmos ad=0.36237p pd=2.605u as=79.8f ps=0.8u w=0.42u l=0.13u
X1171 a_7727_40852# a_7321_40826# A0_uq0 VSS sg13_lv_nmos ad=0.1406p pd=1.12u as=0.333p ps=2.38u w=0.74u l=0.13u
X1172 a_33586_68131# L_HI_uq30 VSS VSS sg13_lv_nmos ad=37.8f pd=0.6u as=0.1701p ps=1.65u w=0.42u l=0.13u
X1173 Y_uq308 X_uq400 VSS VSS sg13_lv_nmos ad=0.1406p pd=1.12u as=0.2516p ps=2.16u w=0.74u l=0.13u
X1174 a_12142_24183# C_uq19 VDD VDD sg13_lv_pmos ad=0.2464p pd=1.56u as=0.3808p ps=2.92u w=1.12u l=0.13u
X1175 a_39043_68844# a_39603_68967# a_39624_69241# VSS sg13_lv_nmos ad=0.12665p pd=1.145u as=0.3473p ps=2.71u w=0.74u l=0.13u
X1176 VSS a_38662_66574# a_38381_66796# VSS sg13_lv_nmos ad=79.8f pd=0.8u as=0.1428p ps=1.52u w=0.42u l=0.5u
X1177 VSS C_uq22 Y_uq110 VSS sg13_lv_nmos ad=0.1463p pd=1.15u as=0.1694p ps=1.21u w=0.77u l=0.13u
X1178 VDD a_48262_63803# L_HI_uq9 VDD sg13_lv_pmos ad=1.4745p pd=9.07u as=0.3927p ps=2.99u w=1.155u l=0.13u
X1179 VDD L_HI_uq32 a_29330_69318# VDD sg13_lv_pmos ad=0.36237p pd=2.605u as=79.8f ps=0.8u w=0.42u l=0.13u
X1180 VSS B_uq67 a_76765_24493# VSS sg13_lv_nmos ad=0.2516p pd=2.16u as=0.1406p ps=1.12u w=0.74u l=0.13u
X1181 VDD Y_uq57 a_12593_18599# VDD sg13_lv_pmos ad=0.2114p pd=1.54u as=0.2856p ps=2.36u w=0.84u l=0.13u
X1182 q[6] a_27988_63620# VSS VSS sg13_lv_nmos ad=0.2886p pd=2.26u as=0.14875p ps=1.16u w=0.74u l=0.13u
X1183 a_78877_24480# L_HI_uq4 VSS VSS sg13_lv_nmos ad=37.8f pd=0.6u as=0.1701p ps=1.65u w=0.42u l=0.13u
X1184 C_uq61 X_uq455 VSS VSS sg13_lv_nmos ad=0.1406p pd=1.12u as=0.2516p ps=2.16u w=0.74u l=0.13u
X1185 VDD a_38044_67610# a_37989_67491# VDD sg13_lv_pmos ad=1.19383p pd=7.16u as=93.45f ps=0.865u w=0.42u l=0.13u
X1186 Y_uq42 X_uq188 VDD VDD sg13_lv_pmos ad=0.3808p pd=2.92u as=0.3808p ps=2.92u w=1.12u l=0.13u
X1187 VSS a_8833_38292# a_8833_38394# VSS sg13_lv_nmos ad=0.1406p pd=1.12u as=0.2516p ps=2.16u w=0.74u l=0.13u
X1188 a_29074_69643# L_HI_uq40 VSS VSS sg13_lv_nmos ad=37.8f pd=0.6u as=0.1701p ps=1.65u w=0.42u l=0.13u
X1189 VSS L_HI_uq3 a_5608_23381# VSS sg13_lv_nmos ad=0.1626p pd=1.415u as=60.89999f ps=0.71u w=0.42u l=0.13u
X1190 VSS clk a_3550_32372# VSS sg13_lv_nmos ad=4.345p pd=28.205u as=0.2516p ps=2.16u w=0.74u l=0.13u
X1191 a_44476_67610# L_HI_uq27 VDD VDD sg13_lv_pmos ad=79.8f pd=0.8u as=1.19383p ps=7.16u w=0.42u l=0.13u
X1192 a_43632_66281# a_43344_65860# a_43570_66281# VSS sg13_lv_nmos ad=0.1428p pd=1.52u as=37.8f ps=0.6u w=0.42u l=0.13u
X1193 a_30454_65317# a_30897_65073# a_30837_65485# VDD sg13_lv_pmos ad=79.8f pd=0.8u as=63f ps=0.72u w=0.42u l=0.13u
X1194 VDD VSS VDD VDD sg13_lv_pmos ad=0.34p pd=2.68u as=0 ps=0 w=1u l=1u
X1195 a_44913_68891# clk VSS VSS sg13_lv_nmos ad=0.2516p pd=2.16u as=1.9335p ps=12.315u w=0.74u l=0.13u
X1196 VSS X_uq300 D_uq22 VSS sg13_lv_nmos ad=0.2516p pd=2.16u as=0.2516p ps=2.16u w=0.74u l=0.13u
X1197 VSS a_42779_69707# a_43446_69928# VSS sg13_lv_nmos ad=0.1406p pd=1.12u as=0.2516p ps=2.16u w=0.74u l=0.13u
X1198 Y_uq280 a_32314_65912# VSS VSS sg13_lv_nmos ad=0.1406p pd=1.12u as=0.17255p ps=1.25u w=0.74u l=0.13u
X1199 SLN[0] a_27700_69668# VDD VDD sg13_lv_pmos ad=0.42p pd=2.99u as=0.2114p ps=1.54u w=1.12u l=0.13u
X1200 VDD Y_uq208 a_4333_38353# VDD sg13_lv_pmos ad=0.4032p pd=2.96u as=0.1176p ps=1.33u w=1.12u l=0.13u
X1201 VDD X_uq91 a_33246_7661# VDD sg13_lv_pmos ad=0.2114p pd=1.54u as=0.2856p ps=2.36u w=0.84u l=0.13u
X1202 VSS X_uq144 a_41414_9149# VSS sg13_lv_nmos ad=0.1469p pd=1.155u as=0.1045p ps=0.93u w=0.55u l=0.13u
X1203 a_10587_24647# D_uq7 Y_uq129 VDD sg13_lv_pmos ad=0.2128p pd=1.5u as=0.4368p ps=3.02u w=1.12u l=0.13u
X1204 VDD a_8833_38292# a_8956_37847# VDD sg13_lv_pmos ad=1.5243p pd=9.795u as=79.8f ps=0.8u w=0.42u l=0.13u
X1205 a_41794_7625# X_uq79 VDD VDD sg13_lv_pmos ad=0.2856p pd=2.36u as=0.2114p ps=1.54u w=0.84u l=0.13u
X1206 VSS a_51057_67379# a_51159_67379# VSS sg13_lv_nmos ad=2.08687p pd=13.23u as=0.2516p ps=2.16u w=0.74u l=0.13u
X1207 VSS X_uq237 C_uq18 VSS sg13_lv_nmos ad=0.2516p pd=2.16u as=0.1406p ps=1.12u w=0.74u l=0.13u
X1208 a_80675_28967# X_uq281 VDD VDD sg13_lv_pmos ad=0.2856p pd=2.36u as=0.2114p ps=1.54u w=0.84u l=0.13u
X1209 C_uq61 X_uq404 a_28694_66904# VDD sg13_lv_pmos ad=0.3808p pd=2.92u as=0.1176p ps=1.33u w=1.12u l=0.13u
X1210 a_76459_21741# Y_uq62 VDD VDD sg13_lv_pmos ad=0.2128p pd=1.5u as=0.3808p ps=2.92u w=1.12u l=0.13u
X1211 a_48070_65062# Q_uq31 VSS VSS sg13_lv_nmos ad=0.1428p pd=1.52u as=79.8f ps=0.8u w=0.42u l=0.13u
X1212 a_33264_66924# a_33783_66728# a_34523_66683# VSS sg13_lv_nmos ad=0.3473p pd=2.71u as=0.12665p ps=1.145u w=0.74u l=0.13u
X1213 Y_uq24 a_37092_9965# VSS VSS sg13_lv_nmos ad=0.1406p pd=1.12u as=0.17255p ps=1.25u w=0.74u l=0.13u
X1214 VSS L_HI_uq32 a_29424_69318# VSS sg13_lv_nmos ad=0.1626p pd=1.415u as=60.89999f ps=0.71u w=0.42u l=0.13u
X1215 a_76765_21469# Y_uq62 A2 VSS sg13_lv_nmos ad=0.1406p pd=1.12u as=0.2516p ps=2.16u w=0.74u l=0.13u
X1216 Y_uq85 B_uq43 a_78282_23717# VDD sg13_lv_pmos ad=0.2408p pd=1.55u as=0.1428p ps=1.375u w=1.12u l=0.13u
X1217 a_41520_69948# a_41494_69853# VDD VDD sg13_lv_pmos ad=0.34p pd=2.68u as=0.36237p ps=2.605u w=1u l=0.13u
X1218 X_uq273 a_77503_29041# VSS VSS sg13_lv_nmos ad=0.2886p pd=2.26u as=0.14875p ps=1.16u w=0.74u l=0.13u
X1219 a_47918_67806# L_HI_uq26 VSS VSS sg13_lv_nmos ad=60.89999f pd=0.71u as=0.1626p ps=1.415u w=0.42u l=0.13u
X1220 B_uq63 a_8561_24647# VDD VDD sg13_lv_pmos ad=0.42p pd=2.99u as=0.2114p ps=1.54u w=1.12u l=0.13u
X1221 Y_uq31 C_uq5 VSS VSS sg13_lv_nmos ad=0.1406p pd=1.12u as=0.2516p ps=2.16u w=0.74u l=0.13u
X1222 VDD VSS VDD VDD sg13_lv_pmos ad=0.19p pd=1.38u as=0 ps=0 w=1u l=1u
X1223 VSS X_uq420 a_27706_64400# VSS sg13_lv_nmos ad=0.17255p pd=1.25u as=0.187p ps=1.78u w=0.55u l=0.13u
X1224 VDD a_35534_9489# X_uq91 VDD sg13_lv_pmos ad=0.2226p pd=1.535u as=0.3976p ps=2.95u w=1.12u l=0.13u
X1225 Y_uq146 X_uq275 VDD VDD sg13_lv_pmos ad=0.3808p pd=2.92u as=0.3808p ps=2.92u w=1.12u l=0.13u
X1226 VSS a_48922_69147# X_uq425 VSS sg13_lv_nmos ad=0.1426p pd=1.16u as=0.2516p ps=2.16u w=0.74u l=0.13u
X1227 VDD a_30203_66217# a_30460_66098# VDD sg13_lv_pmos ad=1.41367p pd=8.85u as=79.8f ps=0.8u w=0.42u l=0.13u
X1228 VSS Y_uq366 a_27700_69668# VSS sg13_lv_nmos ad=0.14875p pd=1.16u as=0.187p ps=1.78u w=0.55u l=0.13u
X1229 a_8956_42551# a_8833_42996# a_9307_42679# VSS sg13_lv_nmos ad=0.1428p pd=1.52u as=37.8f ps=0.6u w=0.42u l=0.13u
X1230 VSS a_8075_34111# a_8111_34043# VSS sg13_lv_nmos ad=79.8f pd=0.8u as=0.1428p ps=1.52u w=0.42u l=0.5u
X1231 VSS a_46808_69594# X_uq448 VSS sg13_lv_nmos ad=0.14875p pd=1.16u as=0.2886p ps=2.26u w=0.74u l=0.13u
X1232 a_7292_38117# A0 a_7705_38415# VSS sg13_lv_nmos ad=0.2176p pd=1.96u as=0.1216p ps=1.02u w=0.64u l=0.13u
X1233 VDD a_6217_24872# a_6319_25015# VDD sg13_lv_pmos ad=1.17282p pd=7.015u as=0.3864p ps=2.93u w=1.12u l=0.13u
X1234 VDD L_HI_uq24 a_33238_66829# VDD sg13_lv_pmos ad=0.1563p pd=1.22u as=0.147p ps=1.54u w=0.42u l=0.13u
X1235 Y_uq91 Y_uq92 VSS VSS sg13_lv_nmos ad=0.2618p pd=2.22u as=0.1463p ps=1.15u w=0.77u l=0.13u
X1236 a_76459_24493# B2_uq6 VSS VSS sg13_lv_nmos ad=0.1406p pd=1.12u as=0.1406p ps=1.12u w=0.74u l=0.13u
X1237 VSS a_34520_68844# X_uq435 VSS sg13_lv_nmos ad=0.14875p pd=1.16u as=0.2886p ps=2.26u w=0.74u l=0.13u
X1238 a_36952_64344# a_36730_64400# VDD VDD sg13_lv_pmos ad=0.1176p pd=1.33u as=0.2618p ps=1.63u w=1.12u l=0.13u
X1239 VDD L_HI_uq12 a_33170_64782# VDD sg13_lv_pmos ad=0.36237p pd=2.605u as=79.8f ps=0.8u w=0.42u l=0.13u
X1240 a_44866_8375# A_uq19 VSS VSS sg13_lv_nmos ad=0.187p pd=1.78u as=0.14875p ps=1.16u w=0.55u l=0.13u
X1241 a_43522_9137# A_uq44 VDD VDD sg13_lv_pmos ad=0.2856p pd=2.36u as=0.2114p ps=1.54u w=0.84u l=0.13u
X1242 a_36273_68416# X_uq435 VDD VDD sg13_lv_pmos ad=0.2464p pd=1.56u as=0.3808p ps=2.92u w=1.12u l=0.13u
X1243 VDD B_uq67 a_77604_21489# VDD sg13_lv_pmos ad=0.1918p pd=1.5u as=0.1596p ps=1.22u w=0.84u l=0.13u
X1244 Y_uq26 X_uq168 VSS VSS sg13_lv_nmos ad=0.1406p pd=1.12u as=0.2516p ps=2.16u w=0.74u l=0.13u
X1245 VSS a_6559_33047# a_6595_32979# VSS sg13_lv_nmos ad=79.8f pd=0.8u as=0.1428p ps=1.52u w=0.42u l=0.13u
X1246 VSS D_uq25 a_9235_35367# VSS sg13_lv_nmos ad=0.2516p pd=2.16u as=0.1406p ps=1.12u w=0.74u l=0.13u
X1247 VSS X_uq436 Y_uq269 VSS sg13_lv_nmos ad=0.2618p pd=2.22u as=0.1694p ps=1.21u w=0.77u l=0.13u
X1248 a_5051_34111# Q_uq13 VDD VDD sg13_lv_pmos ad=0.1428p pd=1.52u as=0.1523p ps=1.38u w=0.42u l=0.13u
X1249 a_5514_23381# a_6319_23503# a_5774_23604# VDD sg13_lv_pmos ad=0.1428p pd=1.52u as=79.8f ps=0.8u w=0.42u l=0.13u
X1250 a_8071_33019# a_8086_31722# a_8107_32787# VSS sg13_lv_nmos ad=0.12665p pd=1.145u as=0.1428p ps=1.52u w=0.42u l=0.13u
X1251 X_uq222 a_75295_23717# VDD VDD sg13_lv_pmos ad=0.42p pd=2.99u as=0.2114p ps=1.54u w=1.12u l=0.13u
X1252 VSS a_41410_7625# X_uq47 VSS sg13_lv_nmos ad=0.14875p pd=1.16u as=0.2886p ps=2.26u w=0.74u l=0.13u
X1253 VSS a_52067_66687# a_52067_66687# VSS sg13_lv_nmos ad=1.8643p pd=11.96u as=0.111p ps=1.34u w=0.3u l=0.13u
X1254 a_37392_65860# a_37366_65824# VDD VDD sg13_lv_pmos ad=0.34p pd=2.68u as=0.36237p ps=2.605u w=1u l=0.13u
X1255 a_43162_63771# a_43277_63772# VDD VDD sg13_lv_pmos ad=0.34p pd=2.68u as=0.2254p ps=1.53u w=1u l=0.5u
X1256 X_uq194 a_9809_20111# VSS VSS sg13_lv_nmos ad=0.2886p pd=2.26u as=0.14875p ps=1.16u w=0.74u l=0.13u
X1257 Y_uq14 A_uq98 a_35202_9173# VDD sg13_lv_pmos ad=0.3808p pd=2.92u as=0.1176p ps=1.33u w=1.12u l=0.13u
X1258 a_7059_24970# a_6217_24872# a_5800_25211# VDD sg13_lv_pmos ad=0.2048p pd=1.63u as=0.34p ps=2.68u w=1u l=0.13u
X1259 VSS a_5809_43188# a_5809_43290# VSS sg13_lv_nmos ad=0.1406p pd=1.12u as=0.2516p ps=2.16u w=0.74u l=0.13u
X1260 a_37942_64312# a_38385_64355# a_37682_64782# VSS sg13_lv_nmos ad=79.8f pd=0.8u as=0.1296p ps=1.52u w=0.42u l=0.13u
X1261 a_52167_65485# a_51275_65364# a_52065_65252# VDD sg13_lv_pmos ad=63f pd=0.72u as=79.8f ps=0.8u w=0.42u l=0.13u
X1262 Y_uq139 X_uq273 VDD VDD sg13_lv_pmos ad=0.3808p pd=2.92u as=0.3808p ps=2.92u w=1.12u l=0.13u
X1263 a_30033_68891# clk VDD VDD sg13_lv_pmos ad=0.4088p pd=2.97u as=1.39265p ps=8.395u w=1.12u l=0.13u
X1264 a_35246_10067# A_uq98 VSS VSS sg13_lv_nmos ad=0.1045p pd=0.93u as=0.1469p ps=1.155u w=0.55u l=0.13u
X1265 X_uq264 a_75295_26741# VSS VSS sg13_lv_nmos ad=0.2886p pd=2.26u as=0.14875p ps=1.16u w=0.74u l=0.13u
X1266 Q_uq23 a_8833_43098# VSS VSS sg13_lv_nmos ad=0.2516p pd=2.16u as=0.1406p ps=1.12u w=0.74u l=0.13u
X1267 a_41750_63880# X_uq399 VDD VDD sg13_lv_pmos ad=0.1176p pd=1.33u as=0.4032p ps=2.96u w=1.12u l=0.13u
X1268 a_76939_20229# Y_uq47 a_76837_20229# VDD sg13_lv_pmos ad=0.2128p pd=1.5u as=0.2128p ps=1.5u w=1.12u l=0.13u
X1269 a_47655_64391# a_46763_64315# a_47553_64391# VDD sg13_lv_pmos ad=63f pd=0.72u as=79.8f ps=0.8u w=0.42u l=0.13u
X1270 a_40082_66294# D_uq48 VDD VDD sg13_lv_pmos ad=79.8f pd=0.8u as=0.1428p ps=1.52u w=0.42u l=0.13u
X1271 VSS a_6574_31914# a_6570_32837# VSS sg13_lv_nmos ad=5.69525p pd=37.455u as=0.2516p ps=2.16u w=0.74u l=0.13u
X1272 Y_uq92 B_uq49 VSS VSS sg13_lv_nmos ad=0.1406p pd=1.12u as=0.2516p ps=2.16u w=0.74u l=0.13u
X1273 VSS din[22] a_75295_20693# VSS sg13_lv_nmos ad=0.14875p pd=1.16u as=0.187p ps=1.78u w=0.55u l=0.13u
X1274 a_8116_31287# a_8086_31722# a_8498_31662# VDD sg13_lv_pmos ad=79.8f pd=0.8u as=63f ps=0.72u w=0.42u l=0.13u
X1275 Q_uq26 a_6559_43290# VDD VDD sg13_lv_pmos ad=0.3808p pd=2.92u as=0.2128p ps=1.5u w=1.12u l=0.13u
X1276 VSS X_uq379 C_uq46 VSS sg13_lv_nmos ad=0.2516p pd=2.16u as=0.1406p ps=1.12u w=0.74u l=0.13u
X1277 a_35157_65903# a_34800_65860# VDD VDD sg13_lv_pmos ad=63f pd=0.72u as=0.1563p ps=1.22u w=0.42u l=0.13u
X1278 VDD a_36454_69121# L_HI_uq38 VDD sg13_lv_pmos ad=1.42837p pd=8.61u as=0.3927p ps=2.99u w=1.155u l=0.13u
X1279 a_28280_69594# X_uq458 VSS VSS sg13_lv_nmos ad=0.187p pd=1.78u as=0.14875p ps=1.16u w=0.55u l=0.13u
X1280 VDD X_uq90 a_34500_9229# VDD sg13_lv_pmos ad=0.2618p pd=1.63u as=0.2856p ps=2.36u w=0.84u l=0.13u
X1281 Q_uq4 a_7726_25191# VDD VDD sg13_lv_pmos ad=0.3808p pd=2.92u as=0.2128p ps=1.5u w=1.12u l=0.13u
X1282 a_46323_67455# a_46475_67339# VDD VDD sg13_lv_pmos ad=0.3864p pd=2.93u as=1.19383p ps=7.16u w=1.12u l=0.13u
X1283 VDD VSS VDD VDD sg13_lv_pmos ad=0.34p pd=2.68u as=0 ps=0 w=1u l=1u
X1284 B2_uq9 X_uq266 VDD VDD sg13_lv_pmos ad=0.3808p pd=2.92u as=0.3808p ps=2.92u w=1.12u l=0.13u
X1285 a_6608_31785# a_6570_32837# a_6604_31479# VSS sg13_lv_nmos ad=0.2373p pd=1.97u as=79.8f ps=0.8u w=0.42u l=0.13u
X1286 VDD D_uq30 a_9609_34825# VDD sg13_lv_pmos ad=0.1596p pd=1.22u as=0.1596p ps=1.22u w=0.84u l=0.13u
X1287 a_39075_67368# Y_uq308 a_38961_67368# VDD sg13_lv_pmos ad=0.2128p pd=1.5u as=0.2464p ps=1.56u w=1.12u l=0.13u
X1288 VSS L_HI_uq14 a_40176_66294# VSS sg13_lv_nmos ad=0.1626p pd=1.415u as=60.89999f ps=0.71u w=0.42u l=0.13u
X1289 VDD a_28931_66687# a_28931_66921# VDD sg13_lv_pmos ad=1.19383p pd=7.16u as=0.2442p ps=2.06u w=0.66u l=0.13u
X1290 a_6893_40355# A0_uq0 a_6563_39963# VDD sg13_lv_pmos ad=0.3325p pd=1.665u as=0.2225p ps=1.445u w=1u l=0.13u
X1291 a_10345_31414# a_10345_31516# VSS VSS sg13_lv_nmos ad=0.2516p pd=2.16u as=0.1406p ps=1.12u w=0.74u l=0.13u
X1292 a_78077_22959# a_77807_22959# VDD VDD sg13_lv_pmos ad=0.34p pd=2.68u as=0.1523p ps=1.38u w=1u l=0.5u
X1293 a_39888_67793# a_39600_67372# a_39826_67793# VSS sg13_lv_nmos ad=0.1428p pd=1.52u as=37.8f ps=0.6u w=0.42u l=0.13u
X1294 VDD a_78179_25943# X_uq251 VDD sg13_lv_pmos ad=0.2114p pd=1.54u as=0.42p ps=2.99u w=1.12u l=0.13u
X1295 a_78455_22492# a_78574_22169# VSS VSS sg13_lv_nmos ad=0.2516p pd=2.16u as=0.1406p ps=1.12u w=0.74u l=0.13u
X1296 Y_uq1 a_42948_8453# VSS VSS sg13_lv_nmos ad=0.1406p pd=1.12u as=0.17255p ps=1.25u w=0.74u l=0.13u
X1297 a_35038_68118# L_HI_uq30 VSS VSS sg13_lv_nmos ad=37.8f pd=0.6u as=79.8f ps=0.8u w=0.42u l=0.13u
X1298 C_uq21 C_uq16 a_10689_17845# VSS sg13_lv_nmos ad=0.2516p pd=2.16u as=0.1406p ps=1.12u w=0.74u l=0.13u
X1299 a_5813_41167# a_5811_42044# a_5892_41738# VSS sg13_lv_nmos ad=79.8f pd=0.8u as=0.1296p ps=1.52u w=0.42u l=0.13u
X1300 VSS reset a_3535_34367# VSS sg13_lv_nmos ad=0.14875p pd=1.16u as=0.187p ps=1.78u w=0.55u l=0.13u
X1301 Y_uq322 C_uq59 VSS VSS sg13_lv_nmos ad=0.2618p pd=2.22u as=0.1463p ps=1.15u w=0.77u l=0.13u
X1302 VDD a_7059_21480# a_7726_21119# VDD sg13_lv_pmos ad=0.2128p pd=1.5u as=0.3864p ps=2.93u w=1.12u l=0.13u
X1303 a_38385_64355# clk VDD VDD sg13_lv_pmos ad=0.4088p pd=2.97u as=1.4357p ps=8.83u w=1.12u l=0.13u
X1304 C_uq72 X_uq438 a_27542_68880# VDD sg13_lv_pmos ad=0.3808p pd=2.92u as=0.1176p ps=1.33u w=1.12u l=0.13u
X1305 a_76651_26277# B2_uq8 a_76549_26277# VDD sg13_lv_pmos ad=0.2128p pd=1.5u as=0.2128p ps=1.5u w=1.12u l=0.13u
X1306 X_uq411 a_27316_66644# VSS VSS sg13_lv_nmos ad=0.2886p pd=2.26u as=0.14875p ps=1.16u w=0.74u l=0.13u
X1307 VDD X_uq319 Y_uq194 VDD sg13_lv_pmos ad=0.3808p pd=2.92u as=0.3808p ps=2.92u w=1.12u l=0.13u
X1308 A_uq97 a_32382_9961# VSS VSS sg13_lv_nmos ad=0.2886p pd=2.26u as=0.14875p ps=1.16u w=0.74u l=0.13u
X1309 a_33634_8375# SLN[1] VSS VSS sg13_lv_nmos ad=0.187p pd=1.78u as=0.14875p ps=1.16u w=0.55u l=0.13u
X1310 VDD X_uq399 a_44602_63624# VDD sg13_lv_pmos ad=0.2618p pd=1.63u as=0.2856p ps=2.36u w=0.84u l=0.13u
X1311 a_7715_40155# Q_uq25 X_uq314 VSS sg13_lv_nmos ad=88.8f pd=0.98u as=0.1628p ps=1.18u w=0.74u l=0.13u
X1312 VSS Y_uq186 a_10819_34857# VSS sg13_lv_nmos ad=0.1626p pd=1.415u as=60.89999f ps=0.71u w=0.42u l=0.13u
X1313 VSS Y_uq68 a_12209_20111# VSS sg13_lv_nmos ad=0.14875p pd=1.16u as=0.187p ps=1.78u w=0.55u l=0.13u
X1314 VSS X_uq168 a_33734_10301# VSS sg13_lv_nmos ad=0.1469p pd=1.155u as=0.1045p ps=0.93u w=0.55u l=0.13u
X1315 a_40984_64344# a_40762_64400# VDD VDD sg13_lv_pmos ad=0.1176p pd=1.33u as=0.2618p ps=1.63u w=1.12u l=0.13u
X1316 a_38074_69147# a_38189_69146# VDD VDD sg13_lv_pmos ad=0.34p pd=2.68u as=0.2254p ps=1.53u w=1u l=0.5u
X1317 a_39227_64705# a_38385_64355# a_37968_64348# VDD sg13_lv_pmos ad=0.2048p pd=1.63u as=0.34p ps=2.68u w=1u l=0.13u
X1318 a_34690_7625# A_uq8 VDD VDD sg13_lv_pmos ad=0.2856p pd=2.36u as=0.2114p ps=1.54u w=0.84u l=0.13u
X1319 VDD a_5523_21946# a_6190_22167# VDD sg13_lv_pmos ad=0.2128p pd=1.5u as=0.3864p ps=2.93u w=1.12u l=0.13u
X1320 VDD a_36166_65062# a_35885_65284# VDD sg13_lv_pmos ad=0.1523p pd=1.38u as=0.34p ps=2.68u w=1u l=0.5u
X1321 VDD Y_uq236 a_6604_41175# VDD sg13_lv_pmos ad=0.1563p pd=1.22u as=0.147p ps=1.54u w=0.42u l=0.13u
X1322 VDD Q_uq47 a_27988_63620# VDD sg13_lv_pmos ad=0.2114p pd=1.54u as=0.2856p ps=2.36u w=0.84u l=0.13u
X1323 X_uq159 a_35070_10685# VDD VDD sg13_lv_pmos ad=0.42p pd=2.99u as=0.2114p ps=1.54u w=1.12u l=0.13u
X1324 a_9619_31795# a_9598_32468# a_9583_31324# VSS sg13_lv_nmos ad=0.1428p pd=1.52u as=0.12665p ps=1.145u w=0.42u l=0.13u
X1325 VSS q[13] a_35838_10685# VSS sg13_lv_nmos ad=0.14875p pd=1.16u as=0.187p ps=1.78u w=0.55u l=0.13u
X1326 a_76357_24765# B1_uq6 a_76459_24765# VDD sg13_lv_pmos ad=0.3808p pd=2.92u as=0.2128p ps=1.5u w=1.12u l=0.13u
X1327 VDD a_78455_28540# Q_uq8 VDD sg13_lv_pmos ad=0.2128p pd=1.5u as=0.3808p ps=2.92u w=1.12u l=0.13u
X1328 VDD Q_uq40 Y_uq351 VDD sg13_lv_pmos ad=0.3808p pd=2.92u as=0.3808p ps=2.92u w=1.12u l=0.13u
X1329 a_7727_38815# B_uq85 VSS VSS sg13_lv_nmos ad=0.1406p pd=1.12u as=0.2516p ps=2.16u w=0.74u l=0.13u
X1330 VSS B_uq18 a_42446_10067# VSS sg13_lv_nmos ad=0.187p pd=1.78u as=0.1045p ps=0.93u w=0.55u l=0.13u
X1331 A_uq38 a_44500_66644# VDD VDD sg13_lv_pmos ad=0.42p pd=2.99u as=0.2114p ps=1.54u w=1.12u l=0.13u
X1332 VSS C_uq65 Y_uq360 VSS sg13_lv_nmos ad=0.1463p pd=1.15u as=0.2618p ps=2.22u w=0.77u l=0.13u
X1333 a_40725_65903# a_40368_65860# VDD VDD sg13_lv_pmos ad=63f pd=0.72u as=0.1563p ps=1.22u w=0.42u l=0.13u
X1334 a_79701_23207# a_79502_23270# VSS VSS sg13_lv_nmos ad=0.27427p pd=2.28u as=2.83008p ps=17.885u w=0.795u l=0.13u
X1335 VSS C_uq22 Y_uq129 VSS sg13_lv_nmos ad=0.1406p pd=1.12u as=0.1406p ps=1.12u w=0.74u l=0.13u
X1336 a_9247_39835# C_uq37 VSS VSS sg13_lv_nmos ad=0.1406p pd=1.12u as=0.1406p ps=1.12u w=0.74u l=0.15u
X1337 X_uq216 a_11537_23135# VDD VDD sg13_lv_pmos ad=0.42p pd=2.99u as=0.2114p ps=1.54u w=1.12u l=0.13u
X1338 a_80593_23681# Q_uq2 VSS VSS sg13_lv_nmos ad=0.1428p pd=1.52u as=79.8f ps=0.8u w=0.42u l=0.13u
X1339 VSS A_uq87 a_39014_10301# VSS sg13_lv_nmos ad=0.1469p pd=1.155u as=0.1045p ps=0.93u w=0.55u l=0.13u
X1340 a_41877_70021# a_41520_69948# VDD VDD sg13_lv_pmos ad=63f pd=0.72u as=0.1563p ps=1.22u w=0.42u l=0.13u
X1341 VSS B_uq96 a_4703_39700# VSS sg13_lv_nmos ad=0.14505p pd=1.15u as=0.1406p ps=1.12u w=0.74u l=0.13u
X1342 VSS q[4] a_34302_8449# VSS sg13_lv_nmos ad=0.14875p pd=1.16u as=0.187p ps=1.78u w=0.55u l=0.13u
X1343 VSS C_uq16 Y_uq34 VSS sg13_lv_nmos ad=0.2618p pd=2.22u as=0.1694p ps=1.21u w=0.77u l=0.13u
X1344 VDD A_uq30 a_37374_8449# VDD sg13_lv_pmos ad=0.2114p pd=1.54u as=0.2856p ps=2.36u w=0.84u l=0.13u
X1345 Y_uq105 X_uq262 VSS VSS sg13_lv_nmos ad=0.2516p pd=2.16u as=0.2516p ps=2.16u w=0.74u l=0.13u
X1346 VDD a_36610_7625# X_uq66 VDD sg13_lv_pmos ad=0.2114p pd=1.54u as=0.42p ps=2.99u w=1.12u l=0.13u
X1347 VDD S Y_uq207 VDD sg13_lv_pmos ad=0.3808p pd=2.92u as=0.3808p ps=2.92u w=1.12u l=0.13u
X1348 Q_uq50 a_49686_69928# VSS VSS sg13_lv_nmos ad=0.2516p pd=2.16u as=0.1406p ps=1.12u w=0.74u l=0.13u
X1349 a_5051_43135# Q_uq28 VDD VDD sg13_lv_pmos ad=0.1428p pd=1.52u as=0.1523p ps=1.38u w=0.42u l=0.13u
X1350 VSS X_uq445 D_uq60 VSS sg13_lv_nmos ad=0.2618p pd=2.22u as=0.1694p ps=1.21u w=0.77u l=0.13u
X1351 VSS Y_uq219 Y_uq176 VSS sg13_lv_nmos ad=0.2516p pd=2.16u as=0.1406p ps=1.12u w=0.74u l=0.13u
X1352 VSS X_uq455 a_28378_67424# VSS sg13_lv_nmos ad=0.17255p pd=1.25u as=0.187p ps=1.78u w=0.55u l=0.13u
X1353 X_uq452 a_40084_69668# VSS VSS sg13_lv_nmos ad=0.2886p pd=2.26u as=0.14875p ps=1.16u w=0.74u l=0.13u
X1354 VSS X_uq168 Y_uq15 VSS sg13_lv_nmos ad=0.2516p pd=2.16u as=0.1406p ps=1.12u w=0.74u l=0.13u
X1355 a_43522_9137# A_uq44 VSS VSS sg13_lv_nmos ad=0.187p pd=1.78u as=0.14875p ps=1.16u w=0.55u l=0.13u
X1356 VSS Y_uq357 a_44500_66644# VSS sg13_lv_nmos ad=0.14875p pd=1.16u as=0.187p ps=1.78u w=0.55u l=0.13u
X1357 Y_uq192 Q_uq17 VDD VDD sg13_lv_pmos ad=0.3808p pd=2.92u as=0.3808p ps=2.92u w=1.12u l=0.13u
X1358 VSS Y_uq24 a_36702_6937# VSS sg13_lv_nmos ad=0.14875p pd=1.16u as=0.187p ps=1.78u w=0.55u l=0.13u
X1359 a_42960_67372# a_43479_67379# a_44219_67729# VSS sg13_lv_nmos ad=0.3473p pd=2.71u as=0.12665p ps=1.145u w=0.74u l=0.13u
X1360 VSS a_5234_22898# B_uq50 VSS sg13_lv_nmos ad=0.1426p pd=1.16u as=0.2516p ps=2.16u w=0.74u l=0.13u
X1361 a_46808_63546# Q_uq36 VDD VDD sg13_lv_pmos ad=0.2856p pd=2.36u as=0.2114p ps=1.54u w=0.84u l=0.13u
X1362 Q_uq41 a_51702_68416# VSS VSS sg13_lv_nmos ad=0.2516p pd=2.16u as=0.1406p ps=1.12u w=0.74u l=0.13u
X1363 a_10751_40159# D_uq30 VSS VSS sg13_lv_nmos ad=0.1406p pd=1.12u as=0.2516p ps=2.16u w=0.74u l=0.13u
X1364 VDD D_uq25 Y_uq178 VDD sg13_lv_pmos ad=0.3808p pd=2.92u as=0.2128p ps=1.5u w=1.12u l=0.13u
X1365 VDD Y_uq234 a_8107_40811# VDD sg13_lv_pmos ad=0.36237p pd=2.605u as=79.8f ps=0.8u w=0.42u l=0.13u
X1366 X_uq236 a_8561_20899# VDD VDD sg13_lv_pmos ad=0.42p pd=2.99u as=0.2114p ps=1.54u w=1.12u l=0.13u
X1367 VDD VSS VDD VDD sg13_lv_pmos ad=0.19p pd=1.38u as=0 ps=0 w=1u l=1u
X1368 a_34514_66294# D_uq45 VDD VDD sg13_lv_pmos ad=79.8f pd=0.8u as=0.1428p ps=1.52u w=0.42u l=0.13u
X1369 a_79340_25229# A1_uq9 VDD VDD sg13_lv_pmos ad=0.2128p pd=1.5u as=0.2128p ps=1.5u w=1.12u l=0.13u
X1370 VDD X_uq352 a_35454_10685# VDD sg13_lv_pmos ad=0.2114p pd=1.54u as=0.2856p ps=2.36u w=0.84u l=0.13u
X1371 a_34646_63880# Q_uq47 Y_uq277 VDD sg13_lv_pmos ad=0.1176p pd=1.33u as=0.3808p ps=2.92u w=1.12u l=0.13u
X1372 VSS Y_uq252 Y_uq266 VSS sg13_lv_nmos ad=0.1463p pd=1.15u as=0.1694p ps=1.21u w=0.77u l=0.13u
X1373 VSS L_HI_uq15 a_34608_66294# VSS sg13_lv_nmos ad=0.1626p pd=1.415u as=60.89999f ps=0.71u w=0.42u l=0.13u
X1374 a_8071_32685# a_8082_32645# a_8071_33019# VSS sg13_lv_nmos ad=0.3473p pd=2.71u as=0.12665p ps=1.145u w=0.74u l=0.13u
X1375 A_uq24 a_36436_63620# VDD VDD sg13_lv_pmos ad=0.42p pd=2.99u as=0.2114p ps=1.54u w=1.12u l=0.13u
X1376 VSS Y_uq103 a_80575_25229# VSS sg13_lv_nmos ad=0.14875p pd=1.16u as=0.187p ps=1.78u w=0.55u l=0.13u
X1377 a_43259_64705# a_42417_64355# a_42000_64348# VDD sg13_lv_pmos ad=0.2048p pd=1.63u as=0.34p ps=2.68u w=1u l=0.13u
X1378 a_50936_63546# Q_uq42 VDD VDD sg13_lv_pmos ad=0.2856p pd=2.36u as=0.2114p ps=1.54u w=0.84u l=0.13u
X1379 C_uq67 X_uq437 a_27638_67368# VDD sg13_lv_pmos ad=0.3808p pd=2.92u as=0.1176p ps=1.33u w=1.12u l=0.13u
X1380 a_7357_36704# Y_uq190 Y_uq188 VDD sg13_lv_pmos ad=0.2128p pd=1.5u as=0.3808p ps=2.92u w=1.12u l=0.13u
X1381 L_HI_uq0 a_80085_21695# VDD VDD sg13_lv_pmos ad=0.3927p pd=2.99u as=1.59725p ps=10.05u w=1.155u l=0.13u
X1382 C_uq2 a_75295_19969# VDD VDD sg13_lv_pmos ad=0.42p pd=2.99u as=0.2114p ps=1.54u w=1.12u l=0.13u
X1383 VDD Q_uq25 A0_uq0 VDD sg13_lv_pmos ad=0.2198p pd=1.53u as=0.2128p ps=1.5u w=1.12u l=0.13u
X1384 Y_uq146 X_uq275 VSS VSS sg13_lv_nmos ad=0.2516p pd=2.16u as=0.2516p ps=2.16u w=0.74u l=0.13u
X1385 a_45856_10221# X_uq137 Y_uq17 VDD sg13_lv_pmos ad=0.1176p pd=1.33u as=0.3808p ps=2.92u w=1.12u l=0.13u
X1386 a_6283_41001# D_uq32 a_5892_41738# VSS sg13_lv_nmos ad=60.89999f pd=0.71u as=0.1428p ps=1.52u w=0.42u l=0.13u
X1387 VSS X_uq145 a_42078_8449# VSS sg13_lv_nmos ad=0.14875p pd=1.16u as=0.187p ps=1.78u w=0.55u l=0.13u
X1388 VDD q[29] a_45150_8449# VDD sg13_lv_pmos ad=0.2114p pd=1.54u as=0.2856p ps=2.36u w=0.84u l=0.13u
X1389 a_29136_69643# a_28848_69948# a_29074_69643# VSS sg13_lv_nmos ad=0.1428p pd=1.52u as=37.8f ps=0.6u w=0.42u l=0.13u
X1390 a_6563_40069# S VDD VDD sg13_lv_pmos ad=0.2856p pd=2.36u as=0.253p ps=1.53u w=0.84u l=0.13u
X1391 a_10729_39672# D_uq30 VSS VSS sg13_lv_nmos ad=0.1406p pd=1.12u as=0.2516p ps=2.16u w=0.74u l=0.13u
X1392 C_uq70 X_uq433 VSS VSS sg13_lv_nmos ad=0.1406p pd=1.12u as=0.2516p ps=2.16u w=0.74u l=0.13u
X1393 a_77323_19529# Y_uq42 VSS VSS sg13_lv_nmos ad=0.1406p pd=1.12u as=0.1406p ps=1.12u w=0.74u l=0.13u
X1394 a_33552_66619# a_33264_66924# a_33490_66619# VSS sg13_lv_nmos ad=0.1428p pd=1.52u as=37.8f ps=0.6u w=0.42u l=0.13u
X1395 a_5774_25116# a_6217_24872# a_5514_24893# VSS sg13_lv_nmos ad=79.8f pd=0.8u as=0.1296p ps=1.52u w=0.42u l=0.13u
X1396 a_6139_20655# Y_uq66 a_6025_20655# VDD sg13_lv_pmos ad=0.2128p pd=1.5u as=0.2464p ps=1.56u w=1.12u l=0.13u
X1397 VDD a_36945_67379# a_37047_67379# VDD sg13_lv_pmos ad=1.19383p pd=7.16u as=0.3864p ps=2.93u w=1.12u l=0.13u
X1398 VSS Y_uq11 a_39390_6937# VSS sg13_lv_nmos ad=0.14875p pd=1.16u as=0.187p ps=1.78u w=0.55u l=0.13u
X1399 X_uq219 a_9713_23135# VDD VDD sg13_lv_pmos ad=0.42p pd=2.99u as=0.2114p ps=1.54u w=1.12u l=0.13u
X1400 C_uq29 a_79026_27533# a_79228_27495# VSS sg13_lv_nmos ad=0.333p pd=2.38u as=0.1406p ps=1.12u w=0.74u l=0.13u
X1401 a_40859_67729# a_40017_67379# a_40765_67729# VSS sg13_lv_nmos ad=0.12665p pd=1.145u as=0.1428p ps=1.52u w=0.42u l=0.13u
X1402 a_44784_69305# a_45015_68891# a_44470_68848# VSS sg13_lv_nmos ad=0.2373p pd=1.97u as=79.8f ps=0.8u w=0.42u l=0.13u
X1403 X_uq19 a_39006_6937# VSS VSS sg13_lv_nmos ad=0.2886p pd=2.26u as=0.14875p ps=1.16u w=0.74u l=0.13u
X1404 a_34917_64467# a_33975_64355# a_34715_64705# VDD sg13_lv_pmos ad=93.45f pd=0.865u as=0.2048p ps=1.63u w=0.42u l=0.13u
X1405 Y_uq257 C_uq42 VSS VSS sg13_lv_nmos ad=0.2618p pd=2.22u as=0.1463p ps=1.15u w=0.77u l=0.13u
X1406 D_uq51 a_46530_66674# VDD VDD sg13_lv_pmos ad=0.4256p pd=3u as=0.2254p ps=1.53u w=1.12u l=0.13u
X1407 Q_uq2 a_80577_24765# VDD VDD sg13_lv_pmos ad=0.3808p pd=2.92u as=0.2128p ps=1.5u w=1.12u l=0.13u
X1408 a_44470_68848# a_44913_68891# a_44853_68927# VDD sg13_lv_pmos ad=79.8f pd=0.8u as=63f ps=0.72u w=0.42u l=0.13u
X1409 a_80178_22252# a_79286_22176# a_80076_22252# VDD sg13_lv_pmos ad=63f pd=0.72u as=79.8f ps=0.8u w=0.42u l=0.13u
X1410 VDD a_44074_8379# a_44032_8709# VDD sg13_lv_pmos ad=0.2618p pd=1.63u as=0.1176p ps=1.33u w=1.12u l=0.13u
X1411 VDD L_HI_uq7 a_78625_26709# VDD sg13_lv_pmos ad=0.1563p pd=1.22u as=0.147p ps=1.54u w=0.42u l=0.13u
X1412 VSS a_78455_28540# Q_uq8 VSS sg13_lv_nmos ad=0.1406p pd=1.12u as=0.2516p ps=2.16u w=0.74u l=0.13u
X1413 a_48250_67635# a_48365_67634# VSS VSS sg13_lv_nmos ad=0.1428p pd=1.52u as=0.1426p ps=1.16u w=0.42u l=0.5u
X1414 VSS C_uq20 Y_uq70 VSS sg13_lv_nmos ad=0.1463p pd=1.15u as=0.1694p ps=1.21u w=0.77u l=0.13u
X1415 Y_uq288 Q_uq50 VDD VDD sg13_lv_pmos ad=0.3808p pd=2.92u as=0.3808p ps=2.92u w=1.12u l=0.13u
X1416 C_uq69 X_uq451 a_42806_68880# VDD sg13_lv_pmos ad=0.3808p pd=2.92u as=0.1176p ps=1.33u w=1.12u l=0.13u
X1417 Y_uq37 C_uq0 VSS VSS sg13_lv_nmos ad=0.2618p pd=2.22u as=0.1463p ps=1.15u w=0.77u l=0.13u
X1418 a_35088_66281# a_34800_65860# a_35026_66281# VSS sg13_lv_nmos ad=0.1428p pd=1.52u as=37.8f ps=0.6u w=0.42u l=0.13u
X1419 D_uq7 C VDD VDD sg13_lv_pmos ad=0.2128p pd=1.5u as=0.2198p ps=1.53u w=1.12u l=0.13u
X1420 VDD VSS VDD VDD sg13_lv_pmos ad=0.34p pd=2.68u as=0 ps=0 w=1u l=1u
X1421 X_uq98 a_44294_10301# VSS VSS sg13_lv_nmos ad=0.2516p pd=2.16u as=0.1469p ps=1.155u w=0.74u l=0.13u
X1422 VDD a_49276_69850# a_49221_69945# VDD sg13_lv_pmos ad=1.6733p pd=10.405u as=93.45f ps=0.865u w=0.42u l=0.13u
X1423 a_39957_67415# a_39600_67372# VDD VDD sg13_lv_pmos ad=63f pd=0.72u as=0.1563p ps=1.22u w=0.42u l=0.13u
X1424 VSS Q_uq55 Y_uq309 VSS sg13_lv_nmos ad=0.2516p pd=2.16u as=0.2516p ps=2.16u w=0.74u l=0.13u
X1425 VSS a_8956_42551# a_9230_42166# VSS sg13_lv_nmos ad=79.8f pd=0.8u as=0.1428p ps=1.52u w=0.42u l=0.13u
X1426 VSS L_HI_uq38 a_36048_69630# VSS sg13_lv_nmos ad=0.1626p pd=1.415u as=60.89999f ps=0.71u w=0.42u l=0.13u
X1427 VSS Y_uq249 Y_uq263 VSS sg13_lv_nmos ad=0.1463p pd=1.15u as=0.1694p ps=1.21u w=0.77u l=0.13u
X1428 a_40740_8789# B_uq21 a_40646_8789# VDD sg13_lv_pmos ad=0.1596p pd=1.22u as=0.2856p ps=2.36u w=0.84u l=0.13u
X1429 X_uq216 a_11537_23135# VSS VSS sg13_lv_nmos ad=0.2886p pd=2.26u as=0.14875p ps=1.16u w=0.74u l=0.13u
X1430 VDD X_uq267 Y_uq148 VDD sg13_lv_pmos ad=0.3808p pd=2.92u as=0.3808p ps=2.92u w=1.12u l=0.13u
X1431 B_uq66 a_3788_24931# VDD VDD sg13_lv_pmos ad=0.42p pd=2.99u as=0.2114p ps=1.54u w=1.12u l=0.13u
X1432 X_uq256 a_7340_25655# VSS VSS sg13_lv_nmos ad=0.2886p pd=2.26u as=0.14875p ps=1.16u w=0.74u l=0.13u
X1433 X_uq343 a_40468_63620# VDD VDD sg13_lv_pmos ad=0.42p pd=2.99u as=0.2114p ps=1.54u w=1.12u l=0.13u
X1434 VDD Y_uq36 a_8849_18599# VDD sg13_lv_pmos ad=0.2114p pd=1.54u as=0.2856p ps=2.36u w=0.84u l=0.13u
X1435 a_10009_25775# B_uq63 VSS VSS sg13_lv_nmos ad=0.1045p pd=0.93u as=0.187p ps=1.78u w=0.55u l=0.13u
X1436 a_42946_6863# Y_uq10 VSS VSS sg13_lv_nmos ad=0.187p pd=1.78u as=0.14875p ps=1.16u w=0.55u l=0.13u
X1437 VDD X_uq432 a_37972_68156# VDD sg13_lv_pmos ad=0.2114p pd=1.54u as=0.2856p ps=2.36u w=0.84u l=0.13u
X1438 a_46485_65903# a_46128_65860# VDD VDD sg13_lv_pmos ad=63f pd=0.72u as=0.1563p ps=1.22u w=0.42u l=0.13u
X1439 a_42226_64769# L_HI_uq10 VSS VSS sg13_lv_nmos ad=37.8f pd=0.6u as=0.1701p ps=1.65u w=0.42u l=0.13u
X1440 a_10385_33469# a_10347_32660# a_10345_31516# VDD sg13_lv_pmos ad=0.34p pd=2.68u as=0.2048p ps=1.63u w=1u l=0.13u
X1441 VDD B_uq87 Y_uq196 VDD sg13_lv_pmos ad=0.2198p pd=1.53u as=0.2128p ps=1.5u w=1.12u l=0.13u
X1442 a_10504_36510# a_10383_35831# a_10345_37044# VDD sg13_lv_pmos ad=93.45f pd=0.865u as=0.2048p ps=1.63u w=0.42u l=0.13u
X1443 a_36816_67793# a_36528_67372# a_36754_67793# VSS sg13_lv_nmos ad=0.1428p pd=1.52u as=37.8f ps=0.6u w=0.42u l=0.13u
X1444 a_79045_21131# a_79286_20664# a_78574_20657# VSS sg13_lv_nmos ad=0.1428p pd=1.52u as=0.12665p ps=1.145u w=0.42u l=0.13u
X1445 D_uq52 C_uq64 a_42435_67368# VDD sg13_lv_pmos ad=0.3808p pd=2.92u as=0.2128p ps=1.5u w=1.12u l=0.13u
X1446 X_uq218 a_10097_23135# VDD VDD sg13_lv_pmos ad=0.42p pd=2.99u as=0.2114p ps=1.54u w=1.12u l=0.13u
X1447 VSS L_HI_uq39 a_32400_69630# VSS sg13_lv_nmos ad=0.1626p pd=1.415u as=60.89999f ps=0.71u w=0.42u l=0.13u
X1448 VSS A_uq91 a_33246_6937# VSS sg13_lv_nmos ad=0.14875p pd=1.16u as=0.187p ps=1.78u w=0.55u l=0.13u
X1449 a_31478_64344# X_uq458 VDD VDD sg13_lv_pmos ad=0.1176p pd=1.33u as=0.4032p ps=2.96u w=1.12u l=0.13u
X1450 a_6026_24906# L_HI_uq5 VSS VSS sg13_lv_nmos ad=37.8f pd=0.6u as=0.1701p ps=1.65u w=0.42u l=0.13u
X1451 a_47171_67415# a_46475_67339# a_47265_67415# VSS sg13_lv_nmos ad=0.1296p pd=1.52u as=79.8f ps=0.8u w=0.42u l=0.13u
X1452 a_41794_6863# A_uq76 VSS VSS sg13_lv_nmos ad=0.187p pd=1.78u as=0.14875p ps=1.16u w=0.55u l=0.13u
X1453 Y_uq86 B1 a_76747_22981# VSS sg13_lv_nmos ad=0.2516p pd=2.16u as=0.1406p ps=1.12u w=0.74u l=0.13u
X1454 VDD a_8071_42647# a_8422_42558# VDD sg13_lv_pmos ad=1.5243p pd=9.795u as=93.45f ps=0.865u w=0.42u l=0.13u
X1455 VDD a_49664_64308# a_49622_64344# VDD sg13_lv_pmos ad=0.2618p pd=1.63u as=0.1176p ps=1.33u w=1.12u l=0.13u
X1456 X_uq35 a_32862_6937# VSS VSS sg13_lv_nmos ad=0.2886p pd=2.26u as=0.14875p ps=1.16u w=0.74u l=0.13u
X1457 VDD B_N a_43428_8453# VDD sg13_lv_pmos ad=0.2618p pd=1.63u as=0.2856p ps=2.36u w=0.84u l=0.13u
X1458 X_uq24 a_37086_6937# VDD VDD sg13_lv_pmos ad=0.42p pd=2.99u as=0.2114p ps=1.54u w=1.12u l=0.13u
X1459 VDD L_HI_uq19 a_43318_65824# VDD sg13_lv_pmos ad=0.1563p pd=1.22u as=0.147p ps=1.54u w=0.42u l=0.13u
X1460 VSS X_uq425 C_uq68 VSS sg13_lv_nmos ad=0.2516p pd=2.16u as=0.1406p ps=1.12u w=0.74u l=0.13u
X1461 a_9583_39117# a_9628_37719# VDD VDD sg13_lv_pmos ad=0.34p pd=2.68u as=0.36237p ps=2.605u w=1u l=0.13u
X1462 VDD a_39484_64586# a_39429_64467# VDD sg13_lv_pmos ad=1.4745p pd=9.07u as=93.45f ps=0.865u w=0.42u l=0.13u
X1463 a_35313_67405# a_35313_67405# VSS VSS sg13_lv_nmos ad=0.111p pd=1.34u as=2.08687p ps=13.23u w=0.3u l=0.13u
X1464 a_46611_64431# a_46763_64315# VSS VSS sg13_lv_nmos ad=0.2516p pd=2.16u as=4.5737p ps=28.36u w=0.74u l=0.13u
X1465 a_44824_63880# a_44602_63624# VDD VDD sg13_lv_pmos ad=0.1176p pd=1.33u as=0.2618p ps=1.63u w=1.12u l=0.13u
X1466 C_uq34 B_uq79 VSS VSS sg13_lv_nmos ad=0.1406p pd=1.12u as=0.2516p ps=2.16u w=0.74u l=0.13u
X1467 VSS X_uq407 C_uq53 VSS sg13_lv_nmos ad=0.2516p pd=2.16u as=0.1406p ps=1.12u w=0.74u l=0.13u
X1468 VDD B_uq93 B_uq92 VDD sg13_lv_pmos ad=0.2198p pd=1.53u as=0.2128p ps=1.5u w=1.12u l=0.13u
X1469 a_5833_39781# S_uq0 VDD VDD sg13_lv_pmos ad=0.2856p pd=2.36u as=0.253p ps=1.53u w=0.84u l=0.13u
X1470 VDD VSS VDD VDD sg13_lv_pmos ad=0.34p pd=2.68u as=0 ps=0 w=1u l=1u
X1471 VSS B_uq4 a_37454_9489# VSS sg13_lv_nmos ad=0.187p pd=1.78u as=0.1045p ps=0.93u w=0.55u l=0.13u
X1472 C_uq32 B_uq78 a_6893_34031# VDD sg13_lv_pmos ad=0.3808p pd=2.92u as=0.1176p ps=1.33u w=1.12u l=0.13u
X1473 VDD Y_uq210 a_9619_37451# VDD sg13_lv_pmos ad=0.36237p pd=2.605u as=79.8f ps=0.8u w=0.42u l=0.13u
X1474 a_39978_65346# a_39779_65409# VSS VSS sg13_lv_nmos ad=0.27427p pd=2.28u as=4.5737p ps=28.36u w=0.795u l=0.13u
X1475 VSS SLN[6] a_32766_10685# VSS sg13_lv_nmos ad=0.14875p pd=1.16u as=0.187p ps=1.78u w=0.55u l=0.13u
X1476 a_77221_19181# B1_uq7 a_77323_19181# VDD sg13_lv_pmos ad=0.3808p pd=2.92u as=0.2128p ps=1.5u w=1.12u l=0.13u
X1477 a_11628_24647# B_uq55 a_11526_24647# VDD sg13_lv_pmos ad=0.2464p pd=1.56u as=0.2128p ps=1.5u w=1.12u l=0.13u
X1478 VSS a_30202_68307# X_uq437 VSS sg13_lv_nmos ad=0.1426p pd=1.16u as=0.2516p ps=2.16u w=0.74u l=0.13u
X1479 D_uq32 C_uq39 a_9247_39835# VSS sg13_lv_nmos ad=0.2516p pd=2.16u as=0.1406p ps=1.12u w=0.74u l=0.15u
X1480 a_33074_68118# D_uq56 VDD VDD sg13_lv_pmos ad=79.8f pd=0.8u as=0.1428p ps=1.52u w=0.42u l=0.13u
X1481 VSS a_7346_22898# B_uq49 VSS sg13_lv_nmos ad=0.1426p pd=1.16u as=0.2516p ps=2.16u w=0.74u l=0.13u
X1482 VSS a_42010_65283# X_uq375 VSS sg13_lv_nmos ad=0.1426p pd=1.16u as=0.2516p ps=2.16u w=0.74u l=0.13u
X1483 C_uq15 a_9671_18965# a_9997_18965# VSS sg13_lv_nmos ad=0.3404p pd=2.4u as=0.1406p ps=1.12u w=0.74u l=0.13u
X1484 a_30369_64391# L_HI_uq21 VDD VDD sg13_lv_pmos ad=0.147p pd=1.54u as=0.1563p ps=1.22u w=0.42u l=0.13u
X1485 VSS a_49318_68844# a_49037_69146# VSS sg13_lv_nmos ad=79.8f pd=0.8u as=0.1428p ps=1.52u w=0.42u l=0.5u
X1486 VSS A_uq88 a_38534_10301# VSS sg13_lv_nmos ad=0.1469p pd=1.155u as=0.1045p ps=0.93u w=0.55u l=0.13u
X1487 a_38986_9137# X_uq81 VDD VDD sg13_lv_pmos ad=0.2856p pd=2.36u as=0.2618p ps=1.63u w=0.84u l=0.13u
X1488 a_6088_21544# a_6319_21130# a_5774_21087# VSS sg13_lv_nmos ad=0.2373p pd=1.97u as=79.8f ps=0.8u w=0.42u l=0.13u
X1489 VDD a_31996_65314# a_31941_65409# VDD sg13_lv_pmos ad=1.41367p pd=8.85u as=93.45f ps=0.865u w=0.42u l=0.13u
X1490 X_uq247 a_9617_25435# VSS VSS sg13_lv_nmos ad=0.2886p pd=2.26u as=0.14875p ps=1.16u w=0.74u l=0.13u
X1491 VDD a_44554_9137# a_44512_9173# VDD sg13_lv_pmos ad=0.2618p pd=1.63u as=0.1176p ps=1.33u w=1.12u l=0.13u
X1492 VDD L_HI a_78787_22643# VDD sg13_lv_pmos ad=1.59725p pd=10.05u as=79.8f ps=0.8u w=0.42u l=0.13u
X1493 a_39490_7625# Y_uq12 VDD VDD sg13_lv_pmos ad=0.2856p pd=2.36u as=0.2114p ps=1.54u w=0.84u l=0.13u
X1494 X_uq219 a_9713_23135# VSS VSS sg13_lv_nmos ad=0.2886p pd=2.26u as=0.14875p ps=1.16u w=0.74u l=0.13u
X1495 a_40184_63546# Q_uq37 VDD VDD sg13_lv_pmos ad=0.2856p pd=2.36u as=0.2114p ps=1.54u w=0.84u l=0.13u
X1496 VDD Q_uq39 Y_uq283 VDD sg13_lv_pmos ad=0.3808p pd=2.92u as=0.3808p ps=2.92u w=1.12u l=0.13u
X1497 L_HI_uq11 a_37386_63834# VDD VDD sg13_lv_pmos ad=0.3927p pd=2.99u as=1.4745p ps=9.07u w=1.155u l=0.13u
X1498 Y_uq116 X_uq242 VSS VSS sg13_lv_nmos ad=0.2516p pd=2.16u as=0.2516p ps=2.16u w=0.74u l=0.13u
X1499 a_78365_24467# D_uq4 VDD VDD sg13_lv_pmos ad=79.8f pd=0.8u as=0.1428p ps=1.52u w=0.42u l=0.13u
X1500 a_31996_65314# a_31739_65171# a_32158_65094# VSS sg13_lv_nmos ad=0.1428p pd=1.52u as=37.8f ps=0.6u w=0.42u l=0.13u
X1501 a_50938_66123# a_51053_66122# VDD VDD sg13_lv_pmos ad=0.34p pd=2.68u as=0.2254p ps=1.53u w=1u l=0.5u
X1502 VDD a_7321_34574# B_uq74 VDD sg13_lv_pmos ad=0.1918p pd=1.5u as=0.3808p ps=2.92u w=1.12u l=0.13u
X1503 VDD D_uq0 a_79982_20740# VDD sg13_lv_pmos ad=0.1428p pd=1.52u as=79.8f ps=0.8u w=0.42u l=0.13u
X1504 VDD a_35110_65062# a_34829_65284# VDD sg13_lv_pmos ad=0.1523p pd=1.38u as=0.34p ps=2.68u w=1u l=0.5u
X1505 a_40368_65860# a_40342_65824# VDD VDD sg13_lv_pmos ad=0.34p pd=2.68u as=0.36237p ps=2.605u w=1u l=0.13u
X1506 VSS B_uq80 a_8799_33220# VSS sg13_lv_nmos ad=0.187p pd=1.78u as=0.1045p ps=0.93u w=0.55u l=0.13u
X1507 a_77629_19529# Y_uq51 Y_uq45 VSS sg13_lv_nmos ad=0.1406p pd=1.12u as=0.2516p ps=2.16u w=0.74u l=0.13u
X1508 VDD a_8071_33019# a_8071_32855# VDD sg13_lv_pmos ad=1.5243p pd=9.795u as=79.8f ps=0.8u w=0.42u l=0.13u
X1509 a_3535_37051# a_3550_35754# a_3535_36717# VDD sg13_lv_pmos ad=0.2048p pd=1.63u as=0.34p ps=2.68u w=1u l=0.13u
X1510 a_8833_42996# a_8835_41852# a_9230_42166# VSS sg13_lv_nmos ad=0.12665p pd=1.145u as=0.1428p ps=1.52u w=0.42u l=0.13u
X1511 VSS C_uq19 Y_uq97 VSS sg13_lv_nmos ad=0.2618p pd=2.22u as=0.1694p ps=1.21u w=0.77u l=0.13u
X1512 a_8835_41852# clk VSS VSS sg13_lv_nmos ad=0.2516p pd=2.16u as=3.58025p ps=22.71u w=0.74u l=0.13u
X1513 a_52504_63880# X_uq382 C_uq42 VDD sg13_lv_pmos ad=0.1176p pd=1.33u as=0.3808p ps=2.92u w=1.12u l=0.13u
X1514 VSS B_uq38 D_uq0 VSS sg13_lv_nmos ad=0.2618p pd=2.22u as=0.1694p ps=1.21u w=0.77u l=0.13u
X1515 a_3535_42833# A_uq347 VSS VSS sg13_lv_nmos ad=0.187p pd=1.78u as=0.14875p ps=1.16u w=0.55u l=0.13u
X1516 a_47110_65062# Q_uq32 VSS VSS sg13_lv_nmos ad=0.1428p pd=1.52u as=79.8f ps=0.8u w=0.42u l=0.13u
X1517 VSS a_45250_6863# X_uq3 VSS sg13_lv_nmos ad=0.14875p pd=1.16u as=0.2886p ps=2.26u w=0.74u l=0.13u
X1518 VSS a_5396_24385# a_5045_24504# VSS sg13_lv_nmos ad=79.8f pd=0.8u as=0.1428p ps=1.52u w=0.42u l=0.13u
X1519 VDD a_7056_25619# B_uq65 VDD sg13_lv_pmos ad=0.2114p pd=1.54u as=0.42p ps=2.99u w=1.12u l=0.13u
X1520 VSS X_uq312 a_7705_35563# VSS sg13_lv_nmos ad=0.2516p pd=2.16u as=0.1406p ps=1.12u w=0.74u l=0.13u
X1521 a_37968_64348# a_37942_64312# VDD VDD sg13_lv_pmos ad=0.34p pd=2.68u as=0.36237p ps=2.605u w=1u l=0.13u
X1522 a_11104_24183# C_uq22 a_10990_24183# VDD sg13_lv_pmos ad=0.2128p pd=1.5u as=0.2464p ps=1.56u w=1.12u l=0.13u
X1523 a_47760_69948# a_47734_69853# VDD VDD sg13_lv_pmos ad=0.34p pd=2.68u as=0.36237p ps=2.605u w=1u l=0.13u
X1524 VDD a_43761_65867# a_43863_65867# VDD sg13_lv_pmos ad=1.41367p pd=8.85u as=0.3864p ps=2.93u w=1.12u l=0.13u
X1525 a_29590_68848# a_30033_68891# a_29330_69318# VSS sg13_lv_nmos ad=79.8f pd=0.8u as=0.1296p ps=1.52u w=0.42u l=0.13u
X1526 VDD q[5] a_32382_10685# VDD sg13_lv_pmos ad=0.2114p pd=1.54u as=0.2856p ps=2.36u w=0.84u l=0.13u
X1527 VSS X_uq297 Y_uq165 VSS sg13_lv_nmos ad=0.2516p pd=2.16u as=0.2516p ps=2.16u w=0.74u l=0.13u
X1528 a_46210_10649# q[25] VSS VSS sg13_lv_nmos ad=0.187p pd=1.78u as=0.14875p ps=1.16u w=0.55u l=0.13u
X1529 a_33856_9173# X_uq168 Y_uq16 VDD sg13_lv_pmos ad=0.1176p pd=1.33u as=0.3808p ps=2.92u w=1.12u l=0.13u
X1530 VDD a_39490_8375# X_uq81 VDD sg13_lv_pmos ad=0.2114p pd=1.54u as=0.42p ps=2.99u w=1.12u l=0.13u
X1531 VDD a_49760_63550# a_49718_63880# VDD sg13_lv_pmos ad=0.2618p pd=1.63u as=0.1176p ps=1.33u w=1.12u l=0.13u
X1532 a_29424_69318# D_uq59 a_29330_69318# VSS sg13_lv_nmos ad=60.89999f pd=0.71u as=0.1428p ps=1.52u w=0.42u l=0.13u
X1533 VDD a_3535_42833# X_uq326 VDD sg13_lv_pmos ad=0.2114p pd=1.54u as=0.42p ps=2.99u w=1.12u l=0.13u
X1534 q[10] a_33364_63620# VDD VDD sg13_lv_pmos ad=0.42p pd=2.99u as=0.2114p ps=1.54u w=1.12u l=0.13u
X1535 a_32938_9891# X_uq123 VSS VSS sg13_lv_nmos ad=0.187p pd=1.78u as=0.17255p ps=1.25u w=0.55u l=0.13u
X1536 a_31739_65171# a_30897_65073# a_31645_65171# VSS sg13_lv_nmos ad=0.12665p pd=1.145u as=0.1428p ps=1.52u w=0.42u l=0.13u
X1537 Y_uq44 X_uq190 VSS VSS sg13_lv_nmos ad=0.2516p pd=2.16u as=0.2516p ps=2.16u w=0.74u l=0.13u
X1538 a_3539_38143# Q_uq18 VSS VSS sg13_lv_nmos ad=0.1428p pd=1.52u as=79.8f ps=0.8u w=0.42u l=0.13u
X1539 VDD q[1] a_34014_7661# VDD sg13_lv_pmos ad=0.2114p pd=1.54u as=0.2856p ps=2.36u w=0.84u l=0.13u
X1540 C_uq25 B_uq66 VSS VSS sg13_lv_nmos ad=0.1406p pd=1.12u as=0.2516p ps=2.16u w=0.74u l=0.13u
X1541 a_80076_28300# a_79134_28340# a_79982_28300# VDD sg13_lv_pmos ad=79.8f pd=0.8u as=0.1428p ps=1.52u w=0.42u l=0.13u
X1542 VSS B_uq76 D_uq14 VSS sg13_lv_nmos ad=0.2516p pd=2.16u as=0.1406p ps=1.12u w=0.74u l=0.13u
X1543 C_uq47 X_uq448 VSS VSS sg13_lv_nmos ad=0.1406p pd=1.12u as=0.2516p ps=2.16u w=0.74u l=0.13u
X1544 a_51971_65485# L_HI_uq17 VDD VDD sg13_lv_pmos ad=79.8f pd=0.8u as=0.36237p ps=2.605u w=0.42u l=0.13u
X1545 a_10819_33671# Y_uq164 VSS VSS sg13_lv_nmos ad=60.89999f pd=0.71u as=0.1626p ps=1.415u w=0.42u l=0.13u
X1546 X_uq72 a_45350_9149# VSS VSS sg13_lv_nmos ad=0.2516p pd=2.16u as=0.1469p ps=1.155u w=0.74u l=0.13u
X1547 a_42562_7625# A_uq72 VDD VDD sg13_lv_pmos ad=0.2856p pd=2.36u as=0.2114p ps=1.54u w=0.84u l=0.13u
X1548 X_uq218 a_10097_23135# VSS VSS sg13_lv_nmos ad=0.2886p pd=2.26u as=0.14875p ps=1.16u w=0.74u l=0.13u
X1549 VSS a_51964_64586# a_51613_64705# VSS sg13_lv_nmos ad=79.8f pd=0.8u as=0.1428p ps=1.52u w=0.42u l=0.13u
X1550 VSS X_uq404 C_uq61 VSS sg13_lv_nmos ad=0.2516p pd=2.16u as=0.1406p ps=1.12u w=0.74u l=0.13u
X1551 Y_uq55 C_uq4 VSS VSS sg13_lv_nmos ad=0.1406p pd=1.12u as=0.2516p ps=2.16u w=0.74u l=0.13u
X1552 VDD D_uq29 C_uq37 VDD sg13_lv_pmos ad=0.3808p pd=2.92u as=0.2128p ps=1.5u w=1.12u l=0.13u
X1553 a_38044_67610# L_HI_uq29 VDD VDD sg13_lv_pmos ad=79.8f pd=0.8u as=1.19383p ps=7.16u w=0.42u l=0.13u
X1554 VDD A_uq92 a_32862_7661# VDD sg13_lv_pmos ad=0.2114p pd=1.54u as=0.2856p ps=2.36u w=0.84u l=0.13u
X1555 VDD a_3535_37051# a_3535_36887# VDD sg13_lv_pmos ad=1.31615p pd=8.395u as=79.8f ps=0.8u w=0.42u l=0.13u
X1556 L_HI_uq29 a_35946_68370# VDD VDD sg13_lv_pmos ad=0.3927p pd=2.99u as=1.42837p ps=8.61u w=1.155u l=0.13u
X1557 a_5630_22595# Q VDD VDD sg13_lv_pmos ad=0.1428p pd=1.52u as=0.1523p ps=1.38u w=0.42u l=0.13u
X1558 a_4237_24190# a_3880_24147# VDD VDD sg13_lv_pmos ad=63f pd=0.72u as=0.1563p ps=1.22u w=0.42u l=0.13u
X1559 VSS a_7316_25113# a_6965_24970# VSS sg13_lv_nmos ad=79.8f pd=0.8u as=0.1428p ps=1.52u w=0.42u l=0.13u
X1560 a_10661_35594# a_10383_35831# a_10349_35023# VSS sg13_lv_nmos ad=0.2373p pd=1.97u as=79.8f ps=0.8u w=0.42u l=0.13u
X1561 VSS a_42446_10067# A_uq74 VSS sg13_lv_nmos ad=0.1469p pd=1.155u as=0.2516p ps=2.16u w=0.74u l=0.13u
X1562 VDD B_uq70 B1_uq2 VDD sg13_lv_pmos ad=0.3808p pd=2.92u as=0.3808p ps=2.92u w=1.12u l=0.13u
X1563 a_5811_42044# clk VDD VDD sg13_lv_pmos ad=0.4088p pd=2.97u as=1.72762p ps=11.19u w=1.12u l=0.13u
X1564 a_46522_64467# a_46264_64782# VDD VDD sg13_lv_pmos ad=93.45f pd=0.865u as=1.4745p ps=9.07u w=0.42u l=0.13u
X1565 VDD a_28160_65062# a_28118_65392# VDD sg13_lv_pmos ad=0.2618p pd=1.63u as=0.1176p ps=1.33u w=1.12u l=0.13u
X1566 VSS X_uq434 C_uq60 VSS sg13_lv_nmos ad=0.2516p pd=2.16u as=0.1406p ps=1.12u w=0.74u l=0.13u
X1567 VDD a_42776_65820# X_uq399 VDD sg13_lv_pmos ad=0.2114p pd=1.54u as=0.42p ps=2.99u w=1.12u l=0.13u
X1568 VSS a_7742_21837# a_7461_22059# VSS sg13_lv_nmos ad=79.8f pd=0.8u as=0.1428p ps=1.52u w=0.42u l=0.5u
X1569 a_50170_66921# a_49912_66606# VDD VDD sg13_lv_pmos ad=93.45f pd=0.865u as=1.19383p ps=7.16u w=0.42u l=0.13u
X1570 VDD C_uq15 a_11957_20111# VDD sg13_lv_pmos ad=0.4032p pd=2.96u as=0.1176p ps=1.33u w=1.12u l=0.13u
X1571 VDD X_uq338 a_40062_10685# VDD sg13_lv_pmos ad=0.2114p pd=1.54u as=0.2856p ps=2.36u w=0.84u l=0.13u
X1572 a_46344_67729# a_46475_67339# a_45763_67332# VDD sg13_lv_pmos ad=0.34p pd=2.68u as=0.2048p ps=1.63u w=1u l=0.13u
X1573 a_52785_65893# a_52785_65893# VSS VSS sg13_lv_nmos ad=0.111p pd=1.34u as=1.8643p ps=11.96u w=0.3u l=0.13u
X1574 a_48206_64782# L_HI_uq9 VSS VSS sg13_lv_nmos ad=60.89999f pd=0.71u as=0.1626p ps=1.415u w=0.42u l=0.13u
X1575 VDD B1_uq6 a_76459_21741# VDD sg13_lv_pmos ad=0.3808p pd=2.92u as=0.2128p ps=1.5u w=1.12u l=0.13u
X1576 a_10349_33537# a_10383_32686# a_10428_32924# VDD sg13_lv_pmos ad=79.8f pd=0.8u as=0.1428p ps=1.52u w=0.42u l=0.13u
X1577 VDD a_44482_7625# X_uq137 VDD sg13_lv_pmos ad=0.2114p pd=1.54u as=0.42p ps=2.99u w=1.12u l=0.13u
X1578 a_6217_21130# clk VSS VSS sg13_lv_nmos ad=0.2516p pd=2.16u as=1.70717p ps=10.335u w=0.74u l=0.13u
X1579 VDD a_7742_24107# a_7461_24409# VDD sg13_lv_pmos ad=0.1523p pd=1.38u as=0.34p ps=2.68u w=1u l=0.5u
X1580 VSS B1_uq6 a_76765_21469# VSS sg13_lv_nmos ad=0.2516p pd=2.16u as=0.1406p ps=1.12u w=0.74u l=0.13u
X1581 VDD a_49318_68844# a_49037_69146# VDD sg13_lv_pmos ad=0.1523p pd=1.38u as=0.34p ps=2.68u w=1u l=0.5u
X1582 a_78181_21632# a_78296_21633# VSS VSS sg13_lv_nmos ad=0.1428p pd=1.52u as=0.1426p ps=1.16u w=0.42u l=0.5u
X1583 VDD a_39814_68086# a_39533_68308# VDD sg13_lv_pmos ad=0.1523p pd=1.38u as=0.34p ps=2.68u w=1u l=0.5u
X1584 a_39490_8375# q[15] VDD VDD sg13_lv_pmos ad=0.2856p pd=2.36u as=0.2114p ps=1.54u w=0.84u l=0.13u
X1585 a_9628_33337# a_9594_31979# a_9632_32989# VSS sg13_lv_nmos ad=79.8f pd=0.8u as=0.2373p ps=1.97u w=0.42u l=0.13u
X1586 X_uq195 a_76447_18457# VDD VDD sg13_lv_pmos ad=0.42p pd=2.99u as=0.2114p ps=1.54u w=1.12u l=0.13u
X1587 VDD a_43330_6863# X_uq8 VDD sg13_lv_pmos ad=0.2114p pd=1.54u as=0.42p ps=2.99u w=1.12u l=0.13u
X1588 VSS a_44913_68891# a_45015_68891# VSS sg13_lv_nmos ad=2.01085p pd=12.81u as=0.2516p ps=2.16u w=0.74u l=0.13u
X1589 a_76285_22981# Y_uq83 Y_uq82 VSS sg13_lv_nmos ad=0.1406p pd=1.12u as=0.2516p ps=2.16u w=0.74u l=0.13u
X1590 a_43354_65283# a_43469_65284# VDD VDD sg13_lv_pmos ad=0.34p pd=2.68u as=0.2254p ps=1.53u w=1u l=0.5u
X1591 a_42000_64348# a_41974_64312# VDD VDD sg13_lv_pmos ad=0.34p pd=2.68u as=0.36237p ps=2.605u w=1u l=0.13u
X1592 VSS X_uq201 C_uq6 VSS sg13_lv_nmos ad=0.2516p pd=2.16u as=0.1406p ps=1.12u w=0.74u l=0.13u
X1593 VSS C_uq21 Y_uq31 VSS sg13_lv_nmos ad=0.2516p pd=2.16u as=0.1406p ps=1.12u w=0.74u l=0.13u
X1594 a_37776_64782# D_uq39 a_37682_64782# VSS sg13_lv_nmos ad=60.89999f pd=0.71u as=0.1428p ps=1.52u w=0.42u l=0.13u
X1595 VSS X_uq400 C_uq55 VSS sg13_lv_nmos ad=0.2516p pd=2.16u as=0.1406p ps=1.12u w=0.74u l=0.13u
X1596 VDD a_10345_43188# a_10468_42743# VDD sg13_lv_pmos ad=1.17462p pd=7.44u as=79.8f ps=0.8u w=0.42u l=0.13u
X1597 X_uq431 a_42292_68880# VDD VDD sg13_lv_pmos ad=0.42p pd=2.99u as=0.2114p ps=1.54u w=1.12u l=0.13u
X1598 C_uq33 a_5809_34453# VDD VDD sg13_lv_pmos ad=0.4256p pd=3u as=0.2254p ps=1.53u w=1.12u l=0.13u
X1599 a_37749_65903# a_37392_65860# VDD VDD sg13_lv_pmos ad=63f pd=0.72u as=0.1563p ps=1.22u w=0.42u l=0.13u
X1600 a_29169_68917# a_29169_68917# VSS VSS sg13_lv_nmos ad=0.111p pd=1.34u as=2.01085p ps=12.81u w=0.3u l=0.13u
X1601 Y_uq149 X_uq277 VDD VDD sg13_lv_pmos ad=0.3808p pd=2.92u as=0.3808p ps=2.92u w=1.12u l=0.13u
X1602 a_50805_64391# a_50448_64348# VDD VDD sg13_lv_pmos ad=63f pd=0.72u as=0.1563p ps=1.22u w=0.42u l=0.13u
X1603 VSS X_uq163 a_34116_10741# VSS sg13_lv_nmos ad=0.17255p pd=1.25u as=0.187p ps=1.78u w=0.55u l=0.13u
X1604 a_79134_28340# a_79286_28224# VDD VDD sg13_lv_pmos ad=0.3864p pd=2.93u as=1.59725p ps=10.05u w=1.12u l=0.13u
X1605 X_uq313 a_6585_39650# VSS VSS sg13_lv_nmos ad=0.2516p pd=2.16u as=0.1331p ps=1.12u w=0.74u l=0.13u
X1606 VDD a_40870_66574# a_40589_66796# VDD sg13_lv_pmos ad=0.1523p pd=1.38u as=0.34p ps=2.68u w=1u l=0.5u
X1607 C_uq43 X_uq448 VSS VSS sg13_lv_nmos ad=0.1406p pd=1.12u as=0.2516p ps=2.16u w=0.74u l=0.13u
X1608 VSS a_29830_65062# a_29549_65284# VSS sg13_lv_nmos ad=79.8f pd=0.8u as=0.1428p ps=1.52u w=0.42u l=0.5u
X1609 a_3539_38143# Q_uq18 VDD VDD sg13_lv_pmos ad=0.1428p pd=1.52u as=0.1523p ps=1.38u w=0.42u l=0.13u
X1610 VDD VSS VDD VDD sg13_lv_pmos ad=0.34p pd=2.68u as=0 ps=0 w=1u l=1u
X1611 a_76837_27789# C1_uq5 C_uq26 VDD sg13_lv_pmos ad=0.2128p pd=1.5u as=0.3808p ps=2.92u w=1.12u l=0.13u
X1612 B_uq73 B_uq75 a_9227_34047# VSS sg13_lv_nmos ad=0.1628p pd=1.18u as=88.8f ps=0.98u w=0.74u l=0.13u
X1613 VDD B_uq67 a_77323_19181# VDD sg13_lv_pmos ad=0.3808p pd=2.92u as=0.2128p ps=1.5u w=1.12u l=0.13u
X1614 a_34800_65860# a_34774_65824# VDD VDD sg13_lv_pmos ad=0.34p pd=2.68u as=0.36237p ps=2.605u w=1u l=0.13u
X1615 a_28944_65860# a_29463_65867# a_30203_66217# VSS sg13_lv_nmos ad=0.3473p pd=2.71u as=0.12665p ps=1.145u w=0.74u l=0.13u
X1616 Y_uq127 X_uq263 VDD VDD sg13_lv_pmos ad=0.3808p pd=2.92u as=0.3808p ps=2.92u w=1.12u l=0.13u
X1617 a_75860_24765# C_uq14 C1_uq2 VDD sg13_lv_pmos ad=0.2128p pd=1.5u as=0.3808p ps=2.92u w=1.12u l=0.13u
X1618 C1_uq7 C_uq27 VSS VSS sg13_lv_nmos ad=0.2618p pd=2.22u as=0.1463p ps=1.15u w=0.77u l=0.13u
X1619 VDD a_7321_32187# D_uq12 VDD sg13_lv_pmos ad=0.2254p pd=1.53u as=0.4256p ps=3u w=1.12u l=0.13u
X1620 a_7357_36704# A0 VDD VDD sg13_lv_pmos ad=0.3808p pd=2.92u as=0.2128p ps=1.5u w=1.12u l=0.13u
X1621 VSS din[28] a_76447_18457# VSS sg13_lv_nmos ad=0.14875p pd=1.16u as=0.187p ps=1.78u w=0.55u l=0.13u
X1622 VSS X_uq91 a_33246_7661# VSS sg13_lv_nmos ad=0.14875p pd=1.16u as=0.187p ps=1.78u w=0.55u l=0.13u
X1623 VSS clk a_79286_22176# VSS sg13_lv_nmos ad=2.83008p pd=17.885u as=0.2516p ps=2.16u w=0.74u l=0.13u
X1624 a_45944_63546# Q_uq31 VDD VDD sg13_lv_pmos ad=0.2856p pd=2.36u as=0.2114p ps=1.54u w=0.84u l=0.13u
X1625 a_41794_7625# X_uq79 VSS VSS sg13_lv_nmos ad=0.187p pd=1.78u as=0.14875p ps=1.16u w=0.55u l=0.13u
X1626 VSS A_uq87 Y_uq19 VSS sg13_lv_nmos ad=0.2516p pd=2.16u as=0.1406p ps=1.12u w=0.74u l=0.13u
X1627 a_8075_33721# a_8111_34043# VDD VDD sg13_lv_pmos ad=0.34p pd=2.68u as=0.2254p ps=1.53u w=1u l=0.5u
X1628 a_39826_67793# L_HI_uq28 VSS VSS sg13_lv_nmos ad=37.8f pd=0.6u as=0.1701p ps=1.65u w=0.42u l=0.13u
X1629 a_7316_23601# L_HI_uq3 VDD VDD sg13_lv_pmos ad=79.8f pd=0.8u as=1.02937p ps=6.325u w=0.42u l=0.13u
X1630 a_30275_64391# a_29579_64315# a_30369_64391# VSS sg13_lv_nmos ad=0.1296p pd=1.52u as=79.8f ps=0.8u w=0.42u l=0.13u
X1631 A_uq94 a_33734_10301# VSS VSS sg13_lv_nmos ad=0.2516p pd=2.16u as=0.1469p ps=1.155u w=0.74u l=0.13u
X1632 a_6215_40129# X_uq313 a_5809_39675# VSS sg13_lv_nmos ad=0.13135p pd=1.095u as=0.1628p ps=1.18u w=0.74u l=0.13u
X1633 a_47734_69853# a_48177_69609# a_47474_69630# VSS sg13_lv_nmos ad=79.8f pd=0.8u as=0.1296p ps=1.52u w=0.42u l=0.13u
X1634 VSS C_uq39 D_uq26 VSS sg13_lv_nmos ad=0.2516p pd=2.16u as=0.1406p ps=1.12u w=0.74u l=0.13u
X1635 VDD Y_uq65 a_12593_19387# VDD sg13_lv_pmos ad=0.2114p pd=1.54u as=0.2856p ps=2.36u w=0.84u l=0.13u
X1636 VDD C_uq23 a_78852_19529# VDD sg13_lv_pmos ad=0.1918p pd=1.5u as=0.1596p ps=1.22u w=0.84u l=0.13u
X1637 VDD Y_uq238 a_4380_41738# VDD sg13_lv_pmos ad=0.36237p pd=2.605u as=79.8f ps=0.8u w=0.42u l=0.13u
X1638 Y_uq304 Q_uq36 VDD VDD sg13_lv_pmos ad=0.3808p pd=2.92u as=0.3808p ps=2.92u w=1.12u l=0.13u
X1639 a_76459_21741# Y_uq63 a_76357_21741# VDD sg13_lv_pmos ad=0.2128p pd=1.5u as=0.2128p ps=1.5u w=1.12u l=0.13u
X1640 a_9583_39117# a_9594_39077# a_9583_39451# VSS sg13_lv_nmos ad=0.3473p pd=2.71u as=0.12665p ps=1.145u w=0.74u l=0.13u
X1641 a_46128_65860# a_46102_65824# VDD VDD sg13_lv_pmos ad=0.34p pd=2.68u as=0.36237p ps=2.605u w=1u l=0.13u
X1642 a_79153_28971# Q_uq8 VDD VDD sg13_lv_pmos ad=0.1428p pd=1.52u as=0.1523p ps=1.38u w=0.42u l=0.13u
X1643 VDD a_78039_23756# Y_uq85 VDD sg13_lv_pmos ad=0.3808p pd=2.92u as=0.2408p ps=1.55u w=1.12u l=0.13u
X1644 Y_uq334 a_43738_68936# VSS VSS sg13_lv_nmos ad=0.1406p pd=1.12u as=0.17255p ps=1.25u w=0.74u l=0.13u
X1645 a_76459_21469# Y_uq63 VSS VSS sg13_lv_nmos ad=0.1406p pd=1.12u as=0.1406p ps=1.12u w=0.74u l=0.13u
X1646 VDD a_46018_6863# X_uq1 VDD sg13_lv_pmos ad=0.2114p pd=1.54u as=0.42p ps=2.99u w=1.12u l=0.13u
X1647 a_51704_69594# Q_uq49 VSS VSS sg13_lv_nmos ad=0.187p pd=1.78u as=0.14875p ps=1.16u w=0.55u l=0.13u
X1648 VDD a_38651_66217# a_38908_66098# VDD sg13_lv_pmos ad=1.41367p pd=8.85u as=79.8f ps=0.8u w=0.42u l=0.13u
X1649 a_6313_24143# X_uq259 VDD VDD sg13_lv_pmos ad=0.2464p pd=1.56u as=0.3808p ps=2.92u w=1.12u l=0.13u
X1650 VDD Y_uq98 a_12593_23135# VDD sg13_lv_pmos ad=0.2114p pd=1.54u as=0.2856p ps=2.36u w=0.84u l=0.13u
X1651 Y_uq322 C_uq59 a_39075_67368# VDD sg13_lv_pmos ad=0.3808p pd=2.92u as=0.2128p ps=1.5u w=1.12u l=0.13u
X1652 B1_uq6 a_77029_20749# VSS VSS sg13_lv_nmos ad=0.1406p pd=1.12u as=0.17255p ps=1.25u w=0.74u l=0.13u
X1653 a_5725_22184# a_4783_21991# a_5523_21946# VDD sg13_lv_pmos ad=93.45f pd=0.865u as=0.2048p ps=1.63u w=0.42u l=0.13u
X1654 VDD q[18] a_39678_10685# VDD sg13_lv_pmos ad=0.2114p pd=1.54u as=0.2856p ps=2.36u w=0.84u l=0.13u
X1655 Y_uq303 a_49690_67424# VSS VSS sg13_lv_nmos ad=0.1406p pd=1.12u as=0.17255p ps=1.25u w=0.74u l=0.13u
X1656 VSS X_uq409 Y_uq311 VSS sg13_lv_nmos ad=0.2516p pd=2.16u as=0.1406p ps=1.12u w=0.74u l=0.13u
X1657 VSS X_uq137 a_44870_9149# VSS sg13_lv_nmos ad=0.1469p pd=1.155u as=0.1045p ps=0.93u w=0.55u l=0.13u
X1658 a_76651_26005# B2_uq8 VSS VSS sg13_lv_nmos ad=0.1406p pd=1.12u as=0.1406p ps=1.12u w=0.74u l=0.13u
X1659 a_5062_31722# clk VDD VDD sg13_lv_pmos ad=0.4088p pd=2.97u as=1.72762p ps=11.19u w=1.12u l=0.13u
X1660 VDD a_3539_37753# X_uq304 VDD sg13_lv_pmos ad=0.2254p pd=1.53u as=0.4256p ps=3u w=1.12u l=0.13u
X1661 Y_uq281 X_uq404 a_28408_65856# VDD sg13_lv_pmos ad=0.3808p pd=2.92u as=0.1176p ps=1.33u w=1.12u l=0.13u
X1662 C_uq56 X_uq420 VSS VSS sg13_lv_nmos ad=0.1406p pd=1.12u as=0.2516p ps=2.16u w=0.74u l=0.13u
X1663 Y_uq185 Y_uq188 a_8405_35930# VDD sg13_lv_pmos ad=0.3808p pd=2.92u as=0.2128p ps=1.5u w=1.12u l=0.13u
X1664 a_6595_42871# Y_uq236 VSS VSS sg13_lv_nmos ad=37.8f pd=0.6u as=79.8f ps=0.8u w=0.42u l=0.13u
X1665 Q_uq33 a_43926_64344# VDD VDD sg13_lv_pmos ad=0.3808p pd=2.92u as=0.2128p ps=1.5u w=1.12u l=0.13u
X1666 VDD q[16] a_38142_10685# VDD sg13_lv_pmos ad=0.2114p pd=1.54u as=0.2856p ps=2.36u w=0.84u l=0.13u
X1667 a_77618_27789# Q_uq6 B1_uq5 VDD sg13_lv_pmos ad=0.2128p pd=1.5u as=0.3808p ps=2.92u w=1.12u l=0.13u
X1668 a_8071_42477# a_8116_41079# VDD VDD sg13_lv_pmos ad=0.34p pd=2.68u as=0.36237p ps=2.605u w=1u l=0.13u
X1669 VSS a_50165_69218# a_50086_69121# VSS sg13_lv_nmos ad=2.01085p pd=12.81u as=0.27427p ps=2.28u w=0.795u l=0.13u
X1670 X_uq446 a_46324_69668# VSS VSS sg13_lv_nmos ad=0.2886p pd=2.26u as=0.14875p ps=1.16u w=0.74u l=0.13u
X1671 X_uq208 a_78189_23023# VDD VDD sg13_lv_pmos ad=0.4256p pd=3u as=0.2254p ps=1.53u w=1.12u l=0.13u
X1672 a_32938_9891# X_uq123 VDD VDD sg13_lv_pmos ad=0.2856p pd=2.36u as=0.2618p ps=1.63u w=0.84u l=0.13u
X1673 VDD Y_uq21 a_39774_6937# VDD sg13_lv_pmos ad=0.2114p pd=1.54u as=0.2856p ps=2.36u w=0.84u l=0.13u
X1674 a_41808_64782# D_uq38 a_41714_64782# VSS sg13_lv_nmos ad=60.89999f pd=0.71u as=0.1428p ps=1.52u w=0.42u l=0.13u
X1675 a_78881_28691# a_78574_28217# a_78787_28691# VSS sg13_lv_nmos ad=37.8f pd=0.6u as=0.1428p ps=1.52u w=0.42u l=0.13u
X1676 a_9594_31979# a_9598_32468# VDD VDD sg13_lv_pmos ad=0.3864p pd=2.93u as=1.17462p ps=7.44u w=1.12u l=0.13u
X1677 VDD Y_uq5 a_33630_6937# VDD sg13_lv_pmos ad=0.2114p pd=1.54u as=0.2856p ps=2.36u w=0.84u l=0.13u
X1678 X_uq297 a_4297_35327# VSS VSS sg13_lv_nmos ad=0.2886p pd=2.26u as=0.14875p ps=1.16u w=0.74u l=0.13u
X1679 SL[0] a_27316_69668# VDD VDD sg13_lv_pmos ad=0.42p pd=2.99u as=0.2114p ps=1.54u w=1.12u l=0.13u
X1680 a_4152_22595# B_uq66 VSS VSS sg13_lv_nmos ad=0.187p pd=1.78u as=0.17255p ps=1.25u w=0.55u l=0.13u
X1681 VSS VDD VSS VSS sg13_lv_nmos ad=79.8f pd=0.8u as=0 ps=-0 w=0.42u l=1u
X1682 a_48465_63625# a_48465_63625# VSS VSS sg13_lv_nmos ad=0.111p pd=1.34u as=3.5825p ps=23.78u w=0.3u l=0.13u
X1683 VSS a_49778_65098# a_49890_65162# VSS sg13_lv_nmos ad=0.1426p pd=1.16u as=0.1428p ps=1.52u w=0.42u l=0.5u
X1684 C_uq56 X_uq405 a_28310_66904# VDD sg13_lv_pmos ad=0.3808p pd=2.92u as=0.1176p ps=1.33u w=1.12u l=0.13u
X1685 a_44938_10649# X_uq136 VDD VDD sg13_lv_pmos ad=0.2856p pd=2.36u as=0.2618p ps=1.63u w=0.84u l=0.13u
X1686 VSS C_uq15 Y_uq98 VSS sg13_lv_nmos ad=0.1463p pd=1.15u as=0.1694p ps=1.21u w=0.77u l=0.13u
X1687 VDD a_38385_64355# a_38487_64355# VDD sg13_lv_pmos ad=1.4745p pd=9.07u as=0.3864p ps=2.93u w=1.12u l=0.13u
X1688 VSS C_uq61 Y_uq328 VSS sg13_lv_nmos ad=0.1463p pd=1.15u as=0.2618p ps=2.22u w=0.77u l=0.13u
X1689 a_33636_10661# B_uq31 a_33542_10661# VDD sg13_lv_pmos ad=0.1596p pd=1.22u as=0.2856p ps=2.36u w=0.84u l=0.13u
X1690 Q a_6190_22167# VDD VDD sg13_lv_pmos ad=0.3808p pd=2.92u as=0.2128p ps=1.5u w=1.12u l=0.13u
X1691 VSS a_37756_69850# a_37405_69707# VSS sg13_lv_nmos ad=79.8f pd=0.8u as=0.1428p ps=1.52u w=0.42u l=0.13u
X1692 VSS VDD VSS VSS sg13_lv_nmos ad=0.1428p pd=1.52u as=0 ps=-0 w=0.42u l=1u
X1693 VDD B_uq68 a_76651_28253# VDD sg13_lv_pmos ad=0.3808p pd=2.92u as=0.2128p ps=1.5u w=1.12u l=0.13u
X1694 a_44294_10301# B_uq8 VSS VSS sg13_lv_nmos ad=0.1045p pd=0.93u as=0.187p ps=1.78u w=0.55u l=0.13u
X1695 a_44554_9137# X_uq94 VSS VSS sg13_lv_nmos ad=0.187p pd=1.78u as=0.17255p ps=1.25u w=0.55u l=0.13u
X1696 VDD a_41026_7625# X_uq48 VDD sg13_lv_pmos ad=0.2114p pd=1.54u as=0.42p ps=2.99u w=1.12u l=0.13u
X1697 a_30682_66795# a_30797_66796# VSS VSS sg13_lv_nmos ad=0.1428p pd=1.52u as=0.1426p ps=1.16u w=0.42u l=0.5u
X1698 a_49251_64344# Y_uq242 a_49137_64344# VDD sg13_lv_pmos ad=0.2128p pd=1.5u as=0.2464p ps=1.56u w=1.12u l=0.13u
X1699 C_uq52 X_uq390 a_27542_65856# VDD sg13_lv_pmos ad=0.3808p pd=2.92u as=0.1176p ps=1.33u w=1.12u l=0.13u
X1700 Q_uq59 a_31542_67368# VDD VDD sg13_lv_pmos ad=0.3808p pd=2.92u as=0.2128p ps=1.5u w=1.12u l=0.13u
X1701 a_5833_35135# a_5809_34855# VSS VSS sg13_lv_nmos ad=0.1428p pd=1.52u as=79.8f ps=0.8u w=0.42u l=0.5u
X1702 VDD a_10345_37457# PC VDD sg13_lv_pmos ad=0.2114p pd=1.54u as=0.42p ps=2.99u w=1.12u l=0.13u
X1703 L_HI_uq37 a_39882_69882# VDD VDD sg13_lv_pmos ad=0.3927p pd=2.99u as=1.6733p ps=10.405u w=1.155u l=0.13u
X1704 a_6559_32877# a_6570_32837# a_6559_33211# VSS sg13_lv_nmos ad=0.3473p pd=2.71u as=0.12665p ps=1.145u w=0.74u l=0.13u
X1705 a_4771_34039# Y_uq174 VSS VSS sg13_lv_nmos ad=37.8f pd=0.6u as=79.8f ps=0.8u w=0.42u l=0.13u
X1706 a_47568_69630# D_uq60 a_47474_69630# VSS sg13_lv_nmos ad=60.89999f pd=0.71u as=0.1428p ps=1.52u w=0.42u l=0.13u
X1707 a_50870_65094# a_50563_65058# a_50776_65094# VSS sg13_lv_nmos ad=37.8f pd=0.6u as=0.1428p ps=1.52u w=0.42u l=0.13u
X1708 VSS Q_uq60 a_27316_69668# VSS sg13_lv_nmos ad=0.14875p pd=1.16u as=0.187p ps=1.78u w=0.55u l=0.13u
X1709 VSS C_uq5 Y_uq40 VSS sg13_lv_nmos ad=0.1463p pd=1.15u as=0.2618p ps=2.22u w=0.77u l=0.13u
X1710 VDD C_uq16 a_11340_18599# VDD sg13_lv_pmos ad=0.3808p pd=2.92u as=0.2464p ps=1.56u w=1.12u l=0.13u
X1711 B_uq84 Y_uq199 a_5821_37924# VDD sg13_lv_pmos ad=0.2128p pd=1.5u as=0.2716p ps=1.605u w=1.12u l=0.13u
X1712 Y_uq75 C_uq8 a_11763_22671# VDD sg13_lv_pmos ad=0.3808p pd=2.92u as=0.1176p ps=1.33u w=1.12u l=0.13u
X1713 Q_uq13 a_4297_34458# VDD VDD sg13_lv_pmos ad=0.3808p pd=2.92u as=0.2128p ps=1.5u w=1.12u l=0.13u
X1714 VDD a_8071_42811# a_8071_42647# VDD sg13_lv_pmos ad=1.5243p pd=9.795u as=79.8f ps=0.8u w=0.42u l=0.13u
X1715 a_76110_19181# C_uq23 a_75996_19181# VDD sg13_lv_pmos ad=0.2128p pd=1.5u as=0.2464p ps=1.56u w=1.12u l=0.13u
X1716 VSS a_4297_30929# X_uq282 VSS sg13_lv_nmos ad=0.14875p pd=1.16u as=0.2886p ps=2.26u w=0.74u l=0.13u
X1717 a_34688_63550# X_uq433 VSS VSS sg13_lv_nmos ad=0.187p pd=1.78u as=0.17255p ps=1.25u w=0.55u l=0.13u
X1718 VDD VSS VDD VDD sg13_lv_pmos ad=0.19p pd=1.38u as=0 ps=0 w=1u l=1u
X1719 a_51608_68844# Q_uq43 VDD VDD sg13_lv_pmos ad=0.2856p pd=2.36u as=0.2114p ps=1.54u w=0.84u l=0.13u
X1720 a_43330_6863# Y_uq2 VDD VDD sg13_lv_pmos ad=0.2856p pd=2.36u as=0.2114p ps=1.54u w=0.84u l=0.13u
X1721 a_37809_65867# clk VSS VSS sg13_lv_nmos ad=0.2516p pd=2.16u as=1.7977p ps=11.53u w=0.74u l=0.13u
X1722 VDD L_HI_uq1 a_3978_21869# VDD sg13_lv_pmos ad=0.36237p pd=2.605u as=79.8f ps=0.8u w=0.42u l=0.13u
X1723 Y_uq116 X_uq242 VDD VDD sg13_lv_pmos ad=0.3808p pd=2.92u as=0.3808p ps=2.92u w=1.12u l=0.13u
X1724 a_48376_66904# a_48154_66648# VDD VDD sg13_lv_pmos ad=0.1176p pd=1.33u as=0.2618p ps=1.63u w=1.12u l=0.13u
X1725 VSS Y_uq39 a_10865_19387# VSS sg13_lv_nmos ad=0.14875p pd=1.16u as=0.187p ps=1.78u w=0.55u l=0.13u
X1726 VDD VSS VDD VDD sg13_lv_pmos ad=0.19p pd=1.38u as=0 ps=0 w=1u l=1u
X1727 VDD L_HI_uq23 a_50614_67336# VDD sg13_lv_pmos ad=0.1563p pd=1.22u as=0.147p ps=1.54u w=0.42u l=0.13u
X1728 a_7742_22595# Q_uq1 VDD VDD sg13_lv_pmos ad=0.1428p pd=1.52u as=0.1523p ps=1.38u w=0.42u l=0.13u
X1729 Y_uq234 X_uq323 VSS VSS sg13_lv_nmos ad=0.2516p pd=2.16u as=0.2516p ps=2.16u w=0.74u l=0.13u
X1730 VSS a_10468_36599# a_10742_36214# VSS sg13_lv_nmos ad=79.8f pd=0.8u as=0.1428p ps=1.52u w=0.42u l=0.13u
X1731 VSS a_30875_67729# a_31542_67368# VSS sg13_lv_nmos ad=0.1406p pd=1.12u as=0.2516p ps=2.16u w=0.74u l=0.13u
X1732 VSS a_52088_69594# A_uq65 VSS sg13_lv_nmos ad=0.14875p pd=1.16u as=0.2886p ps=2.26u w=0.74u l=0.13u
X1733 VDD VSS VDD VDD sg13_lv_pmos ad=0.19p pd=1.38u as=0 ps=0 w=1u l=1u
X1734 A_uq98 a_33342_9173# VDD VDD sg13_lv_pmos ad=0.42p pd=2.99u as=0.2114p ps=1.54u w=1.12u l=0.13u
X1735 A_uq0 a_45268_66644# VSS VSS sg13_lv_nmos ad=0.2886p pd=2.26u as=0.14875p ps=1.16u w=0.74u l=0.13u
X1736 a_8869_34699# D_uq25 a_8833_34465# VDD sg13_lv_pmos ad=0.2125p pd=1.425u as=0.35p ps=2.7u w=1u l=0.13u
X1737 VSS a_37090_8375# X_uq113 VSS sg13_lv_nmos ad=0.14875p pd=1.16u as=0.2886p ps=2.26u w=0.74u l=0.13u
X1738 a_34690_7625# A_uq8 VSS VSS sg13_lv_nmos ad=0.187p pd=1.78u as=0.14875p ps=1.16u w=0.55u l=0.13u
X1739 a_42779_69707# a_41937_69609# a_41520_69948# VDD sg13_lv_pmos ad=0.2048p pd=1.63u as=0.34p ps=2.68u w=1u l=0.13u
X1740 VSS VDD VSS VSS sg13_lv_nmos ad=0.1428p pd=1.52u as=0 ps=-0 w=0.42u l=1u
X1741 VSS X_uq293 a_3535_34847# VSS sg13_lv_nmos ad=0.14875p pd=1.16u as=0.187p ps=1.78u w=0.55u l=0.13u
X1742 a_49760_63550# X_uq446 VDD VDD sg13_lv_pmos ad=0.2856p pd=2.36u as=0.2618p ps=1.63u w=0.84u l=0.13u
X1743 Y_uq294 Y_uq295 VSS VSS sg13_lv_nmos ad=0.1694p pd=1.21u as=0.1463p ps=1.15u w=0.77u l=0.13u
X1744 X_uq159 a_35070_10685# VSS VSS sg13_lv_nmos ad=0.2886p pd=2.26u as=0.14875p ps=1.16u w=0.74u l=0.13u
X1745 VDD Y_uq55 a_9809_20111# VDD sg13_lv_pmos ad=0.2114p pd=1.54u as=0.2856p ps=2.36u w=0.84u l=0.13u
X1746 VDD Y_uq237 a_5813_41167# VDD sg13_lv_pmos ad=0.1563p pd=1.22u as=0.147p ps=1.54u w=0.42u l=0.13u
X1747 VDD a_7292_38117# X_uq303 VDD sg13_lv_pmos ad=0.36195p pd=1.84u as=0.3808p ps=2.92u w=1.12u l=0.13u
X1748 a_8071_42811# a_8086_41514# a_8107_42579# VSS sg13_lv_nmos ad=0.12665p pd=1.145u as=0.1428p ps=1.52u w=0.42u l=0.13u
X1749 a_37090_8375# q[10] VSS VSS sg13_lv_nmos ad=0.187p pd=1.78u as=0.14875p ps=1.16u w=0.55u l=0.13u
X1750 a_5092_34839# a_5062_35274# a_5083_34571# VSS sg13_lv_nmos ad=79.8f pd=0.8u as=0.1296p ps=1.52u w=0.42u l=0.13u
X1751 a_43036_69850# a_42779_69707# a_43198_69630# VSS sg13_lv_nmos ad=0.1428p pd=1.52u as=37.8f ps=0.6u w=0.42u l=0.13u
X1752 a_9594_31979# a_9598_32468# VSS VSS sg13_lv_nmos ad=0.2516p pd=2.16u as=4.17695p ps=26.495u w=0.74u l=0.13u
X1753 VSS Y_uq131 a_8849_25435# VSS sg13_lv_nmos ad=0.14875p pd=1.16u as=0.187p ps=1.78u w=0.55u l=0.13u
X1754 a_8075_38617# a_8111_38939# VSS VSS sg13_lv_nmos ad=0.1428p pd=1.52u as=0.1426p ps=1.16u w=0.42u l=0.5u
X1755 VSS a_46906_69147# X_uq427 VSS sg13_lv_nmos ad=0.1426p pd=1.16u as=0.2516p ps=2.16u w=0.74u l=0.13u
X1756 X_uq244 a_10481_25435# VSS VSS sg13_lv_nmos ad=0.2886p pd=2.26u as=0.14875p ps=1.16u w=0.74u l=0.13u
X1757 a_76069_27789# B1_uq6 a_76171_27789# VDD sg13_lv_pmos ad=0.3808p pd=2.92u as=0.2128p ps=1.5u w=1.12u l=0.13u
X1758 VSS C_uq60 D_uq56 VSS sg13_lv_nmos ad=0.1463p pd=1.15u as=0.2618p ps=2.22u w=0.77u l=0.13u
X1759 a_11861_18135# C_uq1 Y_uq32 VDD sg13_lv_pmos ad=0.1176p pd=1.33u as=0.3808p ps=2.92u w=1.12u l=0.13u
X1760 a_30598_68086# Q_uq60 VSS VSS sg13_lv_nmos ad=0.1428p pd=1.52u as=79.8f ps=0.8u w=0.42u l=0.13u
X1761 VSS Q_uq6 C1_uq4 VSS sg13_lv_nmos ad=0.2516p pd=2.16u as=0.2516p ps=2.16u w=0.74u l=0.13u
X1762 VSS Y_uq98 a_12593_23135# VSS sg13_lv_nmos ad=0.14875p pd=1.16u as=0.187p ps=1.78u w=0.55u l=0.13u
X1763 a_6591_35227# Y_uq181 VSS VSS sg13_lv_nmos ad=0.1406p pd=1.12u as=0.1406p ps=1.12u w=0.74u l=0.15u
X1764 VDD a_6563_38009# a_6893_37967# VDD sg13_lv_pmos ad=0.2618p pd=1.63u as=0.1176p ps=1.33u w=1.12u l=0.13u
X1765 Y_uq76 C_uq8 a_11392_22671# VDD sg13_lv_pmos ad=0.3808p pd=2.92u as=0.2128p ps=1.5u w=1.12u l=0.13u
X1766 a_42406_65062# Q_uq30 VSS VSS sg13_lv_nmos ad=0.1428p pd=1.52u as=79.8f ps=0.8u w=0.42u l=0.13u
X1767 VSS a_79619_21407# B_uq67 VSS sg13_lv_nmos ad=0.14875p pd=1.16u as=0.2886p ps=2.26u w=0.74u l=0.13u
X1768 VDD din[24] a_75679_19969# VDD sg13_lv_pmos ad=0.2114p pd=1.54u as=0.2856p ps=2.36u w=0.84u l=0.13u
X1769 a_46018_6863# Y_uq8 VDD VDD sg13_lv_pmos ad=0.2856p pd=2.36u as=0.2114p ps=1.54u w=0.84u l=0.13u
X1770 VSS a_36610_7625# X_uq66 VSS sg13_lv_nmos ad=0.14875p pd=1.16u as=0.2886p ps=2.26u w=0.74u l=0.13u
X1771 a_28361_68880# C_uq72 D_uq65 VDD sg13_lv_pmos ad=0.2128p pd=1.5u as=0.3808p ps=2.92u w=1.12u l=0.13u
X1772 a_28160_65062# X_uq420 VDD VDD sg13_lv_pmos ad=0.2856p pd=2.36u as=0.2618p ps=1.63u w=0.84u l=0.13u
X1773 VDD a_27608_68082# X_uq420 VDD sg13_lv_pmos ad=0.2114p pd=1.54u as=0.42p ps=2.99u w=1.12u l=0.13u
X1774 VSS C_uq28 C1_uq6 VSS sg13_lv_nmos ad=0.1463p pd=1.15u as=0.2618p ps=2.22u w=0.77u l=0.13u
X1775 Y_uq261 C_uq48 a_43011_65392# VDD sg13_lv_pmos ad=0.3808p pd=2.92u as=0.2128p ps=1.5u w=1.12u l=0.13u
X1776 VSS X_uq157 a_38052_9965# VSS sg13_lv_nmos ad=0.17255p pd=1.25u as=0.187p ps=1.78u w=0.55u l=0.13u
X1777 VSS C_uq8 Y_uq75 VSS sg13_lv_nmos ad=0.2516p pd=2.16u as=0.1406p ps=1.12u w=0.74u l=0.13u
X1778 a_6893_35857# B_uq79 C_uq34 VDD sg13_lv_pmos ad=0.1176p pd=1.33u as=0.3808p ps=2.92u w=1.12u l=0.13u
X1779 Q_uq33 a_43926_64344# VSS VSS sg13_lv_nmos ad=0.2516p pd=2.16u as=0.1406p ps=1.12u w=0.74u l=0.13u
X1780 a_37680_66281# a_37392_65860# a_37618_66281# VSS sg13_lv_nmos ad=0.1428p pd=1.52u as=37.8f ps=0.6u w=0.42u l=0.13u
X1781 X_uq346 a_38740_63620# VSS VSS sg13_lv_nmos ad=0.2886p pd=2.26u as=0.14875p ps=1.16u w=0.74u l=0.13u
X1782 X_uq241 a_75679_25229# VSS VSS sg13_lv_nmos ad=0.2886p pd=2.26u as=0.14875p ps=1.16u w=0.74u l=0.13u
X1783 a_42776_65820# X_uq450 VSS VSS sg13_lv_nmos ad=0.187p pd=1.78u as=0.14875p ps=1.16u w=0.55u l=0.13u
X1784 a_32630_67368# X_uq458 VDD VDD sg13_lv_pmos ad=0.1176p pd=1.33u as=0.4032p ps=2.96u w=1.12u l=0.13u
X1785 A_uq82 a_38534_10301# VDD VDD sg13_lv_pmos ad=0.3976p pd=2.95u as=0.2226p ps=1.535u w=1.12u l=0.13u
X1786 VSS Q_uq6 B1_uq1 VSS sg13_lv_nmos ad=0.2516p pd=2.16u as=0.1406p ps=1.12u w=0.74u l=0.13u
X1787 a_4333_38618# Y_uq206 VDD VDD sg13_lv_pmos ad=0.2128p pd=1.5u as=0.2128p ps=1.5u w=1.12u l=0.13u
X1788 a_6559_32877# a_6604_31479# VDD VDD sg13_lv_pmos ad=0.34p pd=2.68u as=0.36237p ps=2.605u w=1u l=0.13u
X1789 a_35026_66281# L_HI_uq15 VSS VSS sg13_lv_nmos ad=37.8f pd=0.6u as=0.1701p ps=1.65u w=0.42u l=0.13u
X1790 VSS A_uq210 a_3500_23419# VSS sg13_lv_nmos ad=0.14875p pd=1.16u as=0.187p ps=1.78u w=0.55u l=0.13u
X1791 a_36214_69853# a_36657_69609# a_36597_70021# VDD sg13_lv_pmos ad=79.8f pd=0.8u as=63f ps=0.72u w=0.42u l=0.13u
X1792 a_77042_22205# Q_uq6 Y_uq80 VDD sg13_lv_pmos ad=0.2128p pd=1.5u as=0.3808p ps=2.92u w=1.12u l=0.13u
X1793 VSS Y_uq109 a_12017_24647# VSS sg13_lv_nmos ad=0.14875p pd=1.16u as=0.187p ps=1.78u w=0.55u l=0.13u
X1794 a_52565_66552# a_52689_66649# VDD VDD sg13_lv_pmos ad=0.2442p pd=2.06u as=1.19383p ps=7.16u w=0.66u l=0.13u
X1795 VSS X_uq352 a_35454_10685# VSS sg13_lv_nmos ad=0.14875p pd=1.16u as=0.187p ps=1.78u w=0.55u l=0.13u
X1796 VSS a_37126_68086# a_36845_68308# VSS sg13_lv_nmos ad=79.8f pd=0.8u as=0.1428p ps=1.52u w=0.42u l=0.5u
X1797 VDD a_5211_25960# a_5211_25730# VDD sg13_lv_pmos ad=1.17282p pd=7.015u as=0.2442p ps=2.06u w=0.66u l=0.13u
X1798 a_35002_69819# a_35117_69820# VSS VSS sg13_lv_nmos ad=0.1428p pd=1.52u as=0.1426p ps=1.16u w=0.42u l=0.5u
X1799 VDD Y_uq169 a_6595_31211# VDD sg13_lv_pmos ad=0.36237p pd=2.605u as=79.8f ps=0.8u w=0.42u l=0.13u
X1800 D_uq65 Y_uq349 VSS VSS sg13_lv_nmos ad=0.1694p pd=1.21u as=0.1463p ps=1.15u w=0.77u l=0.13u
X1801 Y_uq261 X_uq447 VSS VSS sg13_lv_nmos ad=0.1694p pd=1.21u as=0.2618p ps=2.22u w=0.77u l=0.13u
X1802 VSS a_50865_64355# a_50967_64355# VSS sg13_lv_nmos ad=4.5737p pd=28.36u as=0.2516p ps=2.16u w=0.74u l=0.13u
X1803 a_3571_35051# D_uq22 VDD VDD sg13_lv_pmos ad=79.8f pd=0.8u as=0.1428p ps=1.52u w=0.42u l=0.13u
X1804 VDD a_51986_65856# a_52098_65880# VDD sg13_lv_pmos ad=0.2254p pd=1.53u as=0.34p ps=2.68u w=1u l=0.5u
X1805 Q_uq49 a_52566_67368# VSS VSS sg13_lv_nmos ad=0.2516p pd=2.16u as=0.1406p ps=1.12u w=0.74u l=0.13u
X1806 VSS VDD VSS VSS sg13_lv_nmos ad=79.8f pd=0.8u as=0 ps=-0 w=0.42u l=1u
X1807 X_uq79 a_41414_9149# VDD VDD sg13_lv_pmos ad=0.3976p pd=2.95u as=0.2226p ps=1.535u w=1.12u l=0.13u
X1808 VDD a_46808_63546# q[21] VDD sg13_lv_pmos ad=0.2114p pd=1.54u as=0.42p ps=2.99u w=1.12u l=0.13u
X1809 VSS L_HI_uq0 a_80333_21118# VSS sg13_lv_nmos ad=0.1701p pd=1.65u as=37.8f ps=0.6u w=0.42u l=0.13u
X1810 VDD a_10372_19391# D_uq7 VDD sg13_lv_pmos ad=0.3808p pd=2.92u as=0.2128p ps=1.5u w=1.12u l=0.13u
X1811 VSS A_uq90 a_34014_6937# VSS sg13_lv_nmos ad=0.14875p pd=1.16u as=0.187p ps=1.78u w=0.55u l=0.13u
X1812 VDD L_HI_uq25 a_29330_67806# VDD sg13_lv_pmos ad=0.36237p pd=2.605u as=79.8f ps=0.8u w=0.42u l=0.13u
X1813 a_30364_69850# L_HI_uq40 VDD VDD sg13_lv_pmos ad=79.8f pd=0.8u as=1.6733p ps=10.405u w=0.42u l=0.13u
X1814 a_49318_68844# Q_uq50 VDD VDD sg13_lv_pmos ad=0.1428p pd=1.52u as=0.1523p ps=1.38u w=0.42u l=0.13u
X1815 a_6157_23772# a_5800_23699# VDD VDD sg13_lv_pmos ad=63f pd=0.72u as=0.1563p ps=1.22u w=0.42u l=0.13u
X1816 D_uq14 B_uq76 a_5845_32207# VDD sg13_lv_pmos ad=0.3808p pd=2.92u as=0.1176p ps=1.33u w=1.12u l=0.13u
X1817 a_42562_6863# Y_uq29 VSS VSS sg13_lv_nmos ad=0.187p pd=1.78u as=0.14875p ps=1.16u w=0.55u l=0.13u
X1818 VDD B_uq76 a_7357_32934# VDD sg13_lv_pmos ad=0.19p pd=1.38u as=0.34p ps=2.68u w=1u l=0.13u
X1819 VDD a_77219_28967# C_uq27 VDD sg13_lv_pmos ad=0.2114p pd=1.54u as=0.42p ps=2.99u w=1.12u l=0.13u
X1820 Y_uq263 C_uq44 VSS VSS sg13_lv_nmos ad=0.2618p pd=2.22u as=0.1463p ps=1.15u w=0.77u l=0.13u
X1821 a_50746_69147# a_50861_69146# VDD VDD sg13_lv_pmos ad=0.34p pd=2.68u as=0.2254p ps=1.53u w=1u l=0.5u
X1822 a_32978_66606# D_uq49 VDD VDD sg13_lv_pmos ad=79.8f pd=0.8u as=0.1428p ps=1.52u w=0.42u l=0.13u
X1823 B_uq76 Y_uq181 a_6913_35325# VDD sg13_lv_pmos ad=0.2128p pd=1.5u as=0.2128p ps=1.5u w=1.12u l=0.15u
X1824 Y_uq272 X_uq445 VSS VSS sg13_lv_nmos ad=0.1694p pd=1.21u as=0.2618p ps=2.22u w=0.77u l=0.13u
X1825 VSS L_HI_uq35 a_44304_69318# VSS sg13_lv_nmos ad=0.1626p pd=1.415u as=60.89999f ps=0.71u w=0.42u l=0.13u
X1826 VSS Y_uq6 a_32862_6937# VSS sg13_lv_nmos ad=0.14875p pd=1.16u as=0.187p ps=1.78u w=0.55u l=0.13u
X1827 VDD a_5047_36571# a_5047_36954# VDD sg13_lv_pmos ad=0.2128p pd=1.5u as=0.3864p ps=2.93u w=1.12u l=0.13u
X1828 a_6217_23360# clk VDD VDD sg13_lv_pmos ad=0.4088p pd=2.97u as=0.94357p ps=5.8u w=1.12u l=0.13u
X1829 VSS a_8956_37847# a_9230_37462# VSS sg13_lv_nmos ad=79.8f pd=0.8u as=0.1428p ps=1.52u w=0.42u l=0.13u
X1830 VSS Y_uq54 a_10193_20111# VSS sg13_lv_nmos ad=0.14875p pd=1.16u as=0.187p ps=1.78u w=0.55u l=0.13u
X1831 VDD Y_uq205 a_5381_38737# VDD sg13_lv_pmos ad=0.4032p pd=2.96u as=0.1176p ps=1.33u w=1.12u l=0.13u
X1832 a_5096_31593# a_5047_32685# a_5096_31531# VSS sg13_lv_nmos ad=0.1428p pd=1.52u as=37.8f ps=0.6u w=0.42u l=0.13u
X1833 VDD X_uq348 a_36606_10685# VDD sg13_lv_pmos ad=0.2114p pd=1.54u as=0.2856p ps=2.36u w=0.84u l=0.13u
X1834 A_uq98 a_33342_9173# VSS VSS sg13_lv_nmos ad=0.2886p pd=2.26u as=0.14875p ps=1.16u w=0.74u l=0.13u
X1835 X_uq191 a_12593_20111# VDD VDD sg13_lv_pmos ad=0.42p pd=2.99u as=0.2114p ps=1.54u w=1.12u l=0.13u
X1836 VSS a_4299_42044# a_4335_41975# VSS sg13_lv_nmos ad=5.0377p pd=32.285u as=0.2516p ps=2.16u w=0.74u l=0.13u
X1837 VSS L_HI_uq37 a_39350_69318# VSS sg13_lv_nmos ad=79.8f pd=0.8u as=37.8f ps=0.6u w=0.42u l=0.13u
X1838 VSS X_uq437 C_uq67 VSS sg13_lv_nmos ad=0.2516p pd=2.16u as=0.1406p ps=1.12u w=0.74u l=0.13u
X1839 q[14] a_37588_63620# VDD VDD sg13_lv_pmos ad=0.42p pd=2.99u as=0.2114p ps=1.54u w=1.12u l=0.13u
X1840 X_uq25 a_36702_6937# VDD VDD sg13_lv_pmos ad=0.42p pd=2.99u as=0.2114p ps=1.54u w=1.12u l=0.13u
X1841 a_40594_66281# L_HI_uq14 VSS VSS sg13_lv_nmos ad=37.8f pd=0.6u as=0.1701p ps=1.65u w=0.42u l=0.13u
X1842 a_4297_34356# a_4299_33212# a_4337_32361# VDD sg13_lv_pmos ad=0.2048p pd=1.63u as=0.34p ps=2.68u w=1u l=0.13u
X1843 A2_uq6 B1_uq7 a_76651_28601# VSS sg13_lv_nmos ad=0.2516p pd=2.16u as=0.1406p ps=1.12u w=0.74u l=0.13u
X1844 a_5845_33564# S_uq0 a_5845_33450# VDD sg13_lv_pmos ad=0.2128p pd=1.5u as=0.2464p ps=1.56u w=1.12u l=0.13u
X1845 X_uq341 a_41236_63620# VSS VSS sg13_lv_nmos ad=0.2886p pd=2.26u as=0.14875p ps=1.16u w=0.74u l=0.13u
X1846 q[13] a_36052_63620# VDD VDD sg13_lv_pmos ad=0.42p pd=2.99u as=0.2114p ps=1.54u w=1.12u l=0.13u
X1847 a_39226_63771# a_39341_63772# VDD VDD sg13_lv_pmos ad=0.34p pd=2.68u as=0.2254p ps=1.53u w=1u l=0.5u
X1848 VDD L_HI_uq12 a_33430_64312# VDD sg13_lv_pmos ad=0.1563p pd=1.22u as=0.147p ps=1.54u w=0.42u l=0.13u
X1849 VDD X_uq325 a_8945_19387# VDD sg13_lv_pmos ad=0.2114p pd=1.54u as=0.2856p ps=2.36u w=0.84u l=0.13u
X1850 a_33592_67368# a_33370_67424# VDD VDD sg13_lv_pmos ad=0.1176p pd=1.33u as=0.2618p ps=1.63u w=1.12u l=0.13u
X1851 VSS Y_uq190 a_8103_36475# VSS sg13_lv_nmos ad=0.1406p pd=1.12u as=0.2516p ps=2.16u w=0.74u l=0.15u
X1852 VSS a_31132_67610# a_30781_67729# VSS sg13_lv_nmos ad=79.8f pd=0.8u as=0.1428p ps=1.52u w=0.42u l=0.13u
X1853 a_39484_64586# L_HI_uq11 VDD VDD sg13_lv_pmos ad=79.8f pd=0.8u as=1.4745p ps=9.07u w=0.42u l=0.13u
X1854 C_uq51 X_uq458 VSS VSS sg13_lv_nmos ad=0.1406p pd=1.12u as=0.2516p ps=2.16u w=0.74u l=0.13u
X1855 VSS a_34726_67332# a_34445_67634# VSS sg13_lv_nmos ad=79.8f pd=0.8u as=0.1428p ps=1.52u w=0.42u l=0.5u
X1856 VSS SLN[0] a_33150_8449# VSS sg13_lv_nmos ad=0.14875p pd=1.16u as=0.187p ps=1.78u w=0.55u l=0.13u
X1857 a_31448_68082# Q_uq57 VDD VDD sg13_lv_pmos ad=0.2856p pd=2.36u as=0.2114p ps=1.54u w=0.84u l=0.13u
X1858 a_41198_69318# L_HI_uq37 VSS VSS sg13_lv_nmos ad=60.89999f pd=0.71u as=0.1626p ps=1.415u w=0.42u l=0.13u
X1859 a_43906_7625# Y VDD VDD sg13_lv_pmos ad=0.2856p pd=2.36u as=0.2114p ps=1.54u w=0.84u l=0.13u
X1860 Y_uq105 X_uq262 VDD VDD sg13_lv_pmos ad=0.3808p pd=2.92u as=0.3808p ps=2.92u w=1.12u l=0.13u
X1861 a_7357_40025# A0 VDD VDD sg13_lv_pmos ad=0.3808p pd=2.92u as=0.2128p ps=1.5u w=1.12u l=0.13u
X1862 VSS VDD VSS VSS sg13_lv_nmos ad=0.1428p pd=1.52u as=0 ps=-0 w=0.42u l=1u
X1863 X_uq328 a_3535_43295# VSS VSS sg13_lv_nmos ad=0.2886p pd=2.26u as=0.14875p ps=1.16u w=0.74u l=0.13u
X1864 a_3575_39179# a_3539_39079# VSS VSS sg13_lv_nmos ad=0.1428p pd=1.52u as=79.8f ps=0.8u w=0.42u l=0.5u
X1865 a_6559_33211# a_6574_31914# a_6595_32979# VSS sg13_lv_nmos ad=0.12665p pd=1.145u as=0.1428p ps=1.52u w=0.42u l=0.13u
X1866 Q_uq39 a_30870_65856# VSS VSS sg13_lv_nmos ad=0.2516p pd=2.16u as=0.1406p ps=1.12u w=0.74u l=0.13u
X1867 a_3962_40398# a_3535_41421# VDD VDD sg13_lv_pmos ad=63f pd=0.72u as=0.1563p ps=1.22u w=0.42u l=0.13u
X1868 a_32158_65094# L_HI_uq16 VSS VSS sg13_lv_nmos ad=37.8f pd=0.6u as=79.8f ps=0.8u w=0.42u l=0.13u
X1869 a_30275_64391# D_uq35 a_31022_64782# VSS sg13_lv_nmos ad=0.1428p pd=1.52u as=60.89999f ps=0.71u w=0.42u l=0.13u
X1870 VSS a_28931_66687# a_28931_66687# VSS sg13_lv_nmos ad=1.8643p pd=11.96u as=0.111p ps=1.34u w=0.3u l=0.13u
X1871 VDD L_HI_uq28 a_39574_67336# VDD sg13_lv_pmos ad=0.1563p pd=1.22u as=0.147p ps=1.54u w=0.42u l=0.13u
X1872 a_35680_8709# A_uq98 Y_uq6 VDD sg13_lv_pmos ad=0.1176p pd=1.33u as=0.3808p ps=2.92u w=1.12u l=0.13u
X1873 a_37682_64782# a_38487_64355# a_37942_64312# VDD sg13_lv_pmos ad=0.1428p pd=1.52u as=79.8f ps=0.8u w=0.42u l=0.13u
X1874 VSS X_uq160 a_35550_6937# VSS sg13_lv_nmos ad=0.14875p pd=1.16u as=0.187p ps=1.78u w=0.55u l=0.13u
X1875 VDD a_7321_34111# a_7345_33831# VDD sg13_lv_pmos ad=0.1523p pd=1.38u as=0.34p ps=2.68u w=1u l=0.5u
X1876 Y_uq342 a_35194_68936# VSS VSS sg13_lv_nmos ad=0.1406p pd=1.12u as=0.17255p ps=1.25u w=0.74u l=0.13u
X1877 C_uq49 X_uq383 a_50486_65856# VDD sg13_lv_pmos ad=0.3808p pd=2.92u as=0.1176p ps=1.33u w=1.12u l=0.13u
X1878 a_38441_68416# C_uq65 Y_uq360 VDD sg13_lv_pmos ad=0.2128p pd=1.5u as=0.3808p ps=2.92u w=1.12u l=0.13u
X1879 VSS clk a_46763_64315# VSS sg13_lv_nmos ad=4.19255p pd=26u as=0.2516p ps=2.16u w=0.74u l=0.13u
X1880 a_40474_66795# a_40589_66796# VDD VDD sg13_lv_pmos ad=0.34p pd=2.68u as=0.2254p ps=1.53u w=1u l=0.5u
X1881 VDD VSS VDD VDD sg13_lv_pmos ad=0.34p pd=2.68u as=0 ps=0 w=1u l=1u
X1882 a_51454_68118# L_HI_uq31 VSS VSS sg13_lv_nmos ad=37.8f pd=0.6u as=79.8f ps=0.8u w=0.42u l=0.13u
X1883 a_45418_10649# X_uq135 VDD VDD sg13_lv_pmos ad=0.2856p pd=2.36u as=0.2618p ps=1.63u w=0.84u l=0.13u
X1884 X_uq29 a_35166_6937# VSS VSS sg13_lv_nmos ad=0.2886p pd=2.26u as=0.14875p ps=1.16u w=0.74u l=0.13u
X1885 VSS a_79502_23036# a_79502_23036# VSS sg13_lv_nmos ad=2.83008p pd=17.885u as=0.111p ps=1.34u w=0.3u l=0.13u
X1886 VDD a_80076_20740# a_79155_21054# VDD sg13_lv_pmos ad=0.36237p pd=2.605u as=0.34p ps=2.68u w=1u l=0.13u
X1887 Y_uq22 a_38052_9965# VSS VSS sg13_lv_nmos ad=0.1406p pd=1.12u as=0.17255p ps=1.25u w=0.74u l=0.13u
X1888 a_9598_40746# clk VDD VDD sg13_lv_pmos ad=0.4088p pd=2.97u as=1.12945p ps=7.155u w=1.12u l=0.13u
X1889 VSS a_52186_68307# X_uq412 VSS sg13_lv_nmos ad=0.1426p pd=1.16u as=0.2516p ps=2.16u w=0.74u l=0.13u
X1890 D_uq53 X_uq445 VSS VSS sg13_lv_nmos ad=0.1694p pd=1.21u as=0.2618p ps=2.22u w=0.77u l=0.13u
X1891 Q_uq28 a_4297_43290# VSS VSS sg13_lv_nmos ad=0.2516p pd=2.16u as=0.1406p ps=1.12u w=0.74u l=0.13u
X1892 a_78179_25943# X_uq279 VSS VSS sg13_lv_nmos ad=0.187p pd=1.78u as=0.14875p ps=1.16u w=0.55u l=0.13u
X1893 X_uq18 a_39390_6937# VDD VDD sg13_lv_pmos ad=0.42p pd=2.99u as=0.2114p ps=1.54u w=1.12u l=0.13u
X1894 VSS X_uq297 Y_uq163 VSS sg13_lv_nmos ad=0.2516p pd=2.16u as=0.2516p ps=2.16u w=0.74u l=0.13u
X1895 a_4380_32906# D_uq15 VDD VDD sg13_lv_pmos ad=79.8f pd=0.8u as=0.1428p ps=1.52u w=0.42u l=0.13u
X1896 X_uq208 a_78189_23023# VSS VSS sg13_lv_nmos ad=0.2516p pd=2.16u as=0.1426p ps=1.16u w=0.74u l=0.13u
X1897 a_7321_32187# a_7345_32295# VSS VSS sg13_lv_nmos ad=0.1428p pd=1.52u as=0.1426p ps=1.16u w=0.42u l=0.5u
X1898 a_47855_68880# Y_uq332 a_47753_68880# VDD sg13_lv_pmos ad=0.2464p pd=1.56u as=0.2128p ps=1.5u w=1.12u l=0.13u
X1899 VDD a_39122_69634# a_39234_69698# VDD sg13_lv_pmos ad=0.2254p pd=1.53u as=0.34p ps=2.68u w=1u l=0.5u
X1900 VDD Y_uq265 a_38740_63620# VDD sg13_lv_pmos ad=0.2114p pd=1.54u as=0.2856p ps=2.36u w=0.84u l=0.13u
X1901 VSS a_34688_63550# Y_uq277 VSS sg13_lv_nmos ad=0.17255p pd=1.25u as=0.1406p ps=1.12u w=0.74u l=0.13u
X1902 a_78302_25253# C_uq26 a_78208_25253# VDD sg13_lv_pmos ad=0.19p pd=1.38u as=0.34p ps=2.68u w=1u l=0.13u
X1903 VDD din[14] a_75679_25229# VDD sg13_lv_pmos ad=0.2114p pd=1.54u as=0.2856p ps=2.36u w=0.84u l=0.13u
X1904 a_34108_69850# L_HI_uq39 VDD VDD sg13_lv_pmos ad=79.8f pd=0.8u as=1.6733p ps=10.405u w=0.42u l=0.13u
X1905 VDD a_6559_33047# a_6910_32958# VDD sg13_lv_pmos ad=2.4956p pd=16.32u as=93.45f ps=0.865u w=0.42u l=0.13u
X1906 VDD VSS VDD VDD sg13_lv_pmos ad=0.34p pd=2.68u as=0 ps=0 w=1u l=1u
X1907 Y_uq49 C_uq16 VSS VSS sg13_lv_nmos ad=0.1694p pd=1.21u as=0.2618p ps=2.22u w=0.77u l=0.13u
X1908 D_uq62 a_39234_69698# VSS VSS sg13_lv_nmos ad=0.2516p pd=2.16u as=0.1426p ps=1.16u w=0.74u l=0.13u
X1909 a_75726_28253# Q_uq7 a_75612_28253# VDD sg13_lv_pmos ad=0.2128p pd=1.5u as=0.2464p ps=1.56u w=1.12u l=0.13u
X1910 VDD a_48250_67635# X_uq407 VDD sg13_lv_pmos ad=0.2254p pd=1.53u as=0.4256p ps=3u w=1.12u l=0.13u
X1911 VSS Q_uq57 Y_uq314 VSS sg13_lv_nmos ad=0.2516p pd=2.16u as=0.1406p ps=1.12u w=0.74u l=0.13u
X1912 VSS X_uq326 a_5129_41075# VSS sg13_lv_nmos ad=0.2176p pd=1.96u as=81.6f ps=0.895u w=0.64u l=0.13u
X1913 Q_uq17 a_10345_37146# VSS VSS sg13_lv_nmos ad=0.2516p pd=2.16u as=0.1406p ps=1.12u w=0.74u l=0.13u
X1914 Y_uq122 C_uq20 a_11104_24183# VDD sg13_lv_pmos ad=0.3808p pd=2.92u as=0.2128p ps=1.5u w=1.12u l=0.13u
X1915 a_78625_26709# a_79068_26752# a_79008_26788# VDD sg13_lv_pmos ad=79.8f pd=0.8u as=63f ps=0.72u w=0.42u l=0.13u
X1916 a_34774_65824# a_35217_65867# a_34514_66294# VSS sg13_lv_nmos ad=79.8f pd=0.8u as=0.1296p ps=1.52u w=0.42u l=0.13u
X1917 a_5800_21123# a_6319_21130# a_7059_21480# VSS sg13_lv_nmos ad=0.3473p pd=2.71u as=0.12665p ps=1.145u w=0.74u l=0.13u
X1918 VSS a_52568_69594# A_uq15 VSS sg13_lv_nmos ad=0.14875p pd=1.16u as=0.2886p ps=2.26u w=0.74u l=0.13u
X1919 a_46714_65283# a_46829_65284# VSS VSS sg13_lv_nmos ad=0.1428p pd=1.52u as=0.1426p ps=1.16u w=0.42u l=0.5u
X1920 a_43516_64586# L_HI_uq10 VDD VDD sg13_lv_pmos ad=79.8f pd=0.8u as=1.4745p ps=9.07u w=0.42u l=0.13u
X1921 VDD a_41627_66217# a_41884_66098# VDD sg13_lv_pmos ad=1.41367p pd=8.85u as=79.8f ps=0.8u w=0.42u l=0.13u
X1922 VDD a_34619_68195# a_34876_68338# VDD sg13_lv_pmos ad=1.42837p pd=8.61u as=79.8f ps=0.8u w=0.42u l=0.13u
X1923 VDD B_uq92 Y_uq199 VDD sg13_lv_pmos ad=0.3808p pd=2.92u as=0.2128p ps=1.5u w=1.12u l=0.13u
X1924 VSS a_38182_65062# a_37901_65284# VSS sg13_lv_nmos ad=79.8f pd=0.8u as=0.1428p ps=1.52u w=0.42u l=0.5u
X1925 D_uq52 X_uq447 VSS VSS sg13_lv_nmos ad=0.1694p pd=1.21u as=0.2618p ps=2.22u w=0.77u l=0.13u
X1926 a_50168_69594# Y_uq356 VDD VDD sg13_lv_pmos ad=0.2856p pd=2.36u as=0.2114p ps=1.54u w=0.84u l=0.13u
X1927 a_36206_10067# X_uq162 VSS VSS sg13_lv_nmos ad=0.1045p pd=0.93u as=0.1469p ps=1.155u w=0.55u l=0.13u
X1928 VSS VDD VSS VSS sg13_lv_nmos ad=0.1428p pd=1.52u as=0 ps=-0 w=0.42u l=1u
X1929 VDD din[4] a_76735_29041# VDD sg13_lv_pmos ad=0.2114p pd=1.54u as=0.2856p ps=2.36u w=0.84u l=0.13u
X1930 VSS VDD VSS VSS sg13_lv_nmos ad=79.8f pd=0.8u as=0 ps=-0 w=0.42u l=1u
X1931 Y_uq258 C_uq73 VSS VSS sg13_lv_nmos ad=0.2618p pd=2.22u as=0.1463p ps=1.15u w=0.77u l=0.13u
X1932 a_39490_7625# Y_uq12 VSS VSS sg13_lv_nmos ad=0.187p pd=1.78u as=0.14875p ps=1.16u w=0.55u l=0.13u
X1933 a_7059_23458# a_6217_23360# a_6965_23458# VSS sg13_lv_nmos ad=0.12665p pd=1.145u as=0.1428p ps=1.52u w=0.42u l=0.13u
X1934 Q_uq16 a_5047_36954# VSS VSS sg13_lv_nmos ad=0.2516p pd=2.16u as=0.1406p ps=1.12u w=0.74u l=0.13u
X1935 D_uq44 C_uq55 VSS VSS sg13_lv_nmos ad=0.2618p pd=2.22u as=0.1463p ps=1.15u w=0.77u l=0.13u
X1936 a_3571_39755# a_3546_41381# a_3580_40023# VDD sg13_lv_pmos ad=0.1428p pd=1.52u as=79.8f ps=0.8u w=0.42u l=0.13u
X1937 VDD VSS VDD VDD sg13_lv_pmos ad=0.19p pd=1.38u as=0 ps=0 w=1u l=1u
X1938 a_27542_68880# X_uq455 VDD VDD sg13_lv_pmos ad=0.1176p pd=1.33u as=0.4032p ps=2.96u w=1.12u l=0.13u
X1939 VSS C_uq21 Y_uq57 VSS sg13_lv_nmos ad=0.1463p pd=1.15u as=0.1694p ps=1.21u w=0.77u l=0.13u
X1940 a_28658_66294# a_29463_65867# a_28918_65824# VDD sg13_lv_pmos ad=0.1428p pd=1.52u as=79.8f ps=0.8u w=0.42u l=0.13u
X1941 a_36502_67336# a_36945_67379# a_36242_67806# VSS sg13_lv_nmos ad=79.8f pd=0.8u as=0.1296p ps=1.52u w=0.42u l=0.13u
X1942 VDD Y_uq110 a_11057_24647# VDD sg13_lv_pmos ad=0.2114p pd=1.54u as=0.2856p ps=2.36u w=0.84u l=0.13u
X1943 VSS a_38266_66795# X_uq401 VSS sg13_lv_nmos ad=0.1426p pd=1.16u as=0.2516p ps=2.16u w=0.74u l=0.13u
X1944 a_40017_67379# clk VDD VDD sg13_lv_pmos ad=0.4088p pd=2.97u as=1.17087p ps=7.02u w=1.12u l=0.13u
X1945 Y_uq206 Q_uq25 VSS VSS sg13_lv_nmos ad=0.1406p pd=1.12u as=0.2516p ps=2.16u w=0.74u l=0.13u
X1946 X_uq97 a_44774_10301# VDD VDD sg13_lv_pmos ad=0.3976p pd=2.95u as=0.2226p ps=1.535u w=1.12u l=0.13u
X1947 X_uq352 a_35668_63620# VSS VSS sg13_lv_nmos ad=0.2886p pd=2.26u as=0.14875p ps=1.16u w=0.74u l=0.13u
X1948 X_uq34 a_33246_6937# VDD VDD sg13_lv_pmos ad=0.42p pd=2.99u as=0.2114p ps=1.54u w=1.12u l=0.13u
X1949 A_uq80 a_39494_10301# VSS VSS sg13_lv_nmos ad=0.2516p pd=2.16u as=0.1469p ps=1.155u w=0.74u l=0.13u
X1950 Y_uq3 a_38820_8453# VSS VSS sg13_lv_nmos ad=0.1406p pd=1.12u as=0.17255p ps=1.25u w=0.74u l=0.13u
X1951 a_7705_36806# Y_uq207 Y_uq188 VSS sg13_lv_nmos ad=0.1406p pd=1.12u as=0.1406p ps=1.12u w=0.74u l=0.13u
X1952 VDD Q a_6956_20395# VDD sg13_lv_pmos ad=0.2114p pd=1.54u as=0.2856p ps=2.36u w=0.84u l=0.13u
X1953 a_4754_25082# a_4869_25083# VSS VSS sg13_lv_nmos ad=0.1428p pd=1.52u as=0.1426p ps=1.16u w=0.42u l=0.5u
X1954 a_7321_34111# Q_uq14 VSS VSS sg13_lv_nmos ad=0.1428p pd=1.52u as=79.8f ps=0.8u w=0.42u l=0.13u
X1955 a_34722_9173# a_34500_9229# VDD VDD sg13_lv_pmos ad=0.1176p pd=1.33u as=0.2618p ps=1.63u w=1.12u l=0.13u
X1956 VSS a_7056_25619# B_uq65 VSS sg13_lv_nmos ad=0.14875p pd=1.16u as=0.2886p ps=2.26u w=0.74u l=0.13u
X1957 a_8873_36297# a_8837_36271# VDD VDD sg13_lv_pmos ad=0.34p pd=2.68u as=0.36237p ps=2.605u w=1u l=0.13u
X1958 a_9583_41709# a_9628_40311# VSS VSS sg13_lv_nmos ad=0.2516p pd=2.16u as=0.1626p ps=1.415u w=0.74u l=0.13u
X1959 A_uq30 a_34132_63620# VSS VSS sg13_lv_nmos ad=0.2886p pd=2.26u as=0.14875p ps=1.16u w=0.74u l=0.13u
X1960 VDD a_40184_63546# q[16] VDD sg13_lv_pmos ad=0.2114p pd=1.54u as=0.42p ps=2.99u w=1.12u l=0.13u
X1961 VSS a_48914_65098# a_49026_65162# VSS sg13_lv_nmos ad=0.1426p pd=1.16u as=0.1428p ps=1.52u w=0.42u l=0.5u
X1962 a_34780_66826# a_34523_66683# a_34942_66606# VSS sg13_lv_nmos ad=0.1428p pd=1.52u as=37.8f ps=0.6u w=0.42u l=0.13u
X1963 Y_uq338 X_uq430 a_37720_68880# VDD sg13_lv_pmos ad=0.3808p pd=2.92u as=0.1176p ps=1.33u w=1.12u l=0.13u
X1964 a_5474_31662# a_5047_32685# VDD VDD sg13_lv_pmos ad=63f pd=0.72u as=0.1563p ps=1.22u w=0.42u l=0.13u
X1965 a_9598_40746# clk VSS VSS sg13_lv_nmos ad=0.2516p pd=2.16u as=3.58025p ps=22.71u w=0.74u l=0.13u
X1966 X_uq202 a_75295_21481# VDD VDD sg13_lv_pmos ad=0.42p pd=2.99u as=0.2114p ps=1.54u w=1.12u l=0.13u
X1967 VSS q[5] a_32382_10685# VSS sg13_lv_nmos ad=0.14875p pd=1.16u as=0.187p ps=1.78u w=0.55u l=0.13u
X1968 a_46354_66281# L_HI_uq13 VSS VSS sg13_lv_nmos ad=37.8f pd=0.6u as=0.1701p ps=1.65u w=0.42u l=0.13u
X1969 a_45957_69003# a_45015_68891# a_45755_69241# VDD sg13_lv_pmos ad=93.45f pd=0.865u as=0.2048p ps=1.63u w=0.42u l=0.13u
X1970 VSS a_10349_33537# a_10385_33469# VSS sg13_lv_nmos ad=0.1626p pd=1.415u as=0.2516p ps=2.16u w=0.74u l=0.13u
X1971 VSS Y_uq303 D_uq50 VSS sg13_lv_nmos ad=0.1463p pd=1.15u as=0.1694p ps=1.21u w=0.77u l=0.13u
X1972 Y_uq91 Y_uq92 a_4891_22631# VDD sg13_lv_pmos ad=0.3808p pd=2.92u as=0.2128p ps=1.5u w=1.12u l=0.13u
X1973 a_47222_63880# X_uq448 VDD VDD sg13_lv_pmos ad=0.1176p pd=1.33u as=0.4032p ps=2.96u w=1.12u l=0.13u
X1974 a_6595_40907# D_uq31 VDD VDD sg13_lv_pmos ad=79.8f pd=0.8u as=0.1428p ps=1.52u w=0.42u l=0.13u
X1975 a_49580_66781# a_49699_66570# VDD VDD sg13_lv_pmos ad=0.3864p pd=2.93u as=0.2128p ps=1.5u w=1.12u l=0.13u
X1976 a_44219_67729# a_43377_67379# a_44125_67729# VSS sg13_lv_nmos ad=0.12665p pd=1.145u as=0.1428p ps=1.52u w=0.42u l=0.13u
X1977 VDD a_43738_68307# X_uq413 VDD sg13_lv_pmos ad=0.2254p pd=1.53u as=0.4256p ps=3u w=1.12u l=0.13u
X1978 a_7321_40826# A0 VSS VSS sg13_lv_nmos ad=0.187p pd=1.78u as=0.14505p ps=1.15u w=0.55u l=0.13u
X1979 Y_uq256 a_27706_64400# VSS VSS sg13_lv_nmos ad=0.1406p pd=1.12u as=0.17255p ps=1.25u w=0.74u l=0.13u
X1980 VDD a_37187_63663# a_37187_63897# VDD sg13_lv_pmos ad=1.4745p pd=9.07u as=0.2442p ps=2.06u w=0.66u l=0.13u
X1981 VSS a_33850_65283# X_uq379 VSS sg13_lv_nmos ad=0.1426p pd=1.16u as=0.2516p ps=2.16u w=0.74u l=0.13u
X1982 VDD a_10468_36599# a_10504_36510# VDD sg13_lv_pmos ad=1.17462p pd=7.44u as=93.45f ps=0.865u w=0.42u l=0.13u
X1983 VDD L_HI_uq22 a_28658_66294# VDD sg13_lv_pmos ad=0.36237p pd=2.605u as=79.8f ps=0.8u w=0.42u l=0.13u
X1984 VDD a_10385_33469# a_10428_33120# VDD sg13_lv_pmos ad=0.1563p pd=1.22u as=63f ps=0.72u w=0.42u l=0.13u
X1985 VDD Y_uq250 a_41236_63620# VDD sg13_lv_pmos ad=0.2114p pd=1.54u as=0.2856p ps=2.36u w=0.84u l=0.13u
X1986 a_44866_7625# X_uq98 VDD VDD sg13_lv_pmos ad=0.2856p pd=2.36u as=0.2114p ps=1.54u w=0.84u l=0.13u
X1987 VDD L_HI_uq5 a_5774_25116# VDD sg13_lv_pmos ad=0.1563p pd=1.22u as=0.147p ps=1.54u w=0.42u l=0.13u
X1988 VSS A2_uq3 a_76285_22981# VSS sg13_lv_nmos ad=0.2516p pd=2.16u as=0.1406p ps=1.12u w=0.74u l=0.13u
X1989 VSS q[1] a_34014_7661# VSS sg13_lv_nmos ad=0.14875p pd=1.16u as=0.187p ps=1.78u w=0.55u l=0.13u
X1990 a_42562_7625# A_uq72 VSS VSS sg13_lv_nmos ad=0.187p pd=1.78u as=0.14875p ps=1.16u w=0.55u l=0.13u
X1991 VDD a_8075_34111# a_8111_34043# VDD sg13_lv_pmos ad=0.1523p pd=1.38u as=0.34p ps=2.68u w=1u l=0.5u
X1992 VSS C1_uq5 C_uq26 VSS sg13_lv_nmos ad=0.1406p pd=1.12u as=0.2516p ps=2.16u w=0.74u l=0.13u
X1993 a_49912_66606# a_49699_66570# VDD VDD sg13_lv_pmos ad=79.8f pd=0.8u as=1.19383p ps=7.16u w=0.42u l=0.13u
X1994 VDD a_32216_68082# q[2] VDD sg13_lv_pmos ad=0.2114p pd=1.54u as=0.42p ps=2.99u w=1.12u l=0.13u
X1995 a_7346_22058# a_7461_22059# VSS VSS sg13_lv_nmos ad=0.1428p pd=1.52u as=0.1426p ps=1.16u w=0.42u l=0.5u
X1996 a_5087_39700# a_5051_39674# B_uq92 VSS sg13_lv_nmos ad=0.1406p pd=1.12u as=0.333p ps=2.38u w=0.74u l=0.13u
X1997 a_29138_63586# a_28868_63586# VDD VDD sg13_lv_pmos ad=0.34p pd=2.68u as=0.1523p ps=1.38u w=1u l=0.5u
X1998 a_51610_63771# a_51725_63772# VSS VSS sg13_lv_nmos ad=0.1428p pd=1.52u as=0.1426p ps=1.16u w=0.42u l=0.5u
X1999 VSS a_6217_21130# a_6319_21130# VSS sg13_lv_nmos ad=2.0486p pd=12.405u as=0.2516p ps=2.16u w=0.74u l=0.13u
X2000 VSS din[21] a_75295_21481# VSS sg13_lv_nmos ad=0.14875p pd=1.16u as=0.187p ps=1.78u w=0.55u l=0.13u
X2001 VDD L_HI_uq33 a_50162_64782# VDD sg13_lv_pmos ad=0.36237p pd=2.605u as=79.8f ps=0.8u w=0.42u l=0.13u
X2002 a_50582_69928# X_uq446 VDD VDD sg13_lv_pmos ad=0.1176p pd=1.33u as=0.4032p ps=2.96u w=1.12u l=0.13u
X2003 VSS A_uq92 a_32862_7661# VSS sg13_lv_nmos ad=0.14875p pd=1.16u as=0.187p ps=1.78u w=0.55u l=0.13u
X2004 VDD a_42779_69707# a_43446_69928# VDD sg13_lv_pmos ad=0.2128p pd=1.5u as=0.3864p ps=2.93u w=1.12u l=0.13u
X2005 a_37787_67729# a_36945_67379# a_36528_67372# VDD sg13_lv_pmos ad=0.2048p pd=1.63u as=0.34p ps=2.68u w=1u l=0.13u
X2006 VSS a_41410_6863# X_uq13 VSS sg13_lv_nmos ad=0.14875p pd=1.16u as=0.2886p ps=2.26u w=0.74u l=0.13u
X2007 VSS D_uq1 Y_uq68 VSS sg13_lv_nmos ad=0.23757p pd=2.16u as=0.1406p ps=1.12u w=0.74u l=0.13u
X2008 VSS B2_uq7 a_77047_25577# VSS sg13_lv_nmos ad=0.1406p pd=1.12u as=0.1406p ps=1.12u w=0.74u l=0.13u
X2009 VDD a_46786_7625# X_uq37 VDD sg13_lv_pmos ad=0.2114p pd=1.54u as=0.42p ps=2.99u w=1.12u l=0.13u
X2010 a_36240_69948# a_36214_69853# VSS VSS sg13_lv_nmos ad=0.2516p pd=2.16u as=0.1626p ps=1.415u w=0.74u l=0.13u
X2011 a_80085_21695# a_79886_21758# VSS VSS sg13_lv_nmos ad=0.27427p pd=2.28u as=2.61888p ps=17.445u w=0.795u l=0.13u
X2012 VSS X_uq338 a_40062_10685# VSS sg13_lv_nmos ad=0.14875p pd=1.16u as=0.187p ps=1.78u w=0.55u l=0.13u
X2013 VDD B_uq63 C_uq1 VDD sg13_lv_pmos ad=0.2128p pd=1.5u as=0.2128p ps=1.5u w=1.12u l=0.13u
X2014 VSS a_44482_7625# X_uq137 VSS sg13_lv_nmos ad=0.14875p pd=1.16u as=0.2886p ps=2.26u w=0.74u l=0.13u
X2015 VDD X_uq201 a_77347_21741# VDD sg13_lv_pmos ad=0.4032p pd=2.96u as=0.1176p ps=1.33u w=1.12u l=0.13u
X2016 VDD a_45634_6863# X_uq2 VDD sg13_lv_pmos ad=0.2114p pd=1.54u as=0.42p ps=2.99u w=1.12u l=0.13u
X2017 VDD L_HI_uq6 a_3854_24111# VDD sg13_lv_pmos ad=0.1563p pd=1.22u as=0.147p ps=1.54u w=0.42u l=0.13u
X2018 VSS VDD VSS VSS sg13_lv_nmos ad=0.1428p pd=1.52u as=0 ps=-0 w=0.42u l=1u
X2019 VSS VDD VSS VSS sg13_lv_nmos ad=79.8f pd=0.8u as=0 ps=-0 w=0.42u l=1u
X2020 X_uq262 a_75295_26017# VSS VSS sg13_lv_nmos ad=0.2886p pd=2.26u as=0.14875p ps=1.16u w=0.74u l=0.13u
X2021 VSS X_uq89 a_34980_9229# VSS sg13_lv_nmos ad=0.17255p pd=1.25u as=0.187p ps=1.78u w=0.55u l=0.13u
X2022 a_5849_41193# a_5813_41167# VDD VDD sg13_lv_pmos ad=0.34p pd=2.68u as=0.36237p ps=2.605u w=1u l=0.13u
X2023 a_45590_63880# X_uq448 VDD VDD sg13_lv_pmos ad=0.1176p pd=1.33u as=0.4032p ps=2.96u w=1.12u l=0.13u
X2024 VDD a_36059_66217# a_36316_66098# VDD sg13_lv_pmos ad=1.41367p pd=8.85u as=79.8f ps=0.8u w=0.42u l=0.13u
X2025 VDD X_uq435 a_34223_65856# VDD sg13_lv_pmos ad=0.3808p pd=2.92u as=0.2464p ps=1.56u w=1.12u l=0.13u
X2026 a_39122_69634# a_38852_69634# VSS VSS sg13_lv_nmos ad=0.1428p pd=1.52u as=79.8f ps=0.8u w=0.42u l=0.5u
X2027 VSS Y_uq167 a_5083_31113# VSS sg13_lv_nmos ad=0.1626p pd=1.415u as=60.89999f ps=0.71u w=0.42u l=0.13u
X2028 X_uq431 a_42292_68880# VSS VSS sg13_lv_nmos ad=0.2886p pd=2.26u as=0.14875p ps=1.16u w=0.74u l=0.13u
X2029 a_78208_25253# B_uq51 VSS VSS sg13_lv_nmos ad=0.198p pd=1.27u as=0.1045p ps=0.93u w=0.55u l=0.13u
X2030 a_5083_31019# a_5058_32645# a_5092_31287# VDD sg13_lv_pmos ad=0.1428p pd=1.52u as=79.8f ps=0.8u w=0.42u l=0.13u
X2031 a_27638_67368# X_uq420 VDD VDD sg13_lv_pmos ad=0.1176p pd=1.33u as=0.4032p ps=2.96u w=1.12u l=0.13u
X2032 VSS a_47302_68844# a_47021_69146# VSS sg13_lv_nmos ad=79.8f pd=0.8u as=0.1428p ps=1.52u w=0.42u l=0.5u
X2033 a_32592_69948# a_32566_69853# VSS VSS sg13_lv_nmos ad=0.2516p pd=2.16u as=0.1626p ps=1.415u w=0.74u l=0.13u
X2034 VDD a_46808_69594# X_uq448 VDD sg13_lv_pmos ad=0.2114p pd=1.54u as=0.42p ps=2.99u w=1.12u l=0.13u
X2035 VDD a_29818_66795# X_uq405 VDD sg13_lv_pmos ad=0.2254p pd=1.53u as=0.4256p ps=3u w=1.12u l=0.13u
X2036 a_32024_67332# Q_uq39 VSS VSS sg13_lv_nmos ad=0.187p pd=1.78u as=0.14875p ps=1.16u w=0.55u l=0.13u
X2037 VDD L_HI_uq31 a_49750_68341# VDD sg13_lv_pmos ad=0.1563p pd=1.22u as=0.147p ps=1.54u w=0.42u l=0.13u
X2038 B1_uq5 Q_uq6 VSS VSS sg13_lv_nmos ad=0.1406p pd=1.12u as=0.2516p ps=2.16u w=0.74u l=0.13u
X2039 C_uq30 B_uq77 a_5845_32591# VDD sg13_lv_pmos ad=0.3808p pd=2.92u as=0.1176p ps=1.33u w=1.12u l=0.13u
X2040 a_29830_65062# Q_uq58 VSS VSS sg13_lv_nmos ad=0.1428p pd=1.52u as=79.8f ps=0.8u w=0.42u l=0.13u
X2041 a_43516_64586# a_43259_64705# a_43678_64782# VSS sg13_lv_nmos ad=0.1428p pd=1.52u as=37.8f ps=0.6u w=0.42u l=0.13u
X2042 VDD a_35747_68199# a_35747_68433# VDD sg13_lv_pmos ad=1.42837p pd=8.61u as=0.2442p ps=2.06u w=0.66u l=0.13u
X2043 VSS a_80167_24687# a_79816_24544# VSS sg13_lv_nmos ad=79.8f pd=0.8u as=0.1428p ps=1.52u w=0.42u l=0.13u
X2044 VSS a_79043_25943# C_uq23 VSS sg13_lv_nmos ad=0.14875p pd=1.16u as=0.2886p ps=2.26u w=0.74u l=0.13u
X2045 a_5811_42044# clk VSS VSS sg13_lv_nmos ad=0.2516p pd=2.16u as=4.5562p ps=29.965u w=0.74u l=0.13u
X2046 q[4] a_27316_64344# VDD VDD sg13_lv_pmos ad=0.42p pd=2.99u as=0.2114p ps=1.54u w=1.12u l=0.13u
X2047 D_uq57 a_28770_68186# VSS VSS sg13_lv_nmos ad=0.2516p pd=2.16u as=0.1426p ps=1.16u w=0.74u l=0.13u
X2048 a_32192_63550# X_uq458 VSS VSS sg13_lv_nmos ad=0.187p pd=1.78u as=0.17255p ps=1.25u w=0.55u l=0.13u
X2049 a_40656_66281# a_40368_65860# a_40594_66281# VSS sg13_lv_nmos ad=0.1428p pd=1.52u as=37.8f ps=0.6u w=0.42u l=0.13u
X2050 VDD a_44860_66098# a_44805_65979# VDD sg13_lv_pmos ad=1.41367p pd=8.85u as=93.45f ps=0.865u w=0.42u l=0.13u
X2051 a_37443_65392# Y_uq267 a_37329_65392# VDD sg13_lv_pmos ad=0.2128p pd=1.5u as=0.2464p ps=1.56u w=1.12u l=0.13u
X2052 VDD L_HI_uq20 a_37366_65824# VDD sg13_lv_pmos ad=0.1563p pd=1.22u as=0.147p ps=1.54u w=0.42u l=0.13u
X2053 C_uq65 Q_uq44 VSS VSS sg13_lv_nmos ad=0.1406p pd=1.12u as=0.2516p ps=2.16u w=0.74u l=0.13u
X2054 VDD X_uq145 a_41214_10685# VDD sg13_lv_pmos ad=0.2114p pd=1.54u as=0.2856p ps=2.36u w=0.84u l=0.13u
X2055 VSS B1_uq6 a_77240_27089# VSS sg13_lv_nmos ad=0.2516p pd=2.16u as=0.1406p ps=1.12u w=0.74u l=0.13u
X2056 a_28937_67368# C_uq61 Y_uq328 VDD sg13_lv_pmos ad=0.2128p pd=1.5u as=0.3808p ps=2.92u w=1.12u l=0.13u
X2057 a_10624_24183# C_uq22 a_10510_24183# VDD sg13_lv_pmos ad=0.2128p pd=1.5u as=0.2464p ps=1.56u w=1.12u l=0.13u
X2058 VDD Y_uq366 a_27700_69668# VDD sg13_lv_pmos ad=0.2114p pd=1.54u as=0.2856p ps=2.36u w=0.84u l=0.13u
X2059 VSS a_9583_41879# a_9619_41811# VSS sg13_lv_nmos ad=79.8f pd=0.8u as=0.1428p ps=1.52u w=0.42u l=0.13u
X2060 VSS a_78757_29192# X_uq279 VSS sg13_lv_nmos ad=0.1426p pd=1.16u as=0.2516p ps=2.16u w=0.74u l=0.13u
X2061 a_45094_65062# Q_uq36 VSS VSS sg13_lv_nmos ad=0.1428p pd=1.52u as=79.8f ps=0.8u w=0.42u l=0.13u
X2062 VSS X_uq438 C_uq72 VSS sg13_lv_nmos ad=0.2516p pd=2.16u as=0.1406p ps=1.12u w=0.74u l=0.13u
X2063 VDD C_uq21 a_11957_19647# VDD sg13_lv_pmos ad=0.4032p pd=2.96u as=0.1176p ps=1.33u w=1.12u l=0.13u
X2064 VDD Y_uq34 a_9329_17875# VDD sg13_lv_pmos ad=0.2114p pd=1.54u as=0.2856p ps=2.36u w=0.84u l=0.13u
X2065 a_41508_9149# B_uq19 a_41414_9149# VDD sg13_lv_pmos ad=0.1596p pd=1.22u as=0.2856p ps=2.36u w=0.84u l=0.13u
X2066 a_43738_68307# a_43853_68308# VSS VSS sg13_lv_nmos ad=0.1428p pd=1.52u as=0.1426p ps=1.16u w=0.42u l=0.5u
X2067 VDD a_40642_7625# X_uq49 VDD sg13_lv_pmos ad=0.2114p pd=1.54u as=0.42p ps=2.99u w=1.12u l=0.13u
X2068 a_44866_8375# A_uq19 VDD VDD sg13_lv_pmos ad=0.2856p pd=2.36u as=0.2114p ps=1.54u w=0.84u l=0.13u
X2069 Y_uq10 X_uq144 VSS VSS sg13_lv_nmos ad=0.1406p pd=1.12u as=0.2516p ps=2.16u w=0.74u l=0.13u
X2070 VSS Y_uq326 Y_uq324 VSS sg13_lv_nmos ad=0.1463p pd=1.15u as=0.1694p ps=1.21u w=0.77u l=0.13u
X2071 a_36657_69609# clk VDD VDD sg13_lv_pmos ad=0.4088p pd=2.97u as=1.621p ps=10.08u w=1.12u l=0.13u
X2072 VDD a_51035_68195# a_51702_68416# VDD sg13_lv_pmos ad=0.2128p pd=1.5u as=0.3864p ps=2.93u w=1.12u l=0.13u
X2073 VSS Y_uq263 a_41060_65098# VSS sg13_lv_nmos ad=79.8f pd=0.8u as=0.1428p ps=1.52u w=0.42u l=0.13u
X2074 C_uq0 a_76063_18457# VDD VDD sg13_lv_pmos ad=0.42p pd=2.99u as=0.2114p ps=1.54u w=1.12u l=0.13u
X2075 C_uq65 X_uq429 a_37718_68416# VDD sg13_lv_pmos ad=0.3808p pd=2.92u as=0.1176p ps=1.33u w=1.12u l=0.13u
X2076 VDD Y_uq239 a_35668_63620# VDD sg13_lv_pmos ad=0.2114p pd=1.54u as=0.2856p ps=2.36u w=0.84u l=0.13u
X2077 B_uq23 a_38910_10685# VDD VDD sg13_lv_pmos ad=0.42p pd=2.99u as=0.2114p ps=1.54u w=1.12u l=0.13u
X2078 X_uq206 a_75679_22205# VDD VDD sg13_lv_pmos ad=0.42p pd=2.99u as=0.2114p ps=1.54u w=1.12u l=0.13u
X2079 VSS q[18] a_39678_10685# VSS sg13_lv_nmos ad=0.14875p pd=1.16u as=0.187p ps=1.78u w=0.55u l=0.13u
X2080 a_6217_23360# clk VSS VSS sg13_lv_nmos ad=0.2516p pd=2.16u as=1.6335p ps=10.61u w=0.74u l=0.13u
X2081 a_78074_20693# C_uq29 a_77972_20693# VDD sg13_lv_pmos ad=0.2464p pd=1.56u as=0.2128p ps=1.5u w=1.12u l=0.13u
X2082 VDD Y_uq309 a_34132_63620# VDD sg13_lv_pmos ad=0.2114p pd=1.54u as=0.2856p ps=2.36u w=0.84u l=0.13u
X2083 Y_uq40 D_uq7 VSS VSS sg13_lv_nmos ad=0.1694p pd=1.21u as=0.1463p ps=1.15u w=0.77u l=0.13u
X2084 a_4297_24154# clk VSS VSS sg13_lv_nmos ad=0.2516p pd=2.16u as=2.36857p ps=14.835u w=0.74u l=0.13u
X2085 VSS q[16] a_38142_10685# VSS sg13_lv_nmos ad=0.14875p pd=1.16u as=0.187p ps=1.78u w=0.55u l=0.13u
X2086 a_44476_67610# a_44219_67729# a_44638_67806# VSS sg13_lv_nmos ad=0.1428p pd=1.52u as=37.8f ps=0.6u w=0.42u l=0.13u
X2087 C_uq54 X_uq375 a_40790_65392# VDD sg13_lv_pmos ad=0.3808p pd=2.92u as=0.1176p ps=1.33u w=1.12u l=0.13u
X2088 a_35217_65867# clk VSS VSS sg13_lv_nmos ad=0.2516p pd=2.16u as=1.7977p ps=11.53u w=0.74u l=0.13u
X2089 a_33009_69609# clk VDD VDD sg13_lv_pmos ad=0.4088p pd=2.97u as=1.621p ps=10.08u w=1.12u l=0.13u
X2090 Y_uq249 Q_uq30 a_40984_64344# VDD sg13_lv_pmos ad=0.3808p pd=2.92u as=0.1176p ps=1.33u w=1.12u l=0.13u
X2091 A2_uq1 a_77248_23741# VSS VSS sg13_lv_nmos ad=0.2516p pd=2.16u as=0.13395p ps=1.12u w=0.74u l=0.13u
X2092 VSS a_36657_69609# a_36759_69752# VSS sg13_lv_nmos ad=2.01085p pd=12.81u as=0.2516p ps=2.16u w=0.74u l=0.13u
X2093 a_28280_69594# X_uq458 VDD VDD sg13_lv_pmos ad=0.2856p pd=2.36u as=0.2114p ps=1.54u w=0.84u l=0.13u
X2094 VDD L_HI_uq34 a_47734_69853# VDD sg13_lv_pmos ad=0.1563p pd=1.22u as=0.147p ps=1.54u w=0.42u l=0.13u
X2095 a_51707_64705# a_50865_64355# a_51613_64705# VSS sg13_lv_nmos ad=0.12665p pd=1.145u as=0.1428p ps=1.52u w=0.42u l=0.13u
X2096 a_45842_66294# D_uq42 VDD VDD sg13_lv_pmos ad=79.8f pd=0.8u as=0.1428p ps=1.52u w=0.42u l=0.13u
X2097 VSS din[27] a_76063_18457# VSS sg13_lv_nmos ad=0.14875p pd=1.16u as=0.187p ps=1.78u w=0.55u l=0.13u
X2098 D_uq40 a_33282_65162# VDD VDD sg13_lv_pmos ad=0.4256p pd=3u as=0.2254p ps=1.53u w=1.12u l=0.13u
X2099 X_uq96 a_45254_10301# VSS VSS sg13_lv_nmos ad=0.2516p pd=2.16u as=0.1469p ps=1.155u w=0.74u l=0.13u
X2100 VSS X_uq326 a_5087_42292# VSS sg13_lv_nmos ad=0.14505p pd=1.15u as=0.1406p ps=1.12u w=0.74u l=0.13u
X2101 VSS Y_uq334 Y_uq319 VSS sg13_lv_nmos ad=0.1463p pd=1.15u as=0.1694p ps=1.21u w=0.77u l=0.13u
X2102 a_10137_20869# a_10078_21061# C_uq5 VSS sg13_lv_nmos ad=0.1406p pd=1.12u as=0.3404p ps=2.4u w=0.74u l=0.13u
X2103 VDD a_77699_18383# B_uq32 VDD sg13_lv_pmos ad=0.2114p pd=1.54u as=0.42p ps=2.99u w=1.12u l=0.13u
X2104 VDD a_80593_25947# a_80312_26169# VDD sg13_lv_pmos ad=0.1523p pd=1.38u as=0.34p ps=2.68u w=1u l=0.5u
X2105 VDD a_4944_25619# X_uq259 VDD sg13_lv_pmos ad=0.2114p pd=1.54u as=0.42p ps=2.99u w=1.12u l=0.13u
X2106 a_28600_67368# a_28378_67424# VDD VDD sg13_lv_pmos ad=0.1176p pd=1.33u as=0.2618p ps=1.63u w=1.12u l=0.13u
X2107 a_5087_37951# B_uq88 Y_uq199 VSS sg13_lv_nmos ad=0.1406p pd=1.12u as=0.2516p ps=2.16u w=0.74u l=0.13u
X2108 a_43138_9137# q[23] VDD VDD sg13_lv_pmos ad=0.2856p pd=2.36u as=0.2114p ps=1.54u w=0.84u l=0.13u
X2109 VSS a_37809_65867# a_37911_65867# VSS sg13_lv_nmos ad=1.8643p pd=11.96u as=0.2516p ps=2.16u w=0.74u l=0.13u
X2110 a_45976_67806# a_45763_67332# VDD VDD sg13_lv_pmos ad=79.8f pd=0.8u as=1.19383p ps=7.16u w=0.42u l=0.13u
X2111 VSS Y_uq281 D_uq46 VSS sg13_lv_nmos ad=0.1463p pd=1.15u as=0.1694p ps=1.21u w=0.77u l=0.13u
X2112 VDD L_HI_uq6 a_3594_24581# VDD sg13_lv_pmos ad=0.36237p pd=2.605u as=79.8f ps=0.8u w=0.42u l=0.13u
X2113 VSS a_41026_7625# X_uq48 VSS sg13_lv_nmos ad=0.14875p pd=1.16u as=0.2886p ps=2.26u w=0.74u l=0.13u
X2114 a_33634_8375# SLN[1] VDD VDD sg13_lv_pmos ad=0.2856p pd=2.36u as=0.2114p ps=1.54u w=0.84u l=0.13u
X2115 VDD a_47302_68844# a_47021_69146# VDD sg13_lv_pmos ad=0.1523p pd=1.38u as=0.34p ps=2.68u w=1u l=0.5u
X2116 a_41974_64312# a_42417_64355# a_42357_64391# VDD sg13_lv_pmos ad=79.8f pd=0.8u as=63f ps=0.72u w=0.42u l=0.13u
X2117 a_32969_67368# C_uq60 D_uq56 VDD sg13_lv_pmos ad=0.2128p pd=1.5u as=0.3808p ps=2.92u w=1.12u l=0.13u
X2118 VSS A_uq87 a_40646_8789# VSS sg13_lv_nmos ad=0.1469p pd=1.155u as=0.1045p ps=0.93u w=0.55u l=0.13u
X2119 VSS Q_uq46 a_32980_63620# VSS sg13_lv_nmos ad=0.14875p pd=1.16u as=0.187p ps=1.78u w=0.55u l=0.13u
X2120 a_51320_69594# Y_uq353 VSS VSS sg13_lv_nmos ad=0.187p pd=1.78u as=0.14875p ps=1.16u w=0.55u l=0.13u
X2121 VSS B_uq32 C1 VSS sg13_lv_nmos ad=0.1463p pd=1.15u as=0.1694p ps=1.21u w=0.77u l=0.13u
X2122 SLN[9] a_32596_63620# VSS VSS sg13_lv_nmos ad=0.2886p pd=2.26u as=0.14875p ps=1.16u w=0.74u l=0.13u
X2123 Y_uq144 B1_uq6 a_76171_27517# VSS sg13_lv_nmos ad=0.2516p pd=2.16u as=0.1406p ps=1.12u w=0.74u l=0.13u
X2124 a_29818_66795# a_29933_66796# VSS VSS sg13_lv_nmos ad=0.1428p pd=1.52u as=0.1426p ps=1.16u w=0.42u l=0.5u
X2125 VDD a_44998_68086# a_44717_68308# VDD sg13_lv_pmos ad=0.1523p pd=1.38u as=0.34p ps=2.68u w=1u l=0.5u
X2126 VDD X_uq70 a_37086_6937# VDD sg13_lv_pmos ad=0.2114p pd=1.54u as=0.2856p ps=2.36u w=0.84u l=0.13u
X2127 a_49112_63546# Q_uq54 VDD VDD sg13_lv_pmos ad=0.2856p pd=2.36u as=0.2114p ps=1.54u w=0.84u l=0.13u
X2128 a_80167_26983# L_HI_uq7 VDD VDD sg13_lv_pmos ad=79.8f pd=0.8u as=2.04445p ps=13.405u w=0.42u l=0.13u
X2129 VDD X_uq341 a_39294_10685# VDD sg13_lv_pmos ad=0.2114p pd=1.54u as=0.2856p ps=2.36u w=0.84u l=0.13u
X2130 a_42051_68880# Y_uq337 a_41937_68880# VDD sg13_lv_pmos ad=0.2128p pd=1.5u as=0.2464p ps=1.56u w=1.12u l=0.13u
X2131 a_10428_35594# a_10383_35831# a_10349_35023# VDD sg13_lv_pmos ad=0.1428p pd=1.52u as=79.8f ps=0.8u w=0.42u l=0.13u
X2132 a_45634_6863# Y_uq9 VDD VDD sg13_lv_pmos ad=0.2856p pd=2.36u as=0.2114p ps=1.54u w=0.84u l=0.13u
X2133 a_3584_35625# a_3535_36717# a_3584_35563# VSS sg13_lv_nmos ad=0.1428p pd=1.52u as=37.8f ps=0.6u w=0.42u l=0.13u
X2134 a_52156_67610# a_51899_67729# a_52318_67806# VSS sg13_lv_nmos ad=0.1428p pd=1.52u as=37.8f ps=0.6u w=0.42u l=0.13u
X2135 VDD a_41116_67610# a_41061_67491# VDD sg13_lv_pmos ad=1.19383p pd=7.16u as=93.45f ps=0.865u w=0.42u l=0.13u
X2136 Q_uq50 a_49686_69928# VDD VDD sg13_lv_pmos ad=0.3808p pd=2.92u as=0.2128p ps=1.5u w=1.12u l=0.13u
X2137 a_37386_63834# a_37187_63897# VSS VSS sg13_lv_nmos ad=0.27427p pd=2.28u as=3.5825p ps=23.78u w=0.795u l=0.13u
X2138 a_51608_68844# Q_uq43 VSS VSS sg13_lv_nmos ad=0.187p pd=1.78u as=0.14875p ps=1.16u w=0.55u l=0.13u
X2139 X_uq235 a_11057_24647# VSS VSS sg13_lv_nmos ad=0.2886p pd=2.26u as=0.14875p ps=1.16u w=0.74u l=0.13u
X2140 a_3584_40329# a_3546_41381# a_3580_40023# VSS sg13_lv_nmos ad=0.2373p pd=1.97u as=79.8f ps=0.8u w=0.42u l=0.13u
X2141 X_uq452 a_40084_69668# VDD VDD sg13_lv_pmos ad=0.42p pd=2.99u as=0.2114p ps=1.54u w=1.12u l=0.13u
X2142 VDD a_35770_65283# X_uq387 VDD sg13_lv_pmos ad=0.2254p pd=1.53u as=0.4256p ps=3u w=1.12u l=0.13u
X2143 a_37934_9489# B_uq27 a_38076_9149# VDD sg13_lv_pmos ad=0.2856p pd=2.36u as=0.1596p ps=1.22u w=0.84u l=0.13u
X2144 VSS a_8075_40255# a_8111_40187# VSS sg13_lv_nmos ad=79.8f pd=0.8u as=0.1428p ps=1.52u w=0.42u l=0.5u
X2145 a_7357_35257# B_uq81 a_7357_35155# VDD sg13_lv_pmos ad=0.2128p pd=1.5u as=0.2128p ps=1.5u w=1.12u l=0.13u
X2146 X_uq145 a_40734_9173# VDD VDD sg13_lv_pmos ad=0.42p pd=2.99u as=0.2114p ps=1.54u w=1.12u l=0.13u
X2147 X_uq96 a_45254_10301# VDD VDD sg13_lv_pmos ad=0.3976p pd=2.95u as=0.2226p ps=1.535u w=1.12u l=0.13u
X2148 VSS X_uq412 C_uq58 VSS sg13_lv_nmos ad=0.2516p pd=2.16u as=0.1406p ps=1.12u w=0.74u l=0.13u
X2149 VSS VDD VSS VSS sg13_lv_nmos ad=0.1428p pd=1.52u as=0 ps=-0 w=0.42u l=1u
X2150 VDD a_6559_33211# a_6559_33047# VDD sg13_lv_pmos ad=2.4956p pd=16.32u as=79.8f ps=0.8u w=0.42u l=0.13u
X2151 q[4] a_27316_64344# VSS VSS sg13_lv_nmos ad=0.2886p pd=2.26u as=0.14875p ps=1.16u w=0.74u l=0.13u
X2152 VDD Y_uq206 Y_uq208 VDD sg13_lv_pmos ad=0.3808p pd=2.92u as=0.2128p ps=1.5u w=1.12u l=0.13u
X2153 VSS X_uq375 C_uq54 VSS sg13_lv_nmos ad=0.2516p pd=2.16u as=0.1406p ps=1.12u w=0.74u l=0.13u
X2154 VSS a_44482_8375# X_uq59 VSS sg13_lv_nmos ad=0.14875p pd=1.16u as=0.2886p ps=2.26u w=0.74u l=0.13u
X2155 a_45297_64344# X_uq445 VDD VDD sg13_lv_pmos ad=0.2464p pd=1.56u as=0.3808p ps=2.92u w=1.12u l=0.13u
X2156 X_uq203 a_12593_21623# VSS VSS sg13_lv_nmos ad=0.2886p pd=2.26u as=0.14875p ps=1.16u w=0.74u l=0.13u
X2157 VDD a_32024_67332# q[3] VDD sg13_lv_pmos ad=0.2114p pd=1.54u as=0.42p ps=2.99u w=1.12u l=0.13u
X2158 a_44304_69318# D_uq58 a_44210_69318# VSS sg13_lv_nmos ad=60.89999f pd=0.71u as=0.1428p ps=1.52u w=0.42u l=0.13u
X2159 VSS B_uq3 a_38414_9489# VSS sg13_lv_nmos ad=0.187p pd=1.78u as=0.1045p ps=0.93u w=0.55u l=0.13u
X2160 a_8498_41454# a_8071_42477# VDD VDD sg13_lv_pmos ad=63f pd=0.72u as=0.1563p ps=1.22u w=0.42u l=0.13u
X2161 a_5051_41401# a_5087_41723# VSS VSS sg13_lv_nmos ad=0.1428p pd=1.52u as=0.1426p ps=1.16u w=0.42u l=0.5u
X2162 D_uq61 C_uq69 VSS VSS sg13_lv_nmos ad=0.2618p pd=2.22u as=0.1463p ps=1.15u w=0.77u l=0.13u
X2163 VDD q[4] a_34302_8449# VDD sg13_lv_pmos ad=0.2114p pd=1.54u as=0.2856p ps=2.36u w=0.84u l=0.13u
X2164 a_78455_20980# a_78574_20657# VDD VDD sg13_lv_pmos ad=0.3864p pd=2.93u as=0.2128p ps=1.5u w=1.12u l=0.13u
X2165 a_80333_21118# a_79155_21054# a_79937_20973# VSS sg13_lv_nmos ad=37.8f pd=0.6u as=0.1428p ps=1.52u w=0.42u l=0.13u
X2166 a_51909_64467# a_50967_64355# a_51707_64705# VDD sg13_lv_pmos ad=93.45f pd=0.865u as=0.2048p ps=1.63u w=0.42u l=0.13u
X2167 VDD Y_uq74 a_78671_22959# VDD sg13_lv_pmos ad=0.1523p pd=1.38u as=0.1428p ps=1.52u w=0.42u l=0.13u
X2168 VDD X_uq436 a_28559_63880# VDD sg13_lv_pmos ad=0.3808p pd=2.92u as=0.2464p ps=1.56u w=1.12u l=0.13u
X2169 VSS reset a_40084_69668# VSS sg13_lv_nmos ad=0.14875p pd=1.16u as=0.187p ps=1.78u w=0.55u l=0.13u
X2170 VDD X_uq436 a_27695_65392# VDD sg13_lv_pmos ad=0.3808p pd=2.92u as=0.2464p ps=1.56u w=1.12u l=0.13u
X2171 X_uq179 a_75679_18457# VSS VSS sg13_lv_nmos ad=0.2886p pd=2.26u as=0.14875p ps=1.16u w=0.74u l=0.13u
X2172 a_78077_22959# a_77807_22959# VSS VSS sg13_lv_nmos ad=0.1428p pd=1.52u as=79.8f ps=0.8u w=0.42u l=0.5u
X2173 a_42934_67336# a_43377_67379# a_43317_67415# VDD sg13_lv_pmos ad=79.8f pd=0.8u as=63f ps=0.72u w=0.42u l=0.13u
X2174 VDD a_6574_41610# a_6570_42533# VDD sg13_lv_pmos ad=2.4956p pd=16.32u as=0.3864p ps=2.93u w=1.12u l=0.13u
X2175 VDD Y_uq357 a_44500_66644# VDD sg13_lv_pmos ad=0.2114p pd=1.54u as=0.2856p ps=2.36u w=0.84u l=0.13u
X2176 VSS VDD VSS VSS sg13_lv_nmos ad=79.8f pd=0.8u as=0 ps=-0 w=0.42u l=1u
X2177 VSS a_80197_23984# X_uq215 VSS sg13_lv_nmos ad=0.1426p pd=1.16u as=0.2516p ps=2.16u w=0.74u l=0.13u
X2178 a_44074_8379# X_uq59 VDD VDD sg13_lv_pmos ad=0.2856p pd=2.36u as=0.2618p ps=1.63u w=0.84u l=0.13u
X2179 a_29734_68086# Q_uq57 VSS VSS sg13_lv_nmos ad=0.1428p pd=1.52u as=79.8f ps=0.8u w=0.42u l=0.13u
X2180 a_28754_65098# a_28484_65098# VDD VDD sg13_lv_pmos ad=0.34p pd=2.68u as=0.1523p ps=1.38u w=1u l=0.5u
X2181 VSS a_44024_63546# X_uq339 VSS sg13_lv_nmos ad=0.14875p pd=1.16u as=0.2886p ps=2.26u w=0.74u l=0.13u
X2182 VSS a_43558_63550# a_43277_63772# VSS sg13_lv_nmos ad=79.8f pd=0.8u as=0.1428p ps=1.52u w=0.42u l=0.5u
X2183 VDD a_28658_68122# a_28770_68186# VDD sg13_lv_pmos ad=0.2254p pd=1.53u as=0.34p ps=2.68u w=1u l=0.5u
X2184 a_39350_69318# a_39043_68844# a_39256_69318# VSS sg13_lv_nmos ad=37.8f pd=0.6u as=0.1428p ps=1.52u w=0.42u l=0.13u
X2185 a_79982_28300# L_HI_uq8 VDD VDD sg13_lv_pmos ad=79.8f pd=0.8u as=0.36237p ps=2.605u w=0.42u l=0.13u
X2186 q[8] a_31732_64344# VDD VDD sg13_lv_pmos ad=0.42p pd=2.99u as=0.2114p ps=1.54u w=1.12u l=0.13u
X2187 VSS a_30214_66574# a_29933_66796# VSS sg13_lv_nmos ad=79.8f pd=0.8u as=0.1428p ps=1.52u w=0.42u l=0.5u
X2188 VDD B_uq96 a_4297_39287# VDD sg13_lv_pmos ad=0.2618p pd=1.63u as=0.2856p ps=2.36u w=0.84u l=0.13u
X2189 q[29] a_44884_66644# VSS VSS sg13_lv_nmos ad=0.2886p pd=2.26u as=0.14875p ps=1.16u w=0.74u l=0.13u
X2190 Y_uq7 A_uq98 a_35298_8709# VDD sg13_lv_pmos ad=0.3808p pd=2.92u as=0.1176p ps=1.33u w=1.12u l=0.13u
X2191 Y_uq231 X_uq323 VDD VDD sg13_lv_pmos ad=0.3808p pd=2.92u as=0.3808p ps=2.92u w=1.12u l=0.13u
X2192 a_35946_68370# a_35747_68433# VSS VSS sg13_lv_nmos ad=0.27427p pd=2.28u as=2.08687p ps=13.23u w=0.795u l=0.13u
X2193 Y_uq285 a_49018_66648# VSS VSS sg13_lv_nmos ad=0.1406p pd=1.12u as=0.17255p ps=1.25u w=0.74u l=0.13u
X2194 VSS L_HI_uq25 a_29424_67806# VSS sg13_lv_nmos ad=0.1626p pd=1.415u as=60.89999f ps=0.71u w=0.42u l=0.13u
X2195 VSS a_30203_66217# a_30870_65856# VSS sg13_lv_nmos ad=0.1406p pd=1.12u as=0.2516p ps=2.16u w=0.74u l=0.13u
X2196 VSS B_uq48 D_uq4 VSS sg13_lv_nmos ad=0.2516p pd=2.16u as=0.1406p ps=1.12u w=0.74u l=0.13u
X2197 a_33170_65098# a_32900_65098# VSS VSS sg13_lv_nmos ad=0.1428p pd=1.52u as=79.8f ps=0.8u w=0.42u l=0.5u
X2198 a_4456_42654# a_4335_41975# a_4297_43188# VDD sg13_lv_pmos ad=93.45f pd=0.865u as=0.2048p ps=1.63u w=0.42u l=0.13u
X2199 Y_uq17 X_uq137 VSS VSS sg13_lv_nmos ad=0.1406p pd=1.12u as=0.2516p ps=2.16u w=0.74u l=0.13u
X2200 a_10806_41419# Y_uq231 VSS VSS sg13_lv_nmos ad=37.8f pd=0.6u as=0.1701p ps=1.65u w=0.42u l=0.13u
X2201 a_39494_10301# B_uq23 VSS VSS sg13_lv_nmos ad=0.1045p pd=0.93u as=0.187p ps=1.78u w=0.55u l=0.13u
X2202 VDD a_36226_7625# X_uq67 VDD sg13_lv_pmos ad=0.2114p pd=1.54u as=0.42p ps=2.99u w=1.12u l=0.13u
X2203 VDD X_uq145 a_42078_8449# VDD sg13_lv_pmos ad=0.2114p pd=1.54u as=0.2856p ps=2.36u w=0.84u l=0.13u
X2204 a_48771_64344# Y_uq243 a_48657_64344# VDD sg13_lv_pmos ad=0.2128p pd=1.5u as=0.2464p ps=1.56u w=1.12u l=0.13u
X2205 a_8869_33953# B_uq75 VDD VDD sg13_lv_pmos ad=0.2128p pd=1.5u as=0.2128p ps=1.5u w=1.12u l=0.13u
X2206 VSS din[9] a_75295_27529# VSS sg13_lv_nmos ad=0.14875p pd=1.16u as=0.187p ps=1.78u w=0.55u l=0.13u
X2207 a_6599_40095# a_6563_40069# VSS VSS sg13_lv_nmos ad=0.3367p pd=1.65u as=0.148p ps=1.14u w=0.74u l=0.13u
X2208 VDD A0 a_7357_40451# VDD sg13_lv_pmos ad=0.36p pd=2.72u as=0.1225p ps=1.245u w=1u l=0.13u
X2209 a_50614_67336# a_51057_67379# a_50997_67415# VDD sg13_lv_pmos ad=79.8f pd=0.8u as=63f ps=0.72u w=0.42u l=0.13u
X2210 VSS VDD VSS VSS sg13_lv_nmos ad=79.8f pd=0.8u as=0 ps=-0 w=0.42u l=1u
X2211 a_43138_9137# q[23] VSS VSS sg13_lv_nmos ad=0.187p pd=1.78u as=0.14875p ps=1.16u w=0.55u l=0.13u
X2212 Y_uq84 C_uq29 VSS VSS sg13_lv_nmos ad=0.2618p pd=2.22u as=0.1463p ps=1.15u w=0.77u l=0.13u
X2213 VDD VSS VDD VDD sg13_lv_pmos ad=0.19p pd=1.38u as=0 ps=0 w=1u l=1u
X2214 Y_uq164 X_uq297 VDD VDD sg13_lv_pmos ad=0.3808p pd=2.92u as=0.3808p ps=2.92u w=1.12u l=0.13u
X2215 VDD a_39610_66795# X_uq400 VDD sg13_lv_pmos ad=0.2254p pd=1.53u as=0.4256p ps=3u w=1.12u l=0.13u
X2216 a_8120_31593# a_8082_32645# a_8116_31287# VSS sg13_lv_nmos ad=0.2373p pd=1.97u as=79.8f ps=0.8u w=0.42u l=0.13u
X2217 Y_uq56 X_uq179 VSS VSS sg13_lv_nmos ad=0.2516p pd=2.16u as=0.2516p ps=2.16u w=0.74u l=0.13u
X2218 VSS X_uq85 a_36318_6937# VSS sg13_lv_nmos ad=0.14875p pd=1.16u as=0.187p ps=1.78u w=0.55u l=0.13u
X2219 VSS VDD VSS VSS sg13_lv_nmos ad=0.1428p pd=1.52u as=0 ps=-0 w=0.42u l=1u
X2220 VDD a_39200_66574# a_39158_66904# VDD sg13_lv_pmos ad=0.2618p pd=1.63u as=0.1176p ps=1.33u w=1.12u l=0.13u
X2221 VDD a_6217_23360# a_6319_23503# VDD sg13_lv_pmos ad=1.02937p pd=6.325u as=0.3864p ps=2.93u w=1.12u l=0.13u
X2222 VSS a_32192_63550# Y_uq253 VSS sg13_lv_nmos ad=0.17255p pd=1.25u as=0.1406p ps=1.12u w=0.74u l=0.13u
X2223 VSS A_uq93 a_32766_8449# VSS sg13_lv_nmos ad=0.14875p pd=1.16u as=0.187p ps=1.78u w=0.55u l=0.13u
X2224 a_8107_40811# a_8082_42437# a_8116_41079# VDD sg13_lv_pmos ad=0.1428p pd=1.52u as=79.8f ps=0.8u w=0.42u l=0.13u
X2225 a_31078_66574# Q_uq59 VSS VSS sg13_lv_nmos ad=0.1428p pd=1.52u as=79.8f ps=0.8u w=0.42u l=0.13u
X2226 a_11477_18135# C_uq1 Y_uq36 VDD sg13_lv_pmos ad=0.1176p pd=1.33u as=0.3808p ps=2.92u w=1.12u l=0.13u
X2227 a_44866_6863# X_uq99 VSS VSS sg13_lv_nmos ad=0.187p pd=1.78u as=0.14875p ps=1.16u w=0.55u l=0.13u
X2228 Y_uq119 B_uq58 VSS VSS sg13_lv_nmos ad=0.1694p pd=1.21u as=0.2618p ps=2.22u w=0.77u l=0.13u
X2229 a_43522_7625# A_uq0 VDD VDD sg13_lv_pmos ad=0.2856p pd=2.36u as=0.2114p ps=1.54u w=0.84u l=0.13u
X2230 a_9598_38154# clk VDD VDD sg13_lv_pmos ad=0.4088p pd=2.97u as=1.12945p ps=7.155u w=1.12u l=0.13u
X2231 VSS a_50938_66123# X_uq383 VSS sg13_lv_nmos ad=0.1426p pd=1.16u as=0.2516p ps=2.16u w=0.74u l=0.13u
X2232 a_42566_9149# B_uq17 VSS VSS sg13_lv_nmos ad=0.1045p pd=0.93u as=0.187p ps=1.78u w=0.55u l=0.13u
X2233 D_uq21 C_uq39 VSS VSS sg13_lv_nmos ad=0.1406p pd=1.12u as=0.2516p ps=2.16u w=0.74u l=0.13u
X2234 a_43650_8709# a_43428_8453# VDD VDD sg13_lv_pmos ad=0.1176p pd=1.33u as=0.2618p ps=1.63u w=1.12u l=0.13u
X2235 VDD a_7321_37166# C1_uq8 VDD sg13_lv_pmos ad=0.1918p pd=1.5u as=0.3808p ps=2.92u w=1.12u l=0.13u
X2236 a_8835_37148# clk VSS VSS sg13_lv_nmos ad=0.2516p pd=2.16u as=3.58025p ps=22.71u w=0.74u l=0.13u
X2237 VDD din[23] a_75295_19969# VDD sg13_lv_pmos ad=0.2114p pd=1.54u as=0.2856p ps=2.36u w=0.84u l=0.13u
X2238 a_3535_31126# a_3535_31228# VSS VSS sg13_lv_nmos ad=0.2516p pd=2.16u as=0.1406p ps=1.12u w=0.74u l=0.13u
X2239 a_4297_34356# a_4299_33212# a_4694_33526# VSS sg13_lv_nmos ad=0.12665p pd=1.145u as=0.1428p ps=1.52u w=0.42u l=0.13u
X2240 Y_uq353 Q_uq41 VDD VDD sg13_lv_pmos ad=0.3808p pd=2.92u as=0.3808p ps=2.92u w=1.12u l=0.13u
X2241 a_44496_68884# a_45015_68891# a_45755_69241# VSS sg13_lv_nmos ad=0.3473p pd=2.71u as=0.12665p ps=1.145u w=0.74u l=0.13u
X2242 VDD a_34523_66683# a_34780_66826# VDD sg13_lv_pmos ad=1.19383p pd=7.16u as=79.8f ps=0.8u w=0.42u l=0.13u
X2243 q[15] a_38356_63620# VSS VSS sg13_lv_nmos ad=0.2886p pd=2.26u as=0.14875p ps=1.16u w=0.74u l=0.13u
X2244 VSS a_34972_64586# a_34621_64705# VSS sg13_lv_nmos ad=79.8f pd=0.8u as=0.1428p ps=1.52u w=0.42u l=0.13u
X2245 VSS Q_uq43 a_51716_65897# VSS sg13_lv_nmos ad=79.8f pd=0.8u as=0.1428p ps=1.52u w=0.42u l=0.13u
X2246 X_uq242 a_75295_25229# VSS VSS sg13_lv_nmos ad=0.2886p pd=2.26u as=0.14875p ps=1.16u w=0.74u l=0.13u
X2247 VDD Y_uq340 a_32596_63620# VDD sg13_lv_pmos ad=0.2114p pd=1.54u as=0.2856p ps=2.36u w=0.84u l=0.13u
X2248 a_50444_65269# a_50563_65058# VSS VSS sg13_lv_nmos ad=0.2516p pd=2.16u as=0.1406p ps=1.12u w=0.74u l=0.13u
X2249 a_78574_22169# a_79134_22292# a_79045_22328# VDD sg13_lv_pmos ad=0.2048p pd=1.63u as=93.45f ps=0.865u w=0.42u l=0.13u
X2250 X_uq145 a_40734_9173# VSS VSS sg13_lv_nmos ad=0.2886p pd=2.26u as=0.14875p ps=1.16u w=0.74u l=0.13u
X2251 X_uq30 a_34782_6937# VSS VSS sg13_lv_nmos ad=0.2886p pd=2.26u as=0.14875p ps=1.16u w=0.74u l=0.13u
X2252 VDD a_52486_66827# L_HI_uq23 VDD sg13_lv_pmos ad=1.19383p pd=7.16u as=0.3927p ps=2.99u w=1.155u l=0.13u
X2253 a_5051_39674# Y_uq235 VSS VSS sg13_lv_nmos ad=0.187p pd=1.78u as=0.14505p ps=1.15u w=0.55u l=0.13u
X2254 VSS X_uq348 a_36606_10685# VSS sg13_lv_nmos ad=0.14875p pd=1.16u as=0.187p ps=1.78u w=0.55u l=0.13u
X2255 VDD a_3579_22936# a_3579_22706# VDD sg13_lv_pmos ad=1.37097p pd=8.54u as=0.2442p ps=2.06u w=0.66u l=0.13u
X2256 VDD a_10347_35900# a_10383_35831# VDD sg13_lv_pmos ad=1.17462p pd=7.44u as=0.3864p ps=2.93u w=1.12u l=0.13u
X2257 Y_uq27 X_uq145 VSS VSS sg13_lv_nmos ad=0.1406p pd=1.12u as=0.2516p ps=2.16u w=0.74u l=0.13u
X2258 a_7059_21480# a_6217_21130# a_5800_21123# VDD sg13_lv_pmos ad=0.2048p pd=1.63u as=0.34p ps=2.68u w=1u l=0.13u
X2259 a_79045_28691# a_79286_28224# a_78574_28217# VSS sg13_lv_nmos ad=0.1428p pd=1.52u as=0.12665p ps=1.145u w=0.42u l=0.13u
X2260 a_78946_19529# X_uq251 a_78852_19529# VSS sg13_lv_nmos ad=0.1216p pd=1.02u as=0.2176p ps=1.96u w=0.64u l=0.13u
X2261 a_37366_65824# a_37809_65867# a_37106_66294# VSS sg13_lv_nmos ad=79.8f pd=0.8u as=0.1296p ps=1.52u w=0.42u l=0.13u
X2262 a_49019_69707# a_48177_69609# a_48925_69707# VSS sg13_lv_nmos ad=0.12665p pd=1.145u as=0.1428p ps=1.52u w=0.42u l=0.13u
X2263 a_11334_19647# C_uq5 Y_uq40 VDD sg13_lv_pmos ad=0.2128p pd=1.5u as=0.3808p ps=2.92u w=1.12u l=0.13u
X2264 a_3962_35694# a_3535_36717# VDD VDD sg13_lv_pmos ad=63f pd=0.72u as=0.1563p ps=1.22u w=0.42u l=0.13u
X2265 D_uq42 C_uq47 a_46179_65392# VDD sg13_lv_pmos ad=0.3808p pd=2.92u as=0.2128p ps=1.5u w=1.12u l=0.13u
X2266 a_34972_64586# a_34715_64705# a_35134_64782# VSS sg13_lv_nmos ad=0.1428p pd=1.52u as=37.8f ps=0.6u w=0.42u l=0.13u
X2267 X_uq99 a_43814_10301# VDD VDD sg13_lv_pmos ad=0.3976p pd=2.95u as=0.2226p ps=1.535u w=1.12u l=0.13u
X2268 a_3535_41421# a_3580_40023# VSS VSS sg13_lv_nmos ad=0.2516p pd=2.16u as=0.1626p ps=1.415u w=0.74u l=0.13u
X2269 VSS a_30460_66098# a_30109_66217# VSS sg13_lv_nmos ad=79.8f pd=0.8u as=0.1428p ps=1.52u w=0.42u l=0.13u
X2270 VDD a_43426_10649# X_uq143 VDD sg13_lv_pmos ad=0.2114p pd=1.54u as=0.42p ps=2.99u w=1.12u l=0.13u
X2271 VDD a_4297_34766# B_uq77 VDD sg13_lv_pmos ad=0.1918p pd=1.5u as=0.3808p ps=2.92u w=1.12u l=0.13u
X2272 a_10683_20477# A_N VSS VSS sg13_lv_nmos ad=0.1406p pd=1.12u as=0.2886p ps=2.26u w=0.74u l=0.13u
X2273 a_5083_31113# D_uq16 a_5083_31019# VSS sg13_lv_nmos ad=60.89999f pd=0.71u as=0.1428p ps=1.52u w=0.42u l=0.13u
X2274 a_80675_28967# X_uq281 VSS VSS sg13_lv_nmos ad=0.187p pd=1.78u as=0.14875p ps=1.16u w=0.55u l=0.13u
X2275 a_9217_39590# X_uq308 Y_uq212 VSS sg13_lv_nmos ad=0.1406p pd=1.12u as=0.1406p ps=1.12u w=0.74u l=0.13u
X2276 VDD B_uq63 a_10727_20907# VDD sg13_lv_pmos ad=0.2198p pd=1.53u as=0.2856p ps=2.36u w=0.84u l=0.13u
X2277 VSS B1_uq2 Y_uq103 VSS sg13_lv_nmos ad=0.2516p pd=2.16u as=0.1406p ps=1.12u w=0.74u l=0.13u
X2278 Q_uq60 a_31542_68880# VDD VDD sg13_lv_pmos ad=0.3808p pd=2.92u as=0.2128p ps=1.5u w=1.12u l=0.13u
X2279 a_6986_31854# a_6559_32877# VDD VDD sg13_lv_pmos ad=63f pd=0.72u as=0.1563p ps=1.22u w=0.42u l=0.13u
X2280 VSS a_7321_35905# B_uq80 VSS sg13_lv_nmos ad=0.15745p pd=1.175u as=0.2351p ps=2.16u w=0.74u l=0.13u
X2281 Q_uq38 a_38454_67368# VDD VDD sg13_lv_pmos ad=0.3808p pd=2.92u as=0.2128p ps=1.5u w=1.12u l=0.13u
X2282 VDD Q_uq6 C1_uq4 VDD sg13_lv_pmos ad=0.3808p pd=2.92u as=0.3808p ps=2.92u w=1.12u l=0.13u
X2283 a_43906_7625# Y VSS VSS sg13_lv_nmos ad=0.187p pd=1.78u as=0.14875p ps=1.16u w=0.55u l=0.13u
X2284 VSS D_uq5 Y_uq109 VSS sg13_lv_nmos ad=0.23757p pd=2.16u as=0.1406p ps=1.12u w=0.74u l=0.13u
X2285 a_32566_69853# a_33009_69609# a_32306_69630# VSS sg13_lv_nmos ad=79.8f pd=0.8u as=0.1296p ps=1.52u w=0.42u l=0.13u
X2286 VSS a_39779_65175# a_39779_65175# VSS sg13_lv_nmos ad=4.5737p pd=28.36u as=0.111p ps=1.34u w=0.3u l=0.13u
X2287 B2_uq8 X_uq264 VSS VSS sg13_lv_nmos ad=0.2516p pd=2.16u as=0.2516p ps=2.16u w=0.74u l=0.13u
X2288 VDD B1_uq6 a_76268_20229# VDD sg13_lv_pmos ad=0.2128p pd=1.5u as=0.3808p ps=2.92u w=1.12u l=0.13u
X2289 a_9149_41546# a_8873_41001# a_9294_41227# VSS sg13_lv_nmos ad=0.1428p pd=1.52u as=37.8f ps=0.6u w=0.42u l=0.13u
X2290 a_42321_67368# X_uq447 VDD VDD sg13_lv_pmos ad=0.2464p pd=1.56u as=0.3808p ps=2.92u w=1.12u l=0.13u
X2291 a_41423_66904# Y_uq295 a_41321_66904# VDD sg13_lv_pmos ad=0.2464p pd=1.56u as=0.2128p ps=1.5u w=1.12u l=0.13u
X2292 a_47576_63546# Y_uq304 VDD VDD sg13_lv_pmos ad=0.2856p pd=2.36u as=0.2114p ps=1.54u w=0.84u l=0.13u
X2293 a_5630_22595# Q VSS VSS sg13_lv_nmos ad=0.1428p pd=1.52u as=79.8f ps=0.8u w=0.42u l=0.13u
X2294 a_78365_27179# a_79170_26752# a_78625_26709# VDD sg13_lv_pmos ad=0.1428p pd=1.52u as=79.8f ps=0.8u w=0.42u l=0.13u
X2295 a_6585_34382# B_uq77 VDD VDD sg13_lv_pmos ad=0.1596p pd=1.22u as=0.1918p ps=1.5u w=0.84u l=0.13u
X2296 VDD a_31078_66574# a_30797_66796# VDD sg13_lv_pmos ad=0.1523p pd=1.38u as=0.34p ps=2.68u w=1u l=0.5u
X2297 a_11053_20869# A_N a_10951_20869# VSS sg13_lv_nmos ad=0.1406p pd=1.12u as=0.1406p ps=1.12u w=0.74u l=0.13u
X2298 a_12160_21159# C_uq20 a_12046_21159# VDD sg13_lv_pmos ad=0.2128p pd=1.5u as=0.2464p ps=1.56u w=1.12u l=0.13u
X2299 q[8] a_31732_64344# VSS VSS sg13_lv_nmos ad=0.2886p pd=2.26u as=0.14875p ps=1.16u w=0.74u l=0.13u
X2300 X_uq32 a_34014_6937# VDD VDD sg13_lv_pmos ad=0.42p pd=2.99u as=0.2114p ps=1.54u w=1.12u l=0.13u
X2301 X_uq23 a_37470_6937# VSS VSS sg13_lv_nmos ad=0.2886p pd=2.26u as=0.14875p ps=1.16u w=0.74u l=0.13u
X2302 a_9583_39117# a_9628_37719# VSS VSS sg13_lv_nmos ad=0.2516p pd=2.16u as=0.1626p ps=1.415u w=0.74u l=0.13u
X2303 VDD q[14] a_36222_10685# VDD sg13_lv_pmos ad=0.2114p pd=1.54u as=0.2856p ps=2.36u w=0.84u l=0.13u
X2304 VSS Y_uq238 a_4771_41001# VSS sg13_lv_nmos ad=0.1626p pd=1.415u as=60.89999f ps=0.71u w=0.42u l=0.13u
X2305 a_9598_38154# clk VSS VSS sg13_lv_nmos ad=0.2516p pd=2.16u as=3.58025p ps=22.71u w=0.74u l=0.13u
X2306 Y_uq209 Y_uq206 a_4681_38712# VSS sg13_lv_nmos ad=0.1406p pd=1.12u as=0.1406p ps=1.12u w=0.74u l=0.13u
X2307 X_uq182 a_12593_19387# VDD VDD sg13_lv_pmos ad=0.42p pd=2.99u as=0.2114p ps=1.54u w=1.12u l=0.13u
X2308 Y_uq9 a_43908_9229# VSS VSS sg13_lv_nmos ad=0.1406p pd=1.12u as=0.17255p ps=1.25u w=0.74u l=0.13u
X2309 VDD a_34688_63550# a_34646_63880# VDD sg13_lv_pmos ad=0.2618p pd=1.63u as=0.1176p ps=1.33u w=1.12u l=0.13u
X2310 VSS a_37787_67729# a_38454_67368# VSS sg13_lv_nmos ad=0.1406p pd=1.12u as=0.2516p ps=2.16u w=0.74u l=0.13u
X2311 Y_uq197 X_uq297 VSS VSS sg13_lv_nmos ad=0.2516p pd=2.16u as=0.2516p ps=2.16u w=0.74u l=0.13u
X2312 a_11054_23505# B_uq63 VSS VSS sg13_lv_nmos ad=0.1406p pd=1.12u as=0.14505p ps=1.15u w=0.74u l=0.13u
X2313 a_39610_66795# a_39725_66796# VSS VSS sg13_lv_nmos ad=0.1428p pd=1.52u as=0.1426p ps=1.16u w=0.42u l=0.5u
X2314 a_34942_66606# L_HI_uq24 VSS VSS sg13_lv_nmos ad=37.8f pd=0.6u as=79.8f ps=0.8u w=0.42u l=0.13u
X2315 VDD a_8835_41852# a_8871_41783# VDD sg13_lv_pmos ad=1.5243p pd=9.795u as=0.3864p ps=2.93u w=1.12u l=0.13u
X2316 a_28658_68122# a_28388_68122# VSS VSS sg13_lv_nmos ad=0.1428p pd=1.52u as=79.8f ps=0.8u w=0.42u l=0.5u
X2317 VSS a_35674_66795# X_uq409 VSS sg13_lv_nmos ad=0.1426p pd=1.16u as=0.2516p ps=2.16u w=0.74u l=0.13u
X2318 a_80076_22252# a_79134_22292# a_79937_22485# VSS sg13_lv_nmos ad=79.8f pd=0.8u as=0.2373p ps=1.97u w=0.42u l=0.13u
X2319 VDD L_HI_uq14 a_40342_65824# VDD sg13_lv_pmos ad=0.1563p pd=1.22u as=0.147p ps=1.54u w=0.42u l=0.13u
X2320 a_6559_42743# Y_uq236 VDD VDD sg13_lv_pmos ad=79.8f pd=0.8u as=2.4956p ps=16.32u w=0.42u l=0.13u
X2321 VSS a_36778_9891# Y_uq25 VSS sg13_lv_nmos ad=0.17255p pd=1.25u as=0.1406p ps=1.12u w=0.74u l=0.13u
X2322 B_uq25 a_37758_10685# VDD VDD sg13_lv_pmos ad=0.42p pd=2.99u as=0.2114p ps=1.54u w=1.12u l=0.13u
X2323 VDD a_45898_9891# a_45856_10221# VDD sg13_lv_pmos ad=0.2618p pd=1.63u as=0.1176p ps=1.33u w=1.12u l=0.13u
X2324 a_8422_32766# a_8082_32645# a_8071_33019# VDD sg13_lv_pmos ad=93.45f pd=0.865u as=0.2048p ps=1.63u w=0.42u l=0.13u
X2325 a_8869_34699# D_uq30 VDD VDD sg13_lv_pmos ad=0.34p pd=2.68u as=0.19p ps=1.38u w=1u l=0.13u
X2326 Y_uq286 C_uq53 VSS VSS sg13_lv_nmos ad=0.2618p pd=2.22u as=0.1463p ps=1.15u w=0.77u l=0.13u
X2327 Y_uq238 X_uq323 VDD VDD sg13_lv_pmos ad=0.3808p pd=2.92u as=0.3808p ps=2.92u w=1.12u l=0.13u
X2328 VDD a_46012_69122# a_45957_69003# VDD sg13_lv_pmos ad=1.42837p pd=8.61u as=93.45f ps=0.865u w=0.42u l=0.13u
X2329 a_39882_69882# a_39683_69945# VSS VSS sg13_lv_nmos ad=0.27427p pd=2.28u as=2.01085p ps=12.81u w=0.795u l=0.13u
X2330 a_3571_35051# a_3546_36677# a_3580_35319# VDD sg13_lv_pmos ad=0.1428p pd=1.52u as=79.8f ps=0.8u w=0.42u l=0.13u
X2331 D_uq38 a_41442_65162# VSS VSS sg13_lv_nmos ad=0.2516p pd=2.16u as=0.1426p ps=1.16u w=0.74u l=0.13u
X2332 Y_uq203 B_uq87 VSS VSS sg13_lv_nmos ad=0.1406p pd=1.12u as=0.2516p ps=2.16u w=0.74u l=0.13u
X2333 a_49443_67368# Y_uq303 a_49329_67368# VDD sg13_lv_pmos ad=0.2128p pd=1.5u as=0.2464p ps=1.56u w=1.12u l=0.13u
X2334 a_45173_69576# a_45297_69673# VDD VDD sg13_lv_pmos ad=0.2442p pd=2.06u as=1.6733p ps=10.405u w=0.66u l=0.13u
X2335 X_uq156 a_36222_10685# VDD VDD sg13_lv_pmos ad=0.42p pd=2.99u as=0.2114p ps=1.54u w=1.12u l=0.13u
X2336 VDD X_uq324 a_5405_40939# VDD sg13_lv_pmos ad=0.19p pd=1.38u as=0.2125p ps=1.425u w=1u l=0.13u
X2337 VSS Q_uq37 Y_uq264 VSS sg13_lv_nmos ad=0.2516p pd=2.16u as=0.2516p ps=2.16u w=0.74u l=0.13u
X2338 VSS Y_uq65 a_12593_19387# VSS sg13_lv_nmos ad=0.14875p pd=1.16u as=0.187p ps=1.78u w=0.55u l=0.13u
X2339 Y_uq310 Q_uq56 VSS VSS sg13_lv_nmos ad=0.2516p pd=2.16u as=0.2516p ps=2.16u w=0.74u l=0.13u
X2340 a_28064_67332# X_uq420 VDD VDD sg13_lv_pmos ad=0.2856p pd=2.36u as=0.2618p ps=1.63u w=0.84u l=0.13u
X2341 a_42981_69945# a_42039_69752# a_42779_69707# VDD sg13_lv_pmos ad=93.45f pd=0.865u as=0.2048p ps=1.63u w=0.42u l=0.13u
X2342 a_44326_69598# Q_uq54 VDD VDD sg13_lv_pmos ad=0.1428p pd=1.52u as=0.1523p ps=1.38u w=0.42u l=0.13u
X2343 Y_uq48 X_uq174 VSS VSS sg13_lv_nmos ad=0.2516p pd=2.16u as=0.2516p ps=2.16u w=0.74u l=0.13u
X2344 a_6563_38009# Y_uq205 VDD VDD sg13_lv_pmos ad=0.2856p pd=2.36u as=0.2618p ps=1.63u w=0.84u l=0.13u
X2345 VSS Y_uq169 a_6595_31305# VSS sg13_lv_nmos ad=0.1626p pd=1.415u as=60.89999f ps=0.71u w=0.42u l=0.13u
X2346 a_37596_9149# X_uq162 VDD VDD sg13_lv_pmos ad=0.1596p pd=1.22u as=0.2226p ps=1.535u w=0.84u l=0.13u
X2347 X_uq276 a_76351_29041# VSS VSS sg13_lv_nmos ad=0.2886p pd=2.26u as=0.14875p ps=1.16u w=0.74u l=0.13u
X2348 VDD a_40017_67379# a_40119_67379# VDD sg13_lv_pmos ad=1.19383p pd=7.16u as=0.3864p ps=2.93u w=1.12u l=0.13u
X2349 VSS Q_uq21 Y_uq233 VSS sg13_lv_nmos ad=0.2516p pd=2.16u as=0.2516p ps=2.16u w=0.74u l=0.13u
X2350 VDD a_34714_65283# D_uq45 VDD sg13_lv_pmos ad=0.2254p pd=1.53u as=0.4256p ps=3u w=1.12u l=0.13u
X2351 VDD C_uq39 D_uq23 VDD sg13_lv_pmos ad=0.3808p pd=2.92u as=0.3808p ps=2.92u w=1.12u l=0.13u
X2352 a_27542_65856# X_uq420 VDD VDD sg13_lv_pmos ad=0.1176p pd=1.33u as=0.4032p ps=2.96u w=1.12u l=0.13u
X2353 Q_uq45 a_35286_68416# VSS VSS sg13_lv_nmos ad=0.2516p pd=2.16u as=0.1406p ps=1.12u w=0.74u l=0.13u
X2354 VSS a_7346_22058# B_uq40 VSS sg13_lv_nmos ad=0.1426p pd=1.16u as=0.2516p ps=2.16u w=0.74u l=0.13u
X2355 a_4552_21882# a_4783_21991# a_4238_22092# VSS sg13_lv_nmos ad=0.2373p pd=1.97u as=79.8f ps=0.8u w=0.42u l=0.13u
X2356 VDD VSS VDD VDD sg13_lv_pmos ad=0.19p pd=1.38u as=0 ps=0 w=1u l=1u
X2357 VSS a_4173_25993# a_4094_25896# VSS sg13_lv_nmos ad=2.05957p pd=13.455u as=0.27427p ps=2.28u w=0.795u l=0.13u
X2358 X_uq293 a_3535_34367# VSS VSS sg13_lv_nmos ad=0.2886p pd=2.26u as=0.14875p ps=1.16u w=0.74u l=0.13u
X2359 Y_uq30 a_34116_10741# VSS VSS sg13_lv_nmos ad=0.1406p pd=1.12u as=0.17255p ps=1.25u w=0.74u l=0.13u
X2360 a_6585_34382# C_uq33 a_6641_34510# VSS sg13_lv_nmos ad=0.2176p pd=1.96u as=0.1216p ps=1.02u w=0.64u l=0.13u
X2361 VDD X_uq429 a_38554_65136# VDD sg13_lv_pmos ad=0.2618p pd=1.63u as=0.2856p ps=2.36u w=0.84u l=0.13u
X2362 a_40656_66281# a_40887_65867# a_40342_65824# VSS sg13_lv_nmos ad=0.2373p pd=1.97u as=79.8f ps=0.8u w=0.42u l=0.13u
X2363 a_45898_9891# X_uq95 VDD VDD sg13_lv_pmos ad=0.2856p pd=2.36u as=0.2618p ps=1.63u w=0.84u l=0.13u
X2364 a_46051_64308# a_46611_64431# a_46632_64705# VSS sg13_lv_nmos ad=0.12665p pd=1.145u as=0.3473p ps=2.71u w=0.74u l=0.13u
X2365 Y_uq272 C_uq49 a_49251_65856# VDD sg13_lv_pmos ad=0.3808p pd=2.92u as=0.2128p ps=1.5u w=1.12u l=0.13u
X2366 a_45254_10301# B_uq6 VSS VSS sg13_lv_nmos ad=0.1045p pd=0.93u as=0.187p ps=1.78u w=0.55u l=0.13u
X2367 X_uq28 a_35550_6937# VDD VDD sg13_lv_pmos ad=0.42p pd=2.99u as=0.2114p ps=1.54u w=1.12u l=0.13u
X2368 VSS X_uq427 Y_uq332 VSS sg13_lv_nmos ad=0.2516p pd=2.16u as=0.1406p ps=1.12u w=0.74u l=0.13u
X2369 VDD A_uq75 a_43428_10301# VDD sg13_lv_pmos ad=0.2226p pd=1.535u as=0.1596p ps=1.22u w=0.84u l=0.13u
X2370 VDD a_9583_39451# a_9583_39834# VDD sg13_lv_pmos ad=0.2128p pd=1.5u as=0.3864p ps=2.93u w=1.12u l=0.13u
X2371 VDD din[13] a_75295_25229# VDD sg13_lv_pmos ad=0.2114p pd=1.54u as=0.2856p ps=2.36u w=0.84u l=0.13u
X2372 VDD Q_uq34 a_38356_63620# VDD sg13_lv_pmos ad=0.2114p pd=1.54u as=0.2856p ps=2.36u w=0.84u l=0.13u
X2373 a_51035_68195# a_50193_68097# a_50941_68195# VSS sg13_lv_nmos ad=0.12665p pd=1.145u as=0.1428p ps=1.52u w=0.42u l=0.13u
X2374 VSS Q_uq47 a_27988_63620# VSS sg13_lv_nmos ad=0.14875p pd=1.16u as=0.187p ps=1.78u w=0.55u l=0.13u
X2375 VSS Q_uq24 a_9583_43295# VSS sg13_lv_nmos ad=0.14875p pd=1.16u as=0.187p ps=1.78u w=0.55u l=0.13u
X2376 q[5] a_27604_63620# VSS VSS sg13_lv_nmos ad=0.2886p pd=2.26u as=0.14875p ps=1.16u w=0.74u l=0.13u
X2377 VSS a_29434_65283# X_uq390 VSS sg13_lv_nmos ad=0.1426p pd=1.16u as=0.2516p ps=2.16u w=0.74u l=0.13u
X2378 VSS VDD VSS VSS sg13_lv_nmos ad=79.8f pd=0.8u as=0 ps=-0 w=0.42u l=1u
X2379 a_39106_7625# Y_uq3 VDD VDD sg13_lv_pmos ad=0.2856p pd=2.36u as=0.2114p ps=1.54u w=0.84u l=0.13u
X2380 L_HI_uq26 a_47466_68370# VDD VDD sg13_lv_pmos ad=0.3927p pd=2.99u as=1.42837p ps=8.61u w=1.155u l=0.13u
X2381 VSS a_40006_66574# a_39725_66796# VSS sg13_lv_nmos ad=79.8f pd=0.8u as=0.1428p ps=1.52u w=0.42u l=0.5u
X2382 Y_uq56 X_uq179 VDD VDD sg13_lv_pmos ad=0.3808p pd=2.92u as=0.3808p ps=2.92u w=1.12u l=0.13u
X2383 a_52689_66649# a_52689_66649# VSS VSS sg13_lv_nmos ad=0.111p pd=1.34u as=1.8643p ps=11.96u w=0.3u l=0.13u
X2384 VDD L_HI_uq19 a_43058_66294# VDD sg13_lv_pmos ad=0.36237p pd=2.605u as=79.8f ps=0.8u w=0.42u l=0.13u
X2385 a_40859_67729# a_40017_67379# a_39600_67372# VDD sg13_lv_pmos ad=0.2048p pd=1.63u as=0.34p ps=2.68u w=1u l=0.13u
X2386 VSS B a_37838_8555# VSS sg13_lv_nmos ad=0.187p pd=1.78u as=0.1045p ps=0.93u w=0.55u l=0.13u
X2387 VSS L_HI a_80333_22630# VSS sg13_lv_nmos ad=0.1701p pd=1.65u as=37.8f ps=0.6u w=0.42u l=0.13u
X2388 a_6283_42871# Y_uq237 VSS VSS sg13_lv_nmos ad=37.8f pd=0.6u as=79.8f ps=0.8u w=0.42u l=0.13u
X2389 C_uq1 C_uq24 VDD VDD sg13_lv_pmos ad=0.3808p pd=2.92u as=0.2128p ps=1.5u w=1.12u l=0.13u
X2390 Y_uq85 a_78039_23756# a_78188_24087# VSS sg13_lv_nmos ad=0.2516p pd=2.16u as=0.1406p ps=1.12u w=0.74u l=0.13u
X2391 VDD a_46344_67729# a_47367_67415# VDD sg13_lv_pmos ad=0.1563p pd=1.22u as=63f ps=0.72u w=0.42u l=0.13u
X2392 VSS Y_uq188 Y_uq185 VSS sg13_lv_nmos ad=0.2516p pd=2.16u as=0.1406p ps=1.12u w=0.74u l=0.13u
X2393 a_44722_69305# L_HI_uq35 VSS VSS sg13_lv_nmos ad=37.8f pd=0.6u as=0.1701p ps=1.65u w=0.42u l=0.13u
X2394 a_79045_21131# a_78787_21131# VSS VSS sg13_lv_nmos ad=0.1428p pd=1.52u as=79.8f ps=0.8u w=0.42u l=0.13u
X2395 VSS a_42634_8379# Y_uq2 VSS sg13_lv_nmos ad=0.17255p pd=1.25u as=0.1406p ps=1.12u w=0.74u l=0.13u
X2396 X_uq54 a_37854_7661# VDD VDD sg13_lv_pmos ad=0.42p pd=2.99u as=0.2114p ps=1.54u w=1.12u l=0.13u
X2397 VDD reset a_77887_29041# VDD sg13_lv_pmos ad=0.2114p pd=1.54u as=0.2856p ps=2.36u w=0.84u l=0.13u
X2398 a_9917_37098# D_uq23 VDD VDD sg13_lv_pmos ad=0.2464p pd=1.56u as=0.3808p ps=2.92u w=1.12u l=0.13u
X2399 Y_uq353 Q_uq41 VSS VSS sg13_lv_nmos ad=0.2516p pd=2.16u as=0.2516p ps=2.16u w=0.74u l=0.13u
X2400 VDD a_45755_69241# a_46422_68880# VDD sg13_lv_pmos ad=0.2128p pd=1.5u as=0.3864p ps=2.93u w=1.12u l=0.13u
X2401 a_44866_7625# X_uq98 VSS VSS sg13_lv_nmos ad=0.187p pd=1.78u as=0.14875p ps=1.16u w=0.55u l=0.13u
X2402 VDD C_uq19 a_12684_24183# VDD sg13_lv_pmos ad=0.3808p pd=2.92u as=0.2464p ps=1.56u w=1.12u l=0.13u
X2403 a_7357_31611# D_uq12 VDD VDD sg13_lv_pmos ad=0.2128p pd=1.5u as=0.3808p ps=2.92u w=1.12u l=0.13u
X2404 VSS a_50168_63546# A_uq44 VSS sg13_lv_nmos ad=0.14875p pd=1.16u as=0.2886p ps=2.26u w=0.74u l=0.13u
X2405 VSS a_34286_10067# A_uq93 VSS sg13_lv_nmos ad=0.1469p pd=1.155u as=0.2516p ps=2.16u w=0.74u l=0.13u
X2406 VDD L_HI_uq36 a_41234_69630# VDD sg13_lv_pmos ad=0.36237p pd=2.605u as=79.8f ps=0.8u w=0.42u l=0.13u
X2407 VSS Q_uq30 Y_uq250 VSS sg13_lv_nmos ad=0.2516p pd=2.16u as=0.2516p ps=2.16u w=0.74u l=0.13u
X2408 a_80178_20740# a_79286_20664# a_80076_20740# VDD sg13_lv_pmos ad=63f pd=0.72u as=79.8f ps=0.8u w=0.42u l=0.13u
X2409 a_39200_66574# X_uq399 VDD VDD sg13_lv_pmos ad=0.2856p pd=2.36u as=0.2618p ps=1.63u w=0.84u l=0.13u
X2410 VDD a_37499_69707# a_37756_69850# VDD sg13_lv_pmos ad=1.6733p pd=10.405u as=79.8f ps=0.8u w=0.42u l=0.13u
X2411 a_45922_9137# q[28] VDD VDD sg13_lv_pmos ad=0.2856p pd=2.36u as=0.2114p ps=1.54u w=0.84u l=0.13u
X2412 a_10567_22381# A_N VSS VSS sg13_lv_nmos ad=0.1406p pd=1.12u as=0.18575p ps=1.26u w=0.74u l=0.13u
X2413 a_3571_31535# a_3535_31228# a_3535_31673# VSS sg13_lv_nmos ad=37.8f pd=0.6u as=0.1428p ps=1.52u w=0.42u l=0.13u
X2414 a_9619_40043# a_9594_41669# a_9628_40311# VDD sg13_lv_pmos ad=0.1428p pd=1.52u as=79.8f ps=0.8u w=0.42u l=0.13u
X2415 a_7321_33423# B_uq74 a_7357_32934# VDD sg13_lv_pmos ad=0.35p pd=2.7u as=0.2125p ps=1.425u w=1u l=0.13u
X2416 a_34800_65860# a_35319_65867# a_36059_66217# VSS sg13_lv_nmos ad=0.3473p pd=2.71u as=0.12665p ps=1.145u w=0.74u l=0.13u
X2417 a_8086_41514# clk VDD VDD sg13_lv_pmos ad=0.4088p pd=2.97u as=1.4396p ps=9.25u w=1.12u l=0.13u
X2418 a_46808_63546# Q_uq36 VSS VSS sg13_lv_nmos ad=0.187p pd=1.78u as=0.14875p ps=1.16u w=0.55u l=0.13u
X2419 a_29205_70021# a_28848_69948# VDD VDD sg13_lv_pmos ad=63f pd=0.72u as=0.1563p ps=1.22u w=0.42u l=0.13u
X2420 a_5833_39781# S_uq0 VSS VSS sg13_lv_nmos ad=0.187p pd=1.78u as=0.18945p ps=1.27u w=0.55u l=0.13u
X2421 VDD a_8071_33019# a_8071_33402# VDD sg13_lv_pmos ad=0.2128p pd=1.5u as=0.3864p ps=2.93u w=1.12u l=0.13u
X2422 a_40870_66574# Y_uq294 VSS VSS sg13_lv_nmos ad=0.1428p pd=1.52u as=79.8f ps=0.8u w=0.42u l=0.13u
X2423 D_uq28 X_uq311 a_4333_39313# VDD sg13_lv_pmos ad=0.3808p pd=2.92u as=0.1176p ps=1.33u w=1.12u l=0.13u
X2424 a_46611_64431# a_46763_64315# VDD VDD sg13_lv_pmos ad=0.3864p pd=2.93u as=1.4745p ps=9.07u w=1.12u l=0.13u
X2425 VDD L_HI_uq15 a_34774_65824# VDD sg13_lv_pmos ad=0.1563p pd=1.22u as=0.147p ps=1.54u w=0.42u l=0.13u
X2426 Y_uq11 a_39780_9229# VSS VSS sg13_lv_nmos ad=0.1406p pd=1.12u as=0.17255p ps=1.25u w=0.74u l=0.13u
X2427 VSS a_43714_6863# X_uq7 VSS sg13_lv_nmos ad=0.14875p pd=1.16u as=0.2886p ps=2.26u w=0.74u l=0.13u
X2428 a_75877_23253# B1_uq7 a_75979_23253# VDD sg13_lv_pmos ad=0.3808p pd=2.92u as=0.2128p ps=1.5u w=1.12u l=0.13u
X2429 VDD a_51201_66764# a_50280_66570# VDD sg13_lv_pmos ad=0.36237p pd=2.605u as=0.34p ps=2.68u w=1u l=0.13u
X2430 VSS a_46786_7625# X_uq37 VSS sg13_lv_nmos ad=0.14875p pd=1.16u as=0.2886p ps=2.26u w=0.74u l=0.13u
X2431 B_uq87 a_5809_38522# VDD VDD sg13_lv_pmos ad=0.2128p pd=1.5u as=0.3808p ps=2.92u w=1.12u l=0.13u
X2432 VDD a_49784_68844# X_uq426 VDD sg13_lv_pmos ad=0.2114p pd=1.54u as=0.42p ps=2.99u w=1.12u l=0.13u
X2433 a_42178_7625# A_uq74 VDD VDD sg13_lv_pmos ad=0.2856p pd=2.36u as=0.2114p ps=1.54u w=0.84u l=0.13u
X2434 Y_uq219 B_uq91 a_5845_39311# VDD sg13_lv_pmos ad=0.3808p pd=2.92u as=0.1176p ps=1.33u w=1.12u l=0.13u
X2435 a_78039_23756# X_uq215 VDD VDD sg13_lv_pmos ad=0.1596p pd=1.22u as=0.4536p ps=2.76u w=0.84u l=0.13u
X2436 VSS X_uq449 C_uq64 VSS sg13_lv_nmos ad=0.2516p pd=2.16u as=0.1406p ps=1.12u w=0.74u l=0.13u
X2437 VDD a_5630_22595# a_5349_22897# VDD sg13_lv_pmos ad=0.1523p pd=1.38u as=0.34p ps=2.68u w=1u l=0.5u
X2438 a_47459_64391# L_HI_uq9 VDD VDD sg13_lv_pmos ad=79.8f pd=0.8u as=0.36237p ps=2.605u w=0.42u l=0.13u
X2439 VDD X_uq450 a_49690_67424# VDD sg13_lv_pmos ad=0.2618p pd=1.63u as=0.2856p ps=2.36u w=0.84u l=0.13u
X2440 a_7742_22595# Q_uq1 VSS VSS sg13_lv_nmos ad=0.1428p pd=1.52u as=79.8f ps=0.8u w=0.42u l=0.13u
X2441 a_76939_27789# Y_uq142 VDD VDD sg13_lv_pmos ad=0.2128p pd=1.5u as=0.3808p ps=2.92u w=1.12u l=0.13u
X2442 a_50936_63546# Q_uq42 VSS VSS sg13_lv_nmos ad=0.187p pd=1.78u as=0.14875p ps=1.16u w=0.55u l=0.13u
X2443 VSS a_38044_67610# a_37693_67729# VSS sg13_lv_nmos ad=79.8f pd=0.8u as=0.1428p ps=1.52u w=0.42u l=0.13u
X2444 VDD L_HI_uq13 a_46102_65824# VDD sg13_lv_pmos ad=0.1563p pd=1.22u as=0.147p ps=1.54u w=0.42u l=0.13u
X2445 a_48753_68416# X_uq445 VDD VDD sg13_lv_pmos ad=0.2464p pd=1.56u as=0.3808p ps=2.92u w=1.12u l=0.13u
X2446 A1 Y_uq48 a_76362_19957# VSS sg13_lv_nmos ad=0.1406p pd=1.12u as=0.1406p ps=1.12u w=0.74u l=0.13u
X2447 Y_uq32 C_uq1 VSS VSS sg13_lv_nmos ad=0.1406p pd=1.12u as=0.2516p ps=2.16u w=0.74u l=0.13u
X2448 VDD Y_uq14 a_32478_7661# VDD sg13_lv_pmos ad=0.2114p pd=1.54u as=0.2856p ps=2.36u w=0.84u l=0.13u
X2449 a_44638_67806# L_HI_uq27 VSS VSS sg13_lv_nmos ad=37.8f pd=0.6u as=79.8f ps=0.8u w=0.42u l=0.13u
X2450 Q_uq34 a_39318_65856# VSS VSS sg13_lv_nmos ad=0.2516p pd=2.16u as=0.1406p ps=1.12u w=0.74u l=0.13u
X2451 a_39032_68082# X_uq426 VSS VSS sg13_lv_nmos ad=0.187p pd=1.78u as=0.14875p ps=1.16u w=0.55u l=0.13u
X2452 VSS VDD VSS VSS sg13_lv_nmos ad=0.1428p pd=1.52u as=0 ps=-0 w=0.42u l=1u
X2453 VDD a_5809_36127# a_5833_35847# VDD sg13_lv_pmos ad=0.1523p pd=1.38u as=0.34p ps=2.68u w=1u l=0.5u
X2454 a_41330_65098# a_41060_65098# VSS VSS sg13_lv_nmos ad=0.1428p pd=1.52u as=79.8f ps=0.8u w=0.42u l=0.5u
X2455 VDD Y_uq272 a_49508_65897# VDD sg13_lv_pmos ad=0.1523p pd=1.38u as=0.1428p ps=1.52u w=0.42u l=0.13u
X2456 VDD din[28] a_76447_18457# VDD sg13_lv_pmos ad=0.2114p pd=1.54u as=0.2856p ps=2.36u w=0.84u l=0.13u
X2457 D_uq63 C_uq70 a_35907_68880# VDD sg13_lv_pmos ad=0.3808p pd=2.92u as=0.2128p ps=1.5u w=1.12u l=0.13u
X2458 Y_uq162 C_uq34 a_8869_32796# VDD sg13_lv_pmos ad=0.3808p pd=2.92u as=0.2128p ps=1.5u w=1.12u l=0.13u
X2459 a_76651_28253# Y_uq152 a_76549_28253# VDD sg13_lv_pmos ad=0.2128p pd=1.5u as=0.2128p ps=1.5u w=1.12u l=0.13u
X2460 a_5845_32591# C_uq33 VDD VDD sg13_lv_pmos ad=0.1176p pd=1.33u as=0.4032p ps=2.96u w=1.12u l=0.13u
X2461 X_uq446 a_46324_69668# VDD VDD sg13_lv_pmos ad=0.42p pd=2.99u as=0.2114p ps=1.54u w=1.12u l=0.13u
X2462 C1_uq7 Q_uq8 VSS VSS sg13_lv_nmos ad=0.1694p pd=1.21u as=0.2618p ps=2.22u w=0.77u l=0.13u
X2463 X_uq98 a_44294_10301# VDD VDD sg13_lv_pmos ad=0.3976p pd=2.95u as=0.2226p ps=1.535u w=1.12u l=0.13u
X2464 VSS a_79153_23681# a_78872_23983# VSS sg13_lv_nmos ad=79.8f pd=0.8u as=0.1428p ps=1.52u w=0.42u l=0.5u
X2465 a_52065_65252# L_HI_uq17 VDD VDD sg13_lv_pmos ad=0.147p pd=1.54u as=0.1563p ps=1.22u w=0.42u l=0.13u
X2466 VSS X_uq390 C_uq52 VSS sg13_lv_nmos ad=0.2516p pd=2.16u as=0.1406p ps=1.12u w=0.74u l=0.13u
X2467 Y_uq214 Q_uq23 a_8849_38973# VDD sg13_lv_pmos ad=0.2128p pd=1.5u as=0.2128p ps=1.5u w=1.12u l=0.15u
X2468 a_6088_23394# a_6319_23503# a_5774_23604# VSS sg13_lv_nmos ad=0.2373p pd=1.97u as=79.8f ps=0.8u w=0.42u l=0.13u
X2469 VSS X_uq145 a_41214_10685# VSS sg13_lv_nmos ad=0.14875p pd=1.16u as=0.187p ps=1.78u w=0.55u l=0.13u
X2470 a_51704_69594# Q_uq49 VDD VDD sg13_lv_pmos ad=0.2856p pd=2.36u as=0.2114p ps=1.54u w=0.84u l=0.13u
X2471 VSS a_6217_23360# a_6319_23503# VSS sg13_lv_nmos ad=1.6335p pd=10.61u as=0.2516p ps=2.16u w=0.74u l=0.13u
X2472 a_78577_21411# Q_uq6 VSS VSS sg13_lv_nmos ad=0.1428p pd=1.52u as=79.8f ps=0.8u w=0.42u l=0.13u
X2473 a_46416_66281# a_46647_65867# a_46102_65824# VSS sg13_lv_nmos ad=0.2373p pd=1.97u as=79.8f ps=0.8u w=0.42u l=0.13u
X2474 Y_uq326 Q_uq44 a_37048_66904# VDD sg13_lv_pmos ad=0.3808p pd=2.92u as=0.1176p ps=1.33u w=1.12u l=0.13u
X2475 a_47171_67415# D_uq51 a_47918_67806# VSS sg13_lv_nmos ad=0.1428p pd=1.52u as=60.89999f ps=0.71u w=0.42u l=0.13u
X2476 VSS Y_uq165 a_9619_31631# VSS sg13_lv_nmos ad=79.8f pd=0.8u as=37.8f ps=0.6u w=0.42u l=0.13u
X2477 VDD din[11] a_75679_26741# VDD sg13_lv_pmos ad=0.2114p pd=1.54u as=0.2856p ps=2.36u w=0.84u l=0.13u
X2478 S a_9583_39834# VSS VSS sg13_lv_nmos ad=0.2516p pd=2.16u as=0.1406p ps=1.12u w=0.74u l=0.13u
X2479 a_42368_68086# X_uq449 VDD VDD sg13_lv_pmos ad=0.2856p pd=2.36u as=0.2618p ps=1.63u w=0.84u l=0.13u
X2480 Y_uq155 X_uq271 VSS VSS sg13_lv_nmos ad=0.2516p pd=2.16u as=0.2516p ps=2.16u w=0.74u l=0.13u
X2481 VDD Q_uq19 a_7321_37166# VDD sg13_lv_pmos ad=0.2856p pd=2.36u as=0.1596p ps=1.22u w=0.84u l=0.13u
X2482 VDD a_80197_26168# X_uq250 VDD sg13_lv_pmos ad=0.2254p pd=1.53u as=0.4256p ps=3u w=1.12u l=0.13u
X2483 VSS a_4297_24154# a_4399_24154# VSS sg13_lv_nmos ad=3.1581p pd=19.78u as=0.2516p ps=2.16u w=0.74u l=0.13u
X2484 X_uq170 a_9713_17875# VSS VSS sg13_lv_nmos ad=0.2886p pd=2.26u as=0.14875p ps=1.16u w=0.74u l=0.13u
X2485 X_uq226 a_3500_23419# VSS VSS sg13_lv_nmos ad=0.2886p pd=2.26u as=0.14875p ps=1.16u w=0.74u l=0.13u
X2486 Q_uq21 a_9583_42426# VDD VDD sg13_lv_pmos ad=0.3808p pd=2.92u as=0.2128p ps=1.5u w=1.12u l=0.13u
X2487 VSS a_40642_7625# X_uq49 VSS sg13_lv_nmos ad=0.14875p pd=1.16u as=0.2886p ps=2.26u w=0.74u l=0.13u
X2488 VSS X_uq304 a_4297_37910# VSS sg13_lv_nmos ad=0.14505p pd=1.15u as=0.187p ps=1.78u w=0.55u l=0.13u
X2489 VSS a_35217_65867# a_35319_65867# VSS sg13_lv_nmos ad=1.8643p pd=11.96u as=0.2516p ps=2.16u w=0.74u l=0.13u
X2490 VDD a_33009_69609# a_33111_69752# VDD sg13_lv_pmos ad=1.6733p pd=10.405u as=0.3864p ps=2.93u w=1.12u l=0.13u
X2491 a_8071_42477# a_8116_41079# VSS VSS sg13_lv_nmos ad=0.2516p pd=2.16u as=0.1626p ps=1.415u w=0.74u l=0.13u
X2492 a_8916_41358# a_8873_41001# VDD VDD sg13_lv_pmos ad=63f pd=0.72u as=0.1563p ps=1.22u w=0.42u l=0.13u
X2493 a_31925_66552# a_32049_66649# VDD VDD sg13_lv_pmos ad=0.2442p pd=2.06u as=1.19383p ps=7.16u w=0.66u l=0.13u
X2494 a_9632_38025# a_9594_39077# a_9628_37719# VSS sg13_lv_nmos ad=0.2373p pd=1.97u as=79.8f ps=0.8u w=0.42u l=0.13u
X2495 a_31061_68064# a_31185_68161# VDD VDD sg13_lv_pmos ad=0.2442p pd=2.06u as=1.42837p ps=8.61u w=0.66u l=0.13u
X2496 VDD a_45094_65062# a_44813_65284# VDD sg13_lv_pmos ad=0.1523p pd=1.38u as=0.34p ps=2.68u w=1u l=0.5u
X2497 VDD VSS VDD VDD sg13_lv_pmos ad=0.34p pd=2.68u as=0 ps=0 w=1u l=1u
X2498 VDD Y_uq24 a_36702_6937# VDD sg13_lv_pmos ad=0.2114p pd=1.54u as=0.2856p ps=2.36u w=0.84u l=0.13u
X2499 VSS a_30364_69850# a_30013_69707# VSS sg13_lv_nmos ad=79.8f pd=0.8u as=0.1428p ps=1.52u w=0.42u l=0.13u
X2500 a_10347_35900# clk VSS VSS sg13_lv_nmos ad=0.2516p pd=2.16u as=4.4154p ps=28.205u w=0.74u l=0.13u
X2501 VSS X_uq437 Y_uq349 VSS sg13_lv_nmos ad=0.2516p pd=2.16u as=0.1406p ps=1.12u w=0.74u l=0.13u
X2502 VDD L_HI_uq0 a_78787_21131# VDD sg13_lv_pmos ad=2.04445p pd=13.405u as=79.8f ps=0.8u w=0.42u l=0.13u
X2503 B_uq23 a_38910_10685# VSS VSS sg13_lv_nmos ad=0.2886p pd=2.26u as=0.14875p ps=1.16u w=0.74u l=0.13u
X2504 VDD a_29448_64705# a_30471_64391# VDD sg13_lv_pmos ad=0.1563p pd=1.22u as=63f ps=0.72u w=0.42u l=0.13u
X2505 VDD Q_uq48 a_27604_63620# VDD sg13_lv_pmos ad=0.2114p pd=1.54u as=0.2856p ps=2.36u w=0.84u l=0.13u
X2506 B_uq28 a_34686_10685# VDD VDD sg13_lv_pmos ad=0.42p pd=2.99u as=0.2114p ps=1.54u w=1.12u l=0.13u
X2507 D_uq30 Y_uq196 VDD VDD sg13_lv_pmos ad=0.2128p pd=1.5u as=0.3808p ps=2.92u w=1.12u l=0.13u
X2508 VSS X_uq376 Y_uq267 VSS sg13_lv_nmos ad=0.2516p pd=2.16u as=0.1406p ps=1.12u w=0.74u l=0.13u
X2509 a_78837_27743# a_78638_27806# VSS VSS sg13_lv_nmos ad=0.27427p pd=2.28u as=2.61888p ps=17.445u w=0.795u l=0.13u
X2510 a_30598_68086# Q_uq60 VDD VDD sg13_lv_pmos ad=0.1428p pd=1.52u as=0.1523p ps=1.38u w=0.42u l=0.13u
X2511 L_HI_uq20 a_37578_66858# VDD VDD sg13_lv_pmos ad=0.3927p pd=2.99u as=1.19383p ps=7.16u w=1.155u l=0.13u
X2512 a_7059_24970# a_6217_24872# a_6965_24970# VSS sg13_lv_nmos ad=0.12665p pd=1.145u as=0.1428p ps=1.52u w=0.42u l=0.13u
X2513 VSS a_44698_65283# X_uq397 VSS sg13_lv_nmos ad=0.1426p pd=1.16u as=0.2516p ps=2.16u w=0.74u l=0.13u
X2514 VDD X_uq399 a_39832_65856# VDD sg13_lv_pmos ad=0.4032p pd=2.96u as=0.1176p ps=1.33u w=1.12u l=0.13u
X2515 a_76837_20229# Y_uq52 a_76939_20229# VDD sg13_lv_pmos ad=0.3808p pd=2.92u as=0.2128p ps=1.5u w=1.12u l=0.13u
X2516 VDD X_uq294 a_4297_34766# VDD sg13_lv_pmos ad=0.2856p pd=2.36u as=0.1596p ps=1.22u w=0.84u l=0.13u
X2517 VDD a_52088_69594# A_uq65 VDD sg13_lv_pmos ad=0.2114p pd=1.54u as=0.42p ps=2.99u w=1.12u l=0.13u
X2518 a_36348_10301# X_uq162 VDD VDD sg13_lv_pmos ad=0.1596p pd=1.22u as=0.2226p ps=1.535u w=0.84u l=0.13u
X2519 VSS B_uq66 Y_uq92 VSS sg13_lv_nmos ad=0.2516p pd=2.16u as=0.1406p ps=1.12u w=0.74u l=0.13u
X2520 SLN[6] a_29716_63620# VSS VSS sg13_lv_nmos ad=0.2886p pd=2.26u as=0.14875p ps=1.16u w=0.74u l=0.13u
X2521 VSS X_uq162 Y_uq13 VSS sg13_lv_nmos ad=0.2516p pd=2.16u as=0.1406p ps=1.12u w=0.74u l=0.13u
X2522 a_45922_9137# q[28] VSS VSS sg13_lv_nmos ad=0.187p pd=1.78u as=0.14875p ps=1.16u w=0.55u l=0.13u
X2523 a_48728_65820# Q_uq41 VDD VDD sg13_lv_pmos ad=0.2856p pd=2.36u as=0.2114p ps=1.54u w=0.84u l=0.13u
X2524 a_29338_68307# a_29453_68308# VDD VDD sg13_lv_pmos ad=0.34p pd=2.68u as=0.2254p ps=1.53u w=1u l=0.5u
X2525 C a_8945_19387# VDD VDD sg13_lv_pmos ad=0.42p pd=2.99u as=0.2114p ps=1.54u w=1.12u l=0.13u
X2526 VDD a_47110_65062# a_46829_65284# VDD sg13_lv_pmos ad=0.1523p pd=1.38u as=0.34p ps=2.68u w=1u l=0.5u
X2527 VDD a_37090_8375# X_uq113 VDD sg13_lv_pmos ad=0.2114p pd=1.54u as=0.42p ps=2.99u w=1.12u l=0.13u
X2528 VSS Y_uq231 a_10819_41001# VSS sg13_lv_nmos ad=0.1626p pd=1.415u as=60.89999f ps=0.71u w=0.42u l=0.13u
X2529 VSS a_4944_25619# X_uq259 VSS sg13_lv_nmos ad=0.14875p pd=1.16u as=0.2886p ps=2.26u w=0.74u l=0.13u
X2530 VSS a_43930_69819# X_uq451 VSS sg13_lv_nmos ad=0.1426p pd=1.16u as=0.2516p ps=2.16u w=0.74u l=0.13u
X2531 X_uq239 a_8561_23135# VDD VDD sg13_lv_pmos ad=0.42p pd=2.99u as=0.2114p ps=1.54u w=1.12u l=0.13u
X2532 VSS a_8086_31722# a_8082_32645# VSS sg13_lv_nmos ad=7.58903p pd=50.18u as=0.2516p ps=2.16u w=0.74u l=0.13u
X2533 Q_uq14 a_8071_33402# VSS VSS sg13_lv_nmos ad=0.2516p pd=2.16u as=0.1406p ps=1.12u w=0.74u l=0.13u
X2534 VDD a_47864_66570# A VDD sg13_lv_pmos ad=0.2114p pd=1.54u as=0.42p ps=2.99u w=1.12u l=0.13u
X2535 a_49318_68844# Q_uq50 VSS VSS sg13_lv_nmos ad=0.1428p pd=1.52u as=79.8f ps=0.8u w=0.42u l=0.13u
X2536 VDD Q_uq60 a_27316_69668# VDD sg13_lv_pmos ad=0.2114p pd=1.54u as=0.2856p ps=2.36u w=0.84u l=0.13u
X2537 a_6217_21130# clk VDD VDD sg13_lv_pmos ad=0.4088p pd=2.97u as=1.37097p ps=8.54u w=1.12u l=0.13u
X2538 a_51303_66997# a_50411_66876# a_51201_66764# VDD sg13_lv_pmos ad=63f pd=0.72u as=79.8f ps=0.8u w=0.42u l=0.13u
X2539 VSS C_uq16 Y_uq113 VSS sg13_lv_nmos ad=0.2618p pd=2.22u as=0.1694p ps=1.21u w=0.77u l=0.13u
X2540 a_3584_35625# a_3546_36677# a_3580_35319# VSS sg13_lv_nmos ad=0.2373p pd=1.97u as=79.8f ps=0.8u w=0.42u l=0.13u
X2541 X_uq249 a_8849_25435# VDD VDD sg13_lv_pmos ad=0.42p pd=2.99u as=0.2114p ps=1.54u w=1.12u l=0.13u
X2542 VSS a_52065_65252# a_51144_65058# VSS sg13_lv_nmos ad=0.1626p pd=1.415u as=0.2516p ps=2.16u w=0.74u l=0.13u
X2543 VDD L_HI_uq16 a_30194_65094# VDD sg13_lv_pmos ad=0.36237p pd=2.605u as=79.8f ps=0.8u w=0.42u l=0.13u
X2544 a_35074_7625# A_uq7 VDD VDD sg13_lv_pmos ad=0.2856p pd=2.36u as=0.2114p ps=1.54u w=0.84u l=0.13u
X2545 a_29174_64782# a_28867_64308# a_29080_64782# VSS sg13_lv_nmos ad=37.8f pd=0.6u as=0.1428p ps=1.52u w=0.42u l=0.13u
X2546 a_28024_68880# a_27802_68936# VDD VDD sg13_lv_pmos ad=0.1176p pd=1.33u as=0.2618p ps=1.63u w=1.12u l=0.13u
X2547 X_uq174 a_77215_18457# VDD VDD sg13_lv_pmos ad=0.42p pd=2.99u as=0.2114p ps=1.54u w=1.12u l=0.13u
X2548 a_29424_67806# D_uq57 a_29330_67806# VSS sg13_lv_nmos ad=60.89999f pd=0.71u as=0.1428p ps=1.52u w=0.42u l=0.13u
X2549 Y_uq189 X_uq297 VSS VSS sg13_lv_nmos ad=0.2516p pd=2.16u as=0.2516p ps=2.16u w=0.74u l=0.13u
X2550 VSS a_43750_65062# a_43469_65284# VSS sg13_lv_nmos ad=79.8f pd=0.8u as=0.1428p ps=1.52u w=0.42u l=0.5u
X2551 VSS a_5047_36407# a_5083_36339# VSS sg13_lv_nmos ad=79.8f pd=0.8u as=0.1428p ps=1.52u w=0.42u l=0.13u
X2552 a_8916_41546# D_uq29 VDD VDD sg13_lv_pmos ad=79.8f pd=0.8u as=0.1428p ps=1.52u w=0.42u l=0.13u
X2553 VDD Y_uq11 a_39390_6937# VDD sg13_lv_pmos ad=0.2114p pd=1.54u as=0.2856p ps=2.36u w=0.84u l=0.13u
X2554 VSS Y_uq269 a_32900_65098# VSS sg13_lv_nmos ad=79.8f pd=0.8u as=0.1428p ps=1.52u w=0.42u l=0.13u
X2555 VDD a_50936_63546# q[24] VDD sg13_lv_pmos ad=0.2114p pd=1.54u as=0.42p ps=2.99u w=1.12u l=0.13u
X2556 X_uq224 a_10001_23923# VSS VSS sg13_lv_nmos ad=0.2886p pd=2.26u as=0.14875p ps=1.16u w=0.74u l=0.13u
X2557 VDD a_33898_9137# a_33856_9173# VDD sg13_lv_pmos ad=0.2618p pd=1.63u as=0.1176p ps=1.33u w=1.12u l=0.13u
X2558 VDD B_uq33 C_uq21 VDD sg13_lv_pmos ad=0.2128p pd=1.5u as=0.2128p ps=1.5u w=1.12u l=0.13u
X2559 a_5608_21557# D a_5514_21557# VSS sg13_lv_nmos ad=60.89999f pd=0.71u as=0.1428p ps=1.52u w=0.42u l=0.13u
X2560 a_7321_34574# Q_uq14 a_7705_34702# VSS sg13_lv_nmos ad=0.2176p pd=1.96u as=0.1216p ps=1.02u w=0.64u l=0.13u
X2561 Y_uq192 Q_uq17 VSS VSS sg13_lv_nmos ad=0.2516p pd=2.16u as=0.2516p ps=2.16u w=0.74u l=0.13u
X2562 X_uq211 a_75295_22205# VDD VDD sg13_lv_pmos ad=0.42p pd=2.99u as=0.2114p ps=1.54u w=1.12u l=0.13u
X2563 VSS X_uq325 a_8945_19387# VSS sg13_lv_nmos ad=0.14875p pd=1.16u as=0.187p ps=1.78u w=0.55u l=0.13u
X2564 VSS X_uq341 a_39294_10685# VSS sg13_lv_nmos ad=0.14875p pd=1.16u as=0.187p ps=1.78u w=0.55u l=0.13u
X2565 a_5514_24893# D_uq9 VDD VDD sg13_lv_pmos ad=79.8f pd=0.8u as=0.1428p ps=1.52u w=0.42u l=0.13u
X2566 VDD a_8071_42811# a_8071_43194# VDD sg13_lv_pmos ad=0.2128p pd=1.5u as=0.3864p ps=2.93u w=1.12u l=0.13u
X2567 a_36240_69948# a_36759_69752# a_37499_69707# VSS sg13_lv_nmos ad=0.3473p pd=2.71u as=0.12665p ps=1.145u w=0.74u l=0.13u
X2568 a_8916_41546# a_8871_41783# a_8837_40975# VDD sg13_lv_pmos ad=0.1428p pd=1.52u as=79.8f ps=0.8u w=0.42u l=0.13u
X2569 a_44805_65979# a_43863_65867# a_44603_66217# VDD sg13_lv_pmos ad=93.45f pd=0.865u as=0.2048p ps=1.63u w=0.42u l=0.13u
X2570 a_4106_24568# L_HI_uq6 VSS VSS sg13_lv_nmos ad=37.8f pd=0.6u as=0.1701p ps=1.65u w=0.42u l=0.13u
X2571 a_12256_24183# C_uq15 a_12142_24183# VDD sg13_lv_pmos ad=0.2128p pd=1.5u as=0.2464p ps=1.56u w=1.12u l=0.13u
X2572 VSS a_31448_68082# q[1] VSS sg13_lv_nmos ad=0.14875p pd=1.16u as=0.2886p ps=2.26u w=0.74u l=0.13u
X2573 Y_uq340 Q_uq45 VDD VDD sg13_lv_pmos ad=0.3808p pd=2.92u as=0.3808p ps=2.92u w=1.12u l=0.13u
X2574 a_47674_65283# a_47789_65284# VDD VDD sg13_lv_pmos ad=0.34p pd=2.68u as=0.2254p ps=1.53u w=1u l=0.5u
X2575 VSS a_5062_35274# a_5058_36197# VSS sg13_lv_nmos ad=5.0377p pd=32.285u as=0.2516p ps=2.16u w=0.74u l=0.13u
X2576 a_30033_67379# clk VDD VDD sg13_lv_pmos ad=0.4088p pd=2.97u as=1.17087p ps=7.02u w=1.12u l=0.13u
X2577 VSS din[30] a_77215_18457# VSS sg13_lv_nmos ad=0.14875p pd=1.16u as=0.187p ps=1.78u w=0.55u l=0.13u
X2578 VSS a_46786_8375# X_uq58 VSS sg13_lv_nmos ad=0.14875p pd=1.16u as=0.2886p ps=2.26u w=0.74u l=0.13u
X2579 VDD clk a_79286_22176# VDD sg13_lv_pmos ad=1.59725p pd=10.05u as=0.4088p ps=2.97u w=1.12u l=0.13u
X2580 a_50552_63546# Q_uq51 VDD VDD sg13_lv_pmos ad=0.2856p pd=2.36u as=0.2114p ps=1.54u w=0.84u l=0.13u
X2581 a_40184_63546# Q_uq37 VSS VSS sg13_lv_nmos ad=0.187p pd=1.78u as=0.14875p ps=1.16u w=0.55u l=0.13u
X2582 a_37090_8375# q[10] VDD VDD sg13_lv_pmos ad=0.2856p pd=2.36u as=0.2114p ps=1.54u w=0.84u l=0.13u
X2583 a_31132_67610# L_HI_uq25 VDD VDD sg13_lv_pmos ad=79.8f pd=0.8u as=1.19383p ps=7.16u w=0.42u l=0.13u
X2584 a_4420_42743# a_4297_43188# a_4771_42871# VSS sg13_lv_nmos ad=0.1428p pd=1.52u as=37.8f ps=0.6u w=0.42u l=0.13u
X2585 a_41866_10649# X_uq143 VDD VDD sg13_lv_pmos ad=0.2856p pd=2.36u as=0.2618p ps=1.63u w=0.84u l=0.13u
X2586 C_uq66 X_uq433 VSS VSS sg13_lv_nmos ad=0.1406p pd=1.12u as=0.2516p ps=2.16u w=0.74u l=0.13u
X2587 VDD a_49112_63546# q[23] VDD sg13_lv_pmos ad=0.2114p pd=1.54u as=0.42p ps=2.99u w=1.12u l=0.13u
X2588 a_33074_68118# a_33879_68240# a_33334_68341# VDD sg13_lv_pmos ad=0.1428p pd=1.52u as=79.8f ps=0.8u w=0.42u l=0.13u
X2589 VDD Y_uq131 a_8849_25435# VDD sg13_lv_pmos ad=0.2114p pd=1.54u as=0.2856p ps=2.36u w=0.84u l=0.13u
X2590 VDD a_35842_7625# X_uq68 VDD sg13_lv_pmos ad=0.2114p pd=1.54u as=0.42p ps=2.99u w=1.12u l=0.13u
X2591 VDD a_7742_22595# a_7461_22897# VDD sg13_lv_pmos ad=0.1523p pd=1.38u as=0.34p ps=2.68u w=1u l=0.5u
X2592 Q_uq7 a_80577_26741# VDD VDD sg13_lv_pmos ad=0.3808p pd=2.92u as=0.2128p ps=1.5u w=1.12u l=0.13u
X2593 VDD L_HI_uq27 a_42674_67806# VDD sg13_lv_pmos ad=0.36237p pd=2.605u as=79.8f ps=0.8u w=0.42u l=0.13u
X2594 a_78455_20980# a_78574_20657# VSS VSS sg13_lv_nmos ad=0.2516p pd=2.16u as=0.1406p ps=1.12u w=0.74u l=0.13u
X2595 a_8120_41385# a_8071_42477# a_8120_41323# VSS sg13_lv_nmos ad=0.1428p pd=1.52u as=37.8f ps=0.6u w=0.42u l=0.13u
X2596 a_42946_6863# Y_uq10 VDD VDD sg13_lv_pmos ad=0.2856p pd=2.36u as=0.2114p ps=1.54u w=0.84u l=0.13u
X2597 VDD a_52006_63550# a_51725_63772# VDD sg13_lv_pmos ad=0.1523p pd=1.38u as=0.34p ps=2.68u w=1u l=0.5u
X2598 a_6595_31305# D_uq12 a_6595_31211# VSS sg13_lv_nmos ad=60.89999f pd=0.71u as=0.1428p ps=1.52u w=0.42u l=0.13u
X2599 VSS a_10345_37457# PC VSS sg13_lv_nmos ad=0.14875p pd=1.16u as=0.2886p ps=2.26u w=0.74u l=0.13u
X2600 a_6992_24143# B_uq65 C_uq18 VDD sg13_lv_pmos ad=0.1176p pd=1.33u as=0.3808p ps=2.92u w=1.12u l=0.13u
X2601 a_6574_41610# clk VSS VSS sg13_lv_nmos ad=0.2516p pd=2.16u as=4.5562p ps=29.965u w=0.74u l=0.13u
X2602 a_47734_69853# a_48177_69609# a_48117_70021# VDD sg13_lv_pmos ad=79.8f pd=0.8u as=63f ps=0.72u w=0.42u l=0.13u
X2603 a_39200_66574# X_uq399 VSS VSS sg13_lv_nmos ad=0.187p pd=1.78u as=0.17255p ps=1.25u w=0.55u l=0.13u
X2604 a_9934_39198# a_9594_39077# a_9583_39451# VDD sg13_lv_pmos ad=93.45f pd=0.865u as=0.2048p ps=1.63u w=0.42u l=0.13u
X2605 a_5833_34271# a_5809_33991# VSS VSS sg13_lv_nmos ad=0.1428p pd=1.52u as=79.8f ps=0.8u w=0.42u l=0.5u
X2606 VDD a_5932_42743# a_5968_42654# VDD sg13_lv_pmos ad=1.86053p pd=12.055u as=93.45f ps=0.865u w=0.42u l=0.13u
X2607 a_44134_68086# Q_uq53 VSS VSS sg13_lv_nmos ad=0.1428p pd=1.52u as=79.8f ps=0.8u w=0.42u l=0.13u
X2608 X_uq163 a_32958_9173# VDD VDD sg13_lv_pmos ad=0.42p pd=2.99u as=0.2114p ps=1.54u w=1.12u l=0.13u
X2609 VDD a_51334_65820# a_51053_66122# VDD sg13_lv_pmos ad=0.1523p pd=1.38u as=0.34p ps=2.68u w=1u l=0.5u
X2610 a_46128_65860# a_46647_65867# a_47387_66217# VSS sg13_lv_nmos ad=0.3473p pd=2.71u as=0.12665p ps=1.145u w=0.74u l=0.13u
X2611 VDD A_uq91 a_33246_6937# VDD sg13_lv_pmos ad=0.2114p pd=1.54u as=0.2856p ps=2.36u w=0.84u l=0.13u
X2612 a_79982_28300# D_uq11 a_80729_28691# VSS sg13_lv_nmos ad=0.1428p pd=1.52u as=60.89999f ps=0.71u w=0.42u l=0.13u
X2613 Q_uq13 a_4297_34458# VSS VSS sg13_lv_nmos ad=0.2516p pd=2.16u as=0.1406p ps=1.12u w=0.74u l=0.13u
X2614 a_8956_42551# Y_uq232 VDD VDD sg13_lv_pmos ad=79.8f pd=0.8u as=1.5243p ps=9.795u w=0.42u l=0.13u
X2615 A_uq99 a_32382_8449# VSS VSS sg13_lv_nmos ad=0.2886p pd=2.26u as=0.14875p ps=1.16u w=0.74u l=0.13u
X2616 a_38074_69147# a_38189_69146# VSS VSS sg13_lv_nmos ad=0.1428p pd=1.52u as=0.1426p ps=1.16u w=0.42u l=0.5u
X2617 a_8075_39865# a_8111_40187# VSS VSS sg13_lv_nmos ad=0.1428p pd=1.52u as=0.1426p ps=1.16u w=0.42u l=0.5u
X2618 X_uq445 a_47092_69668# VSS VSS sg13_lv_nmos ad=0.2886p pd=2.26u as=0.14875p ps=1.16u w=0.74u l=0.13u
X2619 a_41794_6863# A_uq76 VDD VDD sg13_lv_pmos ad=0.2856p pd=2.36u as=0.2114p ps=1.54u w=0.84u l=0.13u
X2620 VDD Y_uq167 a_5092_31287# VDD sg13_lv_pmos ad=0.1563p pd=1.22u as=0.147p ps=1.54u w=0.42u l=0.13u
X2621 C_uq8 a_10343_22419# VDD VDD sg13_lv_pmos ad=0.3808p pd=2.92u as=0.2128p ps=1.5u w=1.12u l=0.13u
X2622 VDD L_HI_uq33 a_50422_64312# VDD sg13_lv_pmos ad=0.1563p pd=1.22u as=0.147p ps=1.54u w=0.42u l=0.13u
X2623 VDD a_8833_38292# a_8833_38394# VDD sg13_lv_pmos ad=0.2128p pd=1.5u as=0.3864p ps=2.93u w=1.12u l=0.13u
X2624 a_10862_21993# C_uq24 VSS VSS sg13_lv_nmos ad=0.1406p pd=1.12u as=0.14505p ps=1.15u w=0.74u l=0.13u
X2625 a_5401_37409# Y_uq206 Y_uq195 VDD sg13_lv_pmos ad=0.2128p pd=1.5u as=0.2128p ps=1.5u w=1.12u l=0.15u
X2626 a_6559_32877# a_6604_31479# VSS VSS sg13_lv_nmos ad=0.2516p pd=2.16u as=0.1626p ps=1.415u w=0.74u l=0.13u
X2627 Y_uq293 Q_uq38 VDD VDD sg13_lv_pmos ad=0.3808p pd=2.92u as=0.3808p ps=2.92u w=1.12u l=0.13u
X2628 VDD A_uq210 a_3500_23419# VDD sg13_lv_pmos ad=0.2114p pd=1.54u as=0.2856p ps=2.36u w=0.84u l=0.13u
X2629 VDD L_HI_uq40 a_28562_69630# VDD sg13_lv_pmos ad=0.36237p pd=2.605u as=79.8f ps=0.8u w=0.42u l=0.13u
X2630 a_29904_67793# a_30135_67379# a_29590_67336# VSS sg13_lv_nmos ad=0.2373p pd=1.97u as=79.8f ps=0.8u w=0.42u l=0.13u
X2631 VDD C_uq24 C_uq5 VDD sg13_lv_pmos ad=0.2198p pd=1.53u as=0.2128p ps=1.5u w=1.12u l=0.13u
X2632 a_47459_64391# a_46763_64315# a_47553_64391# VSS sg13_lv_nmos ad=0.1296p pd=1.52u as=79.8f ps=0.8u w=0.42u l=0.13u
X2633 a_9628_37719# a_9598_38154# a_10010_38094# VDD sg13_lv_pmos ad=79.8f pd=0.8u as=63f ps=0.72u w=0.42u l=0.13u
X2634 VSS X_uq446 C_uq42 VSS sg13_lv_nmos ad=0.2516p pd=2.16u as=0.1406p ps=1.12u w=0.74u l=0.13u
X2635 a_32913_65856# X_uq436 VDD VDD sg13_lv_pmos ad=0.2464p pd=1.56u as=0.3808p ps=2.92u w=1.12u l=0.13u
X2636 a_3584_32987# a_3535_31809# a_3584_32893# VSS sg13_lv_nmos ad=37.8f pd=0.6u as=0.1428p ps=1.52u w=0.42u l=0.13u
X2637 a_5381_38737# B_uq87 Y_uq203 VDD sg13_lv_pmos ad=0.1176p pd=1.33u as=0.3808p ps=2.92u w=1.12u l=0.13u
X2638 X_uq199 a_6956_20395# VDD VDD sg13_lv_pmos ad=0.42p pd=2.99u as=0.2114p ps=1.54u w=1.12u l=0.13u
X2639 B_uq33 a_8561_19387# VSS VSS sg13_lv_nmos ad=0.2886p pd=2.26u as=0.14875p ps=1.16u w=0.74u l=0.13u
X2640 a_44938_10649# X_uq136 VSS VSS sg13_lv_nmos ad=0.187p pd=1.78u as=0.17255p ps=1.25u w=0.55u l=0.13u
X2641 a_29616_67372# a_29590_67336# VSS VSS sg13_lv_nmos ad=0.2516p pd=2.16u as=0.1626p ps=1.415u w=0.74u l=0.13u
X2642 Y_uq7 a_35076_8453# VSS VSS sg13_lv_nmos ad=0.1406p pd=1.12u as=0.17255p ps=1.25u w=0.74u l=0.13u
X2643 VDD X_uq312 a_8405_35930# VDD sg13_lv_pmos ad=0.2128p pd=1.5u as=0.3808p ps=2.92u w=1.12u l=0.13u
X2644 a_36387_68416# Y_uq326 a_36273_68416# VDD sg13_lv_pmos ad=0.2128p pd=1.5u as=0.2464p ps=1.56u w=1.12u l=0.13u
X2645 VSS B_uq55 Y_uq107 VSS sg13_lv_nmos ad=0.2516p pd=2.16u as=0.1406p ps=1.12u w=0.74u l=0.13u
X2646 a_9942_24671# B_uq63 a_9840_24671# VDD sg13_lv_pmos ad=0.1575p pd=1.315u as=0.19p ps=1.38u w=1u l=0.13u
X2647 a_80076_22252# L_HI VDD VDD sg13_lv_pmos ad=0.147p pd=1.54u as=0.1563p ps=1.22u w=0.42u l=0.13u
X2648 VDD L_HI_uq23 a_50354_67806# VDD sg13_lv_pmos ad=0.36237p pd=2.605u as=79.8f ps=0.8u w=0.42u l=0.13u
X2649 Y_uq91 X_uq259 VSS VSS sg13_lv_nmos ad=0.1694p pd=1.21u as=0.2618p ps=2.22u w=0.77u l=0.13u
X2650 VSS a_35747_68199# a_35747_68199# VSS sg13_lv_nmos ad=2.08687p pd=13.23u as=0.111p ps=1.34u w=0.3u l=0.13u
X2651 a_11470_20111# C_uq16 VDD VDD sg13_lv_pmos ad=0.2464p pd=1.56u as=0.3808p ps=2.92u w=1.12u l=0.13u
X2652 Y_uq84 C_uq29 a_79758_23717# VDD sg13_lv_pmos ad=0.3808p pd=2.92u as=0.2128p ps=1.5u w=1.12u l=0.13u
X2653 X_uq239 a_8561_23135# VSS VSS sg13_lv_nmos ad=0.2886p pd=2.26u as=0.14875p ps=1.16u w=0.74u l=0.13u
X2654 VSS a_36226_7625# X_uq67 VSS sg13_lv_nmos ad=0.14875p pd=1.16u as=0.2886p ps=2.26u w=0.74u l=0.13u
X2655 VDD D_uq17 a_9619_33563# VDD sg13_lv_pmos ad=0.1428p pd=1.52u as=79.8f ps=0.8u w=0.42u l=0.13u
X2656 VDD C_uq36 Y_uq214 VDD sg13_lv_pmos ad=0.3808p pd=2.92u as=0.2128p ps=1.5u w=1.12u l=0.15u
X2657 VDD a_32192_63550# a_32150_63880# VDD sg13_lv_pmos ad=0.2618p pd=1.63u as=0.1176p ps=1.33u w=1.12u l=0.13u
X2658 VSS L_HI_uq36 a_41328_69630# VSS sg13_lv_nmos ad=0.1626p pd=1.415u as=60.89999f ps=0.71u w=0.42u l=0.13u
X2659 a_37680_66281# a_37911_65867# a_37366_65824# VSS sg13_lv_nmos ad=0.2373p pd=1.97u as=79.8f ps=0.8u w=0.42u l=0.13u
X2660 VSS a_5211_25960# a_5211_25960# VSS sg13_lv_nmos ad=2.05957p pd=13.455u as=0.111p ps=1.34u w=0.3u l=0.13u
X2661 a_11436_19647# D_uq7 a_11334_19647# VDD sg13_lv_pmos ad=0.2464p pd=1.56u as=0.2128p ps=1.5u w=1.12u l=0.13u
X2662 VDD Y_uq89 a_12593_21623# VDD sg13_lv_pmos ad=0.2114p pd=1.54u as=0.2856p ps=2.36u w=0.84u l=0.13u
X2663 VSS a_7059_24970# a_7726_25191# VSS sg13_lv_nmos ad=0.1406p pd=1.12u as=0.2516p ps=2.16u w=0.74u l=0.13u
X2664 VDD a_5047_36407# a_5398_36318# VDD sg13_lv_pmos ad=1.86053p pd=12.055u as=93.45f ps=0.865u w=0.42u l=0.13u
X2665 X_uq189 a_75295_18457# VSS VSS sg13_lv_nmos ad=0.2886p pd=2.26u as=0.14875p ps=1.16u w=0.74u l=0.13u
X2666 Y_uq83 X_uq211 VSS VSS sg13_lv_nmos ad=0.2516p pd=2.16u as=0.2516p ps=2.16u w=0.74u l=0.13u
X2667 VSS a_36202_8379# Y_uq5 VSS sg13_lv_nmos ad=0.17255p pd=1.25u as=0.1406p ps=1.12u w=0.74u l=0.13u
X2668 VDD Y_uq346 a_29716_63620# VDD sg13_lv_pmos ad=0.2114p pd=1.54u as=0.2856p ps=2.36u w=0.84u l=0.13u
X2669 Y_uq68 D_uq1 a_11467_21623# VDD sg13_lv_pmos ad=0.4368p pd=3.02u as=0.2128p ps=1.5u w=1.12u l=0.13u
X2670 VDD a_4297_36603# X_uq300 VDD sg13_lv_pmos ad=0.2254p pd=1.53u as=0.4256p ps=3u w=1.12u l=0.13u
X2671 a_41061_67491# a_40119_67379# a_40859_67729# VDD sg13_lv_pmos ad=93.45f pd=0.865u as=0.2048p ps=1.63u w=0.42u l=0.13u
X2672 VSS Q a_6956_20395# VSS sg13_lv_nmos ad=0.14875p pd=1.16u as=0.187p ps=1.78u w=0.55u l=0.13u
X2673 a_44870_9149# B_uq2 VSS VSS sg13_lv_nmos ad=0.1045p pd=0.93u as=0.187p ps=1.78u w=0.55u l=0.13u
X2674 D_uq20 B_uq77 VSS VSS sg13_lv_nmos ad=0.1694p pd=1.21u as=0.2618p ps=2.22u w=0.77u l=0.13u
X2675 a_8075_37753# a_8111_38075# VSS VSS sg13_lv_nmos ad=0.1428p pd=1.52u as=0.1426p ps=1.16u w=0.42u l=0.5u
X2676 a_29265_69609# clk VSS VSS sg13_lv_nmos ad=0.2516p pd=2.16u as=1.9335p ps=12.315u w=0.74u l=0.13u
X2677 a_45022_66294# L_HI_uq19 VSS VSS sg13_lv_nmos ad=37.8f pd=0.6u as=79.8f ps=0.8u w=0.42u l=0.13u
X2678 a_52376_68844# Q_uq40 VDD VDD sg13_lv_pmos ad=0.2856p pd=2.36u as=0.2114p ps=1.54u w=0.84u l=0.13u
X2679 VSS a_45176_63546# X_uq338 VSS sg13_lv_nmos ad=0.14875p pd=1.16u as=0.2886p ps=2.26u w=0.74u l=0.13u
X2680 a_43522_7625# A_uq0 VSS VSS sg13_lv_nmos ad=0.187p pd=1.78u as=0.14875p ps=1.16u w=0.55u l=0.13u
X2681 a_29427_64431# a_29579_64315# VSS VSS sg13_lv_nmos ad=0.2516p pd=2.16u as=4.5737p ps=28.36u w=0.74u l=0.13u
X2682 a_44602_68307# a_44717_68308# VDD VDD sg13_lv_pmos ad=0.34p pd=2.68u as=0.2254p ps=1.53u w=1u l=0.5u
X2683 a_30202_68307# a_30317_68308# VSS VSS sg13_lv_nmos ad=0.1428p pd=1.52u as=0.1426p ps=1.16u w=0.42u l=0.5u
X2684 a_10742_32304# a_10468_31961# VSS VSS sg13_lv_nmos ad=0.1428p pd=1.52u as=79.8f ps=0.8u w=0.42u l=0.13u
X2685 a_3535_36717# a_3580_35319# VSS VSS sg13_lv_nmos ad=0.2516p pd=2.16u as=0.1626p ps=1.415u w=0.74u l=0.13u
X2686 a_49699_66570# a_50259_66824# a_50170_66921# VDD sg13_lv_pmos ad=0.2048p pd=1.63u as=93.45f ps=0.865u w=0.42u l=0.13u
X2687 a_45603_68416# Y_uq334 a_45489_68416# VDD sg13_lv_pmos ad=0.2128p pd=1.5u as=0.2464p ps=1.56u w=1.12u l=0.13u
X2688 VDD VSS VDD VDD sg13_lv_pmos ad=0.34p pd=2.68u as=0 ps=0 w=1u l=1u
X2689 a_10669_18965# C a_10567_18965# VSS sg13_lv_nmos ad=0.1406p pd=1.12u as=0.1406p ps=1.12u w=0.74u l=0.13u
X2690 a_8869_39488# Y_uq214 VDD VDD sg13_lv_pmos ad=0.3808p pd=2.92u as=0.2128p ps=1.5u w=1.12u l=0.13u
X2691 a_6595_31211# a_6570_32837# a_6604_31479# VDD sg13_lv_pmos ad=0.1428p pd=1.52u as=79.8f ps=0.8u w=0.42u l=0.13u
X2692 VSS X_uq312 a_7705_36275# VSS sg13_lv_nmos ad=0.2176p pd=1.96u as=81.6f ps=0.895u w=0.64u l=0.13u
X2693 a_39043_68844# a_39603_68967# a_39514_69003# VDD sg13_lv_pmos ad=0.2048p pd=1.63u as=93.45f ps=0.865u w=0.42u l=0.13u
X2694 a_32880_69643# a_33111_69752# a_32566_69853# VSS sg13_lv_nmos ad=0.2373p pd=1.97u as=79.8f ps=0.8u w=0.42u l=0.13u
X2695 a_10468_31961# a_10345_31516# VDD VDD sg13_lv_pmos ad=79.8f pd=0.8u as=1.17462p ps=7.44u w=0.42u l=0.13u
X2696 Q_uq25 a_8071_43194# VSS VSS sg13_lv_nmos ad=0.2516p pd=2.16u as=0.1406p ps=1.12u w=0.74u l=0.13u
X2697 a_49776_68436# a_50295_68240# a_51035_68195# VSS sg13_lv_nmos ad=0.3473p pd=2.71u as=0.12665p ps=1.145u w=0.74u l=0.13u
X2698 a_44210_69318# a_45015_68891# a_44470_68848# VDD sg13_lv_pmos ad=0.1428p pd=1.52u as=79.8f ps=0.8u w=0.42u l=0.13u
X2699 VSS a_46545_65867# a_46647_65867# VSS sg13_lv_nmos ad=1.8643p pd=11.96u as=0.2516p ps=2.16u w=0.74u l=0.13u
X2700 Q_uq37 a_41526_67368# VDD VDD sg13_lv_pmos ad=0.3808p pd=2.92u as=0.2128p ps=1.5u w=1.12u l=0.13u
X2701 Q_uq23 a_8833_43098# VDD VDD sg13_lv_pmos ad=0.3808p pd=2.92u as=0.2128p ps=1.5u w=1.12u l=0.13u
X2702 VSS a_48728_63546# X_uq333 VSS sg13_lv_nmos ad=0.14875p pd=1.16u as=0.2886p ps=2.26u w=0.74u l=0.13u
X2703 VSS a_37454_9489# X_uq85 VSS sg13_lv_nmos ad=0.1469p pd=1.155u as=0.2516p ps=2.16u w=0.74u l=0.13u
X2704 a_80167_24687# L_HI_uq4 VDD VDD sg13_lv_pmos ad=79.8f pd=0.8u as=1.59725p ps=10.05u w=0.42u l=0.13u
X2705 Y_uq18 X_uq144 VSS VSS sg13_lv_nmos ad=0.1406p pd=1.12u as=0.2516p ps=2.16u w=0.74u l=0.13u
X2706 a_4264_22187# a_4238_22092# VDD VDD sg13_lv_pmos ad=0.34p pd=2.68u as=0.36237p ps=2.605u w=1u l=0.13u
X2707 a_8832_34225# B_uq75 a_8869_33750# VDD sg13_lv_pmos ad=0.34p pd=2.68u as=0.1225p ps=1.245u w=1u l=0.13u
X2708 a_51035_68195# a_50193_68097# a_49776_68436# VDD sg13_lv_pmos ad=0.2048p pd=1.63u as=0.34p ps=2.68u w=1u l=0.13u
X2709 a_9149_36842# a_8873_36297# a_9294_36523# VSS sg13_lv_nmos ad=0.1428p pd=1.52u as=37.8f ps=0.6u w=0.42u l=0.13u
X2710 VDD SLN[0] a_33150_8449# VDD sg13_lv_pmos ad=0.2114p pd=1.54u as=0.2856p ps=2.36u w=0.84u l=0.13u
X2711 a_42178_6863# Y_uq18 VSS VSS sg13_lv_nmos ad=0.187p pd=1.78u as=0.14875p ps=1.16u w=0.55u l=0.13u
X2712 a_6608_41481# a_6559_42573# a_6608_41419# VSS sg13_lv_nmos ad=0.1428p pd=1.52u as=37.8f ps=0.6u w=0.42u l=0.13u
X2713 VDD Q_uq32 Y_uq290 VDD sg13_lv_pmos ad=0.3808p pd=2.92u as=0.3808p ps=2.92u w=1.12u l=0.13u
X2714 VDD C_uq33 Y_uq159 VDD sg13_lv_pmos ad=0.3808p pd=2.92u as=0.3808p ps=2.92u w=1.12u l=0.13u
X2715 a_3535_38609# A_uq322 VSS VSS sg13_lv_nmos ad=0.187p pd=1.78u as=0.14875p ps=1.16u w=0.55u l=0.13u
X2716 a_5047_36237# a_5058_36197# a_5047_36571# VSS sg13_lv_nmos ad=0.3473p pd=2.71u as=0.12665p ps=1.145u w=0.74u l=0.13u
X2717 VSS L_HI_uq24 a_33072_66606# VSS sg13_lv_nmos ad=0.1626p pd=1.415u as=60.89999f ps=0.71u w=0.42u l=0.13u
X2718 D_uq5 a_10852_23191# a_11054_23505# VSS sg13_lv_nmos ad=0.333p pd=2.38u as=0.1406p ps=1.12u w=0.74u l=0.13u
X2719 VSS Y_uq129 a_9617_25435# VSS sg13_lv_nmos ad=0.14875p pd=1.16u as=0.187p ps=1.78u w=0.55u l=0.13u
X2720 VSS a_43426_10649# X_uq143 VSS sg13_lv_nmos ad=0.14875p pd=1.16u as=0.2886p ps=2.26u w=0.74u l=0.13u
X2721 a_45944_63546# Q_uq31 VSS VSS sg13_lv_nmos ad=0.187p pd=1.78u as=0.14875p ps=1.16u w=0.55u l=0.13u
X2722 VDD L_HI_uq7 a_78365_27179# VDD sg13_lv_pmos ad=0.36237p pd=2.605u as=79.8f ps=0.8u w=0.42u l=0.13u
X2723 a_31544_66570# Y_uq363 VSS VSS sg13_lv_nmos ad=0.187p pd=1.78u as=0.14875p ps=1.16u w=0.55u l=0.13u
X2724 VSS a_40859_67729# a_41526_67368# VSS sg13_lv_nmos ad=0.1406p pd=1.12u as=0.2516p ps=2.16u w=0.74u l=0.13u
X2725 VSS Y_uq7 a_32478_6937# VSS sg13_lv_nmos ad=0.14875p pd=1.16u as=0.187p ps=1.78u w=0.55u l=0.13u
X2726 a_77144_22553# Y_uq71 Y_uq80 VSS sg13_lv_nmos ad=0.1406p pd=1.12u as=0.1406p ps=1.12u w=0.74u l=0.13u
X2727 Q_uq60 a_31542_68880# VSS VSS sg13_lv_nmos ad=0.2516p pd=2.16u as=0.1406p ps=1.12u w=0.74u l=0.13u
X2728 X_uq163 a_32958_9173# VSS VSS sg13_lv_nmos ad=0.2886p pd=2.26u as=0.14875p ps=1.16u w=0.74u l=0.13u
X2729 VSS a_7742_24107# a_7461_24409# VSS sg13_lv_nmos ad=79.8f pd=0.8u as=0.1428p ps=1.52u w=0.42u l=0.5u
X2730 a_33168_68118# D_uq56 a_33074_68118# VSS sg13_lv_nmos ad=60.89999f pd=0.71u as=0.1428p ps=1.52u w=0.42u l=0.13u
X2731 VDD a_3535_38609# B_uq86 VDD sg13_lv_pmos ad=0.2114p pd=1.54u as=0.42p ps=2.99u w=1.12u l=0.13u
X2732 VDD Y_uq139 a_77138_26741# VDD sg13_lv_pmos ad=0.2128p pd=1.5u as=0.2128p ps=1.5u w=1.12u l=0.13u
X2733 Y_uq41 C_uq5 VSS VSS sg13_lv_nmos ad=0.1406p pd=1.12u as=0.2516p ps=2.16u w=0.74u l=0.13u
X2734 X_uq272 a_77887_29041# VDD VDD sg13_lv_pmos ad=0.42p pd=2.99u as=0.2114p ps=1.54u w=1.12u l=0.13u
X2735 a_52322_65107# a_51144_65058# a_51926_65252# VSS sg13_lv_nmos ad=37.8f pd=0.6u as=0.1428p ps=1.52u w=0.42u l=0.13u
X2736 a_46690_9887# A_uq65 VDD VDD sg13_lv_pmos ad=0.2856p pd=2.36u as=0.2114p ps=1.54u w=0.84u l=0.13u
X2737 VDD a_52568_69594# A_uq15 VDD sg13_lv_pmos ad=0.2114p pd=1.54u as=0.42p ps=2.99u w=1.12u l=0.13u
X2738 X_uq26 a_36318_6937# VDD VDD sg13_lv_pmos ad=0.42p pd=2.99u as=0.2114p ps=1.54u w=1.12u l=0.13u
X2739 a_78179_25943# X_uq279 VDD VDD sg13_lv_pmos ad=0.2856p pd=2.36u as=0.2114p ps=1.54u w=0.84u l=0.13u
X2740 a_9632_40555# Y_uq228 VSS VSS sg13_lv_nmos ad=37.8f pd=0.6u as=0.1701p ps=1.65u w=0.42u l=0.13u
X2741 Y_uq340 Q_uq45 VSS VSS sg13_lv_nmos ad=0.2516p pd=2.16u as=0.2516p ps=2.16u w=0.74u l=0.13u
X2742 X_uq348 a_37972_63620# VSS VSS sg13_lv_nmos ad=0.2886p pd=2.26u as=0.14875p ps=1.16u w=0.74u l=0.13u
X2743 VDD a_7316_21361# a_7261_21242# VDD sg13_lv_pmos ad=1.37097p pd=8.54u as=93.45f ps=0.865u w=0.42u l=0.13u
X2744 Q_uq30 a_42294_65856# VSS VSS sg13_lv_nmos ad=0.2516p pd=2.16u as=0.1406p ps=1.12u w=0.74u l=0.13u
X2745 a_78459_24467# D_uq4 a_78365_24467# VSS sg13_lv_nmos ad=60.89999f pd=0.71u as=0.1428p ps=1.52u w=0.42u l=0.13u
X2746 VSS q[14] a_36222_10685# VSS sg13_lv_nmos ad=0.14875p pd=1.16u as=0.187p ps=1.78u w=0.55u l=0.13u
X2747 C_uq20 a_10343_18965# VDD VDD sg13_lv_pmos ad=0.3808p pd=2.92u as=0.2128p ps=1.5u w=1.12u l=0.13u
X2748 VSS Y_uq70 a_9905_21623# VSS sg13_lv_nmos ad=0.14875p pd=1.16u as=0.187p ps=1.78u w=0.55u l=0.13u
X2749 a_31941_65409# a_30999_65216# a_31739_65171# VDD sg13_lv_pmos ad=93.45f pd=0.865u as=0.2048p ps=1.63u w=0.42u l=0.13u
X2750 a_51899_67729# a_51057_67379# a_51805_67729# VSS sg13_lv_nmos ad=0.12665p pd=1.145u as=0.1428p ps=1.52u w=0.42u l=0.13u
X2751 VSS L_HI_uq21 a_29174_64782# VSS sg13_lv_nmos ad=79.8f pd=0.8u as=37.8f ps=0.6u w=0.42u l=0.13u
X2752 VSS C_uq1 Y_uq34 VSS sg13_lv_nmos ad=0.1463p pd=1.15u as=0.2618p ps=2.22u w=0.77u l=0.13u
X2753 VSS C_uq21 Y_uq89 VSS sg13_lv_nmos ad=0.1463p pd=1.15u as=0.1694p ps=1.21u w=0.77u l=0.13u
X2754 VDD Q_uq49 Y_uq352 VDD sg13_lv_pmos ad=0.3808p pd=2.92u as=0.3808p ps=2.92u w=1.12u l=0.13u
X2755 VDD a_50865_64355# a_50967_64355# VDD sg13_lv_pmos ad=1.4745p pd=9.07u as=0.3864p ps=2.93u w=1.12u l=0.13u
X2756 VDD a_40835_69711# a_40835_69945# VDD sg13_lv_pmos ad=1.6733p pd=10.405u as=0.2442p ps=2.06u w=0.66u l=0.13u
X2757 VDD a_43042_10649# B_uq19 VDD sg13_lv_pmos ad=0.2114p pd=1.54u as=0.42p ps=2.99u w=1.12u l=0.13u
X2758 VDD a_47576_63546# X_uq335 VDD sg13_lv_pmos ad=0.2114p pd=1.54u as=0.42p ps=2.99u w=1.12u l=0.13u
X2759 a_80333_22630# a_79155_22566# a_79937_22485# VSS sg13_lv_nmos ad=37.8f pd=0.6u as=0.1428p ps=1.52u w=0.42u l=0.13u
X2760 a_34726_67332# Q_uq45 VDD VDD sg13_lv_pmos ad=0.1428p pd=1.52u as=0.1523p ps=1.38u w=0.42u l=0.13u
X2761 a_75979_22981# Y_uq88 VSS VSS sg13_lv_nmos ad=0.1406p pd=1.12u as=0.1406p ps=1.12u w=0.74u l=0.13u
X2762 B_uq25 a_37758_10685# VSS VSS sg13_lv_nmos ad=0.2886p pd=2.26u as=0.14875p ps=1.16u w=0.74u l=0.13u
X2763 a_10345_37044# a_10347_35900# a_10385_35049# VDD sg13_lv_pmos ad=0.2048p pd=1.63u as=0.34p ps=2.68u w=1u l=0.13u
X2764 X_uq190 a_75679_19969# VSS VSS sg13_lv_nmos ad=0.2886p pd=2.26u as=0.14875p ps=1.16u w=0.74u l=0.13u
X2765 a_51334_65820# Q_uq52 VSS VSS sg13_lv_nmos ad=0.1428p pd=1.52u as=79.8f ps=0.8u w=0.42u l=0.13u
X2766 VSS VDD VSS VSS sg13_lv_nmos ad=0.1428p pd=1.52u as=0 ps=-0 w=0.42u l=1u
X2767 VDD Q_uq47 Y_uq346 VDD sg13_lv_pmos ad=0.3808p pd=2.92u as=0.3808p ps=2.92u w=1.12u l=0.13u
X2768 X_uq156 a_36222_10685# VSS VSS sg13_lv_nmos ad=0.2886p pd=2.26u as=0.14875p ps=1.16u w=0.74u l=0.13u
X2769 VSS VDD VSS VSS sg13_lv_nmos ad=0.1428p pd=1.52u as=0 ps=-0 w=0.42u l=1u
X2770 a_37392_65860# a_37911_65867# a_38651_66217# VSS sg13_lv_nmos ad=0.3473p pd=2.71u as=0.12665p ps=1.145u w=0.74u l=0.13u
X2771 a_79045_22328# a_78787_22643# VDD VDD sg13_lv_pmos ad=93.45f pd=0.865u as=1.59725p ps=10.05u w=0.42u l=0.13u
X2772 a_3584_40267# Y_uq230 VSS VSS sg13_lv_nmos ad=37.8f pd=0.6u as=0.1701p ps=1.65u w=0.42u l=0.13u
X2773 Y_uq28 X_uq137 VSS VSS sg13_lv_nmos ad=0.1406p pd=1.12u as=0.2516p ps=2.16u w=0.74u l=0.13u
X2774 X_uq33 a_33630_6937# VSS VSS sg13_lv_nmos ad=0.2886p pd=2.26u as=0.14875p ps=1.16u w=0.74u l=0.13u
X2775 VSS a_44482_6863# X_uq5 VSS sg13_lv_nmos ad=0.14875p pd=1.16u as=0.2886p ps=2.26u w=0.74u l=0.13u
X2776 VDD a_38074_69147# X_uq430 VDD sg13_lv_pmos ad=0.2254p pd=1.53u as=0.4256p ps=3u w=1.12u l=0.13u
X2777 VSS a_4420_42743# a_4694_42358# VSS sg13_lv_nmos ad=79.8f pd=0.8u as=0.1428p ps=1.52u w=0.42u l=0.13u
X2778 a_37578_66858# a_37379_66921# VSS VSS sg13_lv_nmos ad=0.27427p pd=2.28u as=1.8643p ps=11.96u w=0.795u l=0.13u
X2779 a_76741_25577# A2_uq2 VSS VSS sg13_lv_nmos ad=0.1406p pd=1.12u as=0.2516p ps=2.16u w=0.74u l=0.13u
X2780 a_5051_34111# Q_uq13 VSS VSS sg13_lv_nmos ad=0.1428p pd=1.52u as=79.8f ps=0.8u w=0.42u l=0.13u
X2781 VDD X_uq304 a_5401_37409# VDD sg13_lv_pmos ad=0.3808p pd=2.92u as=0.2128p ps=1.5u w=1.12u l=0.15u
X2782 VDD X_uq323 Y_uq210 VDD sg13_lv_pmos ad=0.3808p pd=2.92u as=0.3808p ps=2.92u w=1.12u l=0.13u
X2783 X_uq243 a_11633_25435# VSS VSS sg13_lv_nmos ad=0.2886p pd=2.26u as=0.14875p ps=1.16u w=0.74u l=0.13u
X2784 a_33360_68436# a_33879_68240# a_34619_68195# VSS sg13_lv_nmos ad=0.3473p pd=2.71u as=0.12665p ps=1.145u w=0.74u l=0.13u
X2785 D_uq8 C_uq25 VSS VSS sg13_lv_nmos ad=0.2618p pd=2.22u as=0.1463p ps=1.15u w=0.77u l=0.13u
X2786 a_9307_40809# D_uq29 a_8916_41546# VSS sg13_lv_nmos ad=60.89999f pd=0.71u as=0.1428p ps=1.52u w=0.42u l=0.13u
X2787 VDD L_HI_uq28 a_39314_67806# VDD sg13_lv_pmos ad=0.36237p pd=2.605u as=79.8f ps=0.8u w=0.42u l=0.13u
X2788 VSS X_uq236 a_10289_21623# VSS sg13_lv_nmos ad=0.14875p pd=1.16u as=0.187p ps=1.78u w=0.55u l=0.13u
X2789 VSS a_5047_33019# a_5047_33402# VSS sg13_lv_nmos ad=0.1406p pd=1.12u as=0.2516p ps=2.16u w=0.74u l=0.13u
X2790 VSS a_48070_65062# a_47789_65284# VSS sg13_lv_nmos ad=79.8f pd=0.8u as=0.1428p ps=1.52u w=0.42u l=0.5u
X2791 VDD a_34715_64705# a_35382_64344# VDD sg13_lv_pmos ad=0.2128p pd=1.5u as=0.3864p ps=2.93u w=1.12u l=0.13u
X2792 VSS a_39622_63550# a_39341_63772# VSS sg13_lv_nmos ad=79.8f pd=0.8u as=0.1428p ps=1.52u w=0.42u l=0.5u
X2793 a_4297_36603# a_4321_36711# VDD VDD sg13_lv_pmos ad=0.34p pd=2.68u as=0.2254p ps=1.53u w=1u l=0.5u
X2794 a_10468_42743# a_10345_43188# a_10819_42871# VSS sg13_lv_nmos ad=0.1428p pd=1.52u as=37.8f ps=0.6u w=0.42u l=0.13u
X2795 VSS a_4297_34766# B_uq77 VSS sg13_lv_nmos ad=0.1331p pd=1.12u as=0.2516p ps=2.16u w=0.74u l=0.13u
X2796 VSS B_uq40 C_uq3 VSS sg13_lv_nmos ad=0.2516p pd=2.16u as=0.1406p ps=1.12u w=0.74u l=0.13u
X2797 a_33873_64355# clk VSS VSS sg13_lv_nmos ad=0.2516p pd=2.16u as=4.19255p ps=26u w=0.74u l=0.13u
X2798 VDD a_45944_63546# q[20] VDD sg13_lv_pmos ad=0.2114p pd=1.54u as=0.42p ps=2.99u w=1.12u l=0.13u
X2799 a_45763_67332# a_46323_67455# a_46344_67729# VSS sg13_lv_nmos ad=0.12665p pd=1.145u as=0.3473p ps=2.71u w=0.74u l=0.13u
X2800 VDD a_45094_69851# L_HI_uq35 VDD sg13_lv_pmos ad=1.6733p pd=10.405u as=0.3927p ps=2.99u w=1.155u l=0.13u
X2801 VSS a_32938_9891# Y_uq26 VSS sg13_lv_nmos ad=0.17255p pd=1.25u as=0.1406p ps=1.12u w=0.74u l=0.13u
X2802 a_34619_68195# a_33777_68097# a_33360_68436# VDD sg13_lv_pmos ad=0.2048p pd=1.63u as=0.34p ps=2.68u w=1u l=0.13u
X2803 a_36528_69643# a_36759_69752# a_36214_69853# VSS sg13_lv_nmos ad=0.2373p pd=1.97u as=79.8f ps=0.8u w=0.42u l=0.13u
X2804 X_uq319 a_3535_34847# VSS VSS sg13_lv_nmos ad=0.2886p pd=2.26u as=0.14875p ps=1.16u w=0.74u l=0.13u
X2805 a_29590_68848# a_30033_68891# a_29973_68927# VDD sg13_lv_pmos ad=79.8f pd=0.8u as=63f ps=0.72u w=0.42u l=0.13u
X2806 D_uq29 Y_uq219 VDD VDD sg13_lv_pmos ad=0.3808p pd=2.92u as=0.3808p ps=2.92u w=1.12u l=0.13u
X2807 VSS X_uq88 a_36900_9229# VSS sg13_lv_nmos ad=0.17255p pd=1.25u as=0.187p ps=1.78u w=0.55u l=0.13u
X2808 a_39106_7625# Y_uq3 VSS VSS sg13_lv_nmos ad=0.187p pd=1.78u as=0.14875p ps=1.16u w=0.55u l=0.13u
X2809 VSS a_39814_68086# a_39533_68308# VSS sg13_lv_nmos ad=79.8f pd=0.8u as=0.1428p ps=1.52u w=0.42u l=0.5u
X2810 a_44603_66217# a_43761_65867# a_44509_66217# VSS sg13_lv_nmos ad=0.12665p pd=1.145u as=0.1428p ps=1.52u w=0.42u l=0.13u
X2811 Y_uq257 X_uq445 VSS VSS sg13_lv_nmos ad=0.1694p pd=1.21u as=0.2618p ps=2.22u w=0.77u l=0.13u
X2812 VDD a_79502_23036# a_79502_23270# VDD sg13_lv_pmos ad=4.72727p pd=30.285u as=0.2442p ps=2.06u w=0.66u l=0.13u
X2813 VDD VSS VDD VDD sg13_lv_pmos ad=0.19p pd=1.38u as=0 ps=0 w=1u l=1u
X2814 a_77245_27517# Y_uq142 C_uq26 VSS sg13_lv_nmos ad=0.1406p pd=1.12u as=0.2516p ps=2.16u w=0.74u l=0.13u
X2815 a_79910_24544# a_79068_24446# a_78651_24785# VDD sg13_lv_pmos ad=0.2048p pd=1.63u as=0.34p ps=2.68u w=1u l=0.13u
X2816 D C_uq3 VSS VSS sg13_lv_nmos ad=0.2618p pd=2.22u as=0.1463p ps=1.15u w=0.77u l=0.13u
X2817 a_8833_42996# a_8835_41852# a_8873_41001# VDD sg13_lv_pmos ad=0.2048p pd=1.63u as=0.34p ps=2.68u w=1u l=0.13u
X2818 VSS B_uq30 a_35246_10067# VSS sg13_lv_nmos ad=0.187p pd=1.78u as=0.1045p ps=0.93u w=0.55u l=0.13u
X2819 Y_uq90 C_uq8 VSS VSS sg13_lv_nmos ad=0.1406p pd=1.12u as=0.2516p ps=2.16u w=0.74u l=0.13u
X2820 a_11680_21159# C_uq21 a_11566_21159# VDD sg13_lv_pmos ad=0.2128p pd=1.5u as=0.2464p ps=1.56u w=1.12u l=0.13u
X2821 VDD B_uq67 a_76438_22181# VDD sg13_lv_pmos ad=0.3808p pd=2.92u as=0.2744p ps=1.61u w=1.12u l=0.13u
X2822 X_uq54 a_37854_7661# VSS VSS sg13_lv_nmos ad=0.2886p pd=2.26u as=0.14875p ps=1.16u w=0.74u l=0.13u
X2823 VSS X_uq345 C_uq44 VSS sg13_lv_nmos ad=0.2516p pd=2.16u as=0.1406p ps=1.12u w=0.74u l=0.13u
X2824 VDD clk a_46763_64315# VDD sg13_lv_pmos ad=1.4357p pd=8.83u as=0.4088p ps=2.97u w=1.12u l=0.13u
X2825 VDD A2_uq6 a_76939_27789# VDD sg13_lv_pmos ad=0.3808p pd=2.92u as=0.2128p ps=1.5u w=1.12u l=0.13u
X2826 X_uq277 a_75967_29041# VSS VSS sg13_lv_nmos ad=0.2886p pd=2.26u as=0.14875p ps=1.16u w=0.74u l=0.13u
X2827 Q_uq46 a_36726_65856# VSS VSS sg13_lv_nmos ad=0.2516p pd=2.16u as=0.1406p ps=1.12u w=0.74u l=0.13u
X2828 a_45418_10649# X_uq135 VSS VSS sg13_lv_nmos ad=0.187p pd=1.78u as=0.17255p ps=1.25u w=0.55u l=0.13u
X2829 a_38206_67806# L_HI_uq29 VSS VSS sg13_lv_nmos ad=37.8f pd=0.6u as=79.8f ps=0.8u w=0.42u l=0.13u
X2830 VSS a_45755_69241# a_46422_68880# VSS sg13_lv_nmos ad=0.1406p pd=1.12u as=0.2516p ps=2.16u w=0.74u l=0.13u
X2831 a_40334_9489# A_uq87 VSS VSS sg13_lv_nmos ad=0.1045p pd=0.93u as=0.1469p ps=1.155u w=0.55u l=0.13u
X2832 VSS Q_uq6 A1 VSS sg13_lv_nmos ad=0.2516p pd=2.16u as=0.1406p ps=1.12u w=0.74u l=0.13u
X2833 C_uq69 X_uq449 VSS VSS sg13_lv_nmos ad=0.1406p pd=1.12u as=0.2516p ps=2.16u w=0.74u l=0.13u
X2834 a_37070_11001# B_uq28 a_37212_10661# VDD sg13_lv_pmos ad=0.2856p pd=2.36u as=0.1596p ps=1.22u w=0.84u l=0.13u
X2835 B_uq58 C_uq19 VSS VSS sg13_lv_nmos ad=0.2516p pd=2.16u as=0.2516p ps=2.16u w=0.74u l=0.13u
X2836 a_9583_31324# a_9594_31979# a_9583_31905# VSS sg13_lv_nmos ad=0.12665p pd=1.145u as=0.3473p ps=2.71u w=0.74u l=0.13u
X2837 a_5109_39206# Y_uq235 Y_uq211 VSS sg13_lv_nmos ad=0.1406p pd=1.12u as=0.1406p ps=1.12u w=0.74u l=0.13u
X2838 a_32978_66606# a_33783_66728# a_33238_66829# VDD sg13_lv_pmos ad=0.1428p pd=1.52u as=79.8f ps=0.8u w=0.42u l=0.13u
X2839 VSS a_9628_33337# a_9583_31905# VSS sg13_lv_nmos ad=0.1626p pd=1.415u as=0.2516p ps=2.16u w=0.74u l=0.13u
X2840 a_31294_69318# L_HI_uq32 VSS VSS sg13_lv_nmos ad=37.8f pd=0.6u as=79.8f ps=0.8u w=0.42u l=0.13u
X2841 a_4264_22187# a_4238_22092# VSS VSS sg13_lv_nmos ad=0.2516p pd=2.16u as=0.1626p ps=1.415u w=0.74u l=0.13u
X2842 VDD Y_uq41 a_9617_19387# VDD sg13_lv_pmos ad=0.2114p pd=1.54u as=0.2856p ps=2.36u w=0.84u l=0.13u
X2843 VSS A_uq75 Y_uq1 VSS sg13_lv_nmos ad=0.2516p pd=2.16u as=0.1406p ps=1.12u w=0.74u l=0.13u
X2844 B1_uq1 Q_uq6 a_76172_25229# VDD sg13_lv_pmos ad=0.3808p pd=2.92u as=0.2128p ps=1.5u w=1.12u l=0.13u
X2845 a_35388_10301# A_uq98 VDD VDD sg13_lv_pmos ad=0.1596p pd=1.22u as=0.2226p ps=1.535u w=0.84u l=0.13u
X2846 VDD a_42562_6863# X_uq10 VDD sg13_lv_pmos ad=0.2114p pd=1.54u as=0.42p ps=2.99u w=1.12u l=0.13u
X2847 VSS Y_uq94 D_uq3 VSS sg13_lv_nmos ad=0.1463p pd=1.15u as=0.1694p ps=1.21u w=0.77u l=0.13u
X2848 Q_uq31 a_48054_65856# VSS VSS sg13_lv_nmos ad=0.2516p pd=2.16u as=0.1406p ps=1.12u w=0.74u l=0.13u
X2849 a_4333_39313# a_4297_39287# VDD VDD sg13_lv_pmos ad=0.1176p pd=1.33u as=0.2618p ps=1.63u w=1.12u l=0.13u
X2850 VDD Y_uq268 a_37972_63620# VDD sg13_lv_pmos ad=0.2114p pd=1.54u as=0.2856p ps=2.36u w=0.84u l=0.13u
X2851 VDD a_47267_68199# a_47267_68433# VDD sg13_lv_pmos ad=1.42837p pd=8.61u as=0.2442p ps=2.06u w=0.66u l=0.13u
X2852 a_47459_64391# D_uq34 a_48206_64782# VSS sg13_lv_nmos ad=0.1428p pd=1.52u as=60.89999f ps=0.71u w=0.42u l=0.13u
X2853 VDD a_35398_69598# a_35117_69820# VDD sg13_lv_pmos ad=0.1523p pd=1.38u as=0.34p ps=2.68u w=1u l=0.5u
X2854 Y_uq6 A_uq98 VSS VSS sg13_lv_nmos ad=0.1406p pd=1.12u as=0.2516p ps=2.16u w=0.74u l=0.13u
X2855 a_10661_41738# a_10383_41975# a_10349_41167# VSS sg13_lv_nmos ad=0.2373p pd=1.97u as=79.8f ps=0.8u w=0.42u l=0.13u
X2856 VSS B_uq55 Y_uq130 VSS sg13_lv_nmos ad=0.2516p pd=2.16u as=0.1406p ps=1.12u w=0.74u l=0.13u
X2857 VDD a_8071_32855# a_8422_32766# VDD sg13_lv_pmos ad=1.5243p pd=9.795u as=93.45f ps=0.865u w=0.42u l=0.13u
X2858 a_7357_35257# Y_uq190 VDD VDD sg13_lv_pmos ad=0.2128p pd=1.5u as=0.3808p ps=2.92u w=1.12u l=0.13u
X2859 a_50064_68131# a_49776_68436# a_50002_68131# VSS sg13_lv_nmos ad=0.1428p pd=1.52u as=37.8f ps=0.6u w=0.42u l=0.13u
X2860 B1_uq6 C_uq23 a_77251_20693# VDD sg13_lv_pmos ad=0.3808p pd=2.92u as=0.1176p ps=1.33u w=1.12u l=0.13u
X2861 VSS a_49784_68844# X_uq426 VSS sg13_lv_nmos ad=0.14875p pd=1.16u as=0.2886p ps=2.26u w=0.74u l=0.13u
X2862 a_42178_7625# A_uq74 VSS VSS sg13_lv_nmos ad=0.187p pd=1.78u as=0.14875p ps=1.16u w=0.55u l=0.13u
X2863 a_5096_31531# Y_uq167 VSS VSS sg13_lv_nmos ad=37.8f pd=0.6u as=0.1701p ps=1.65u w=0.42u l=0.13u
X2864 VSS VDD VSS VSS sg13_lv_nmos ad=79.8f pd=0.8u as=0 ps=-0 w=0.42u l=1u
X2865 a_5845_39311# Y_uq229 VDD VDD sg13_lv_pmos ad=0.1176p pd=1.33u as=0.4032p ps=2.96u w=1.12u l=0.13u
X2866 VSS L_HI_uq11 a_37776_64782# VSS sg13_lv_nmos ad=0.1626p pd=1.415u as=60.89999f ps=0.71u w=0.42u l=0.13u
X2867 a_34121_65856# C_uq50 Y_uq276 VDD sg13_lv_pmos ad=0.2128p pd=1.5u as=0.3808p ps=2.92u w=1.12u l=0.13u
X2868 a_39314_67806# a_40119_67379# a_39574_67336# VDD sg13_lv_pmos ad=0.1428p pd=1.52u as=79.8f ps=0.8u w=0.42u l=0.13u
X2869 a_3571_41719# Y_uq230 VSS VSS sg13_lv_nmos ad=37.8f pd=0.6u as=79.8f ps=0.8u w=0.42u l=0.13u
X2870 VDD Q_uq37 Y_uq264 VDD sg13_lv_pmos ad=0.3808p pd=2.92u as=0.3808p ps=2.92u w=1.12u l=0.13u
X2871 a_39374_9489# A_uq88 VSS VSS sg13_lv_nmos ad=0.1045p pd=0.93u as=0.1469p ps=1.155u w=0.55u l=0.13u
X2872 VDD din[2] a_77503_29041# VDD sg13_lv_pmos ad=0.2114p pd=1.54u as=0.2856p ps=2.36u w=0.84u l=0.13u
X2873 VSS Y_uq14 a_32478_7661# VSS sg13_lv_nmos ad=0.14875p pd=1.16u as=0.187p ps=1.78u w=0.55u l=0.13u
X2874 a_44408_64308# Q_uq32 VDD VDD sg13_lv_pmos ad=0.2856p pd=2.36u as=0.2114p ps=1.54u w=0.84u l=0.13u
X2875 VSS Y_uq113 a_8945_24647# VSS sg13_lv_nmos ad=0.14875p pd=1.16u as=0.187p ps=1.78u w=0.55u l=0.13u
X2876 VDD a_5150_24861# a_4869_25083# VDD sg13_lv_pmos ad=0.1523p pd=1.38u as=0.34p ps=2.68u w=1u l=0.5u
X2877 Y_uq48 X_uq174 VDD VDD sg13_lv_pmos ad=0.3808p pd=2.92u as=0.3808p ps=2.92u w=1.12u l=0.13u
X2878 VSS Y_uq246 D_uq34 VSS sg13_lv_nmos ad=0.1463p pd=1.15u as=0.1694p ps=1.21u w=0.77u l=0.13u
X2879 VSS B_uq87 a_6215_37492# VSS sg13_lv_nmos ad=0.14505p pd=1.15u as=0.1406p ps=1.12u w=0.74u l=0.13u
X2880 Q_uq15 a_6559_33594# VDD VDD sg13_lv_pmos ad=0.3808p pd=2.92u as=0.2128p ps=1.5u w=1.12u l=0.13u
X2881 a_5051_43135# Q_uq28 VSS VSS sg13_lv_nmos ad=0.1428p pd=1.52u as=79.8f ps=0.8u w=0.42u l=0.13u
X2882 a_29361_65867# clk VDD VDD sg13_lv_pmos ad=0.4088p pd=2.97u as=1.37835p ps=8.63u w=1.12u l=0.13u
X2883 VSS a_41026_6863# X_uq14 VSS sg13_lv_nmos ad=0.14875p pd=1.16u as=0.2886p ps=2.26u w=0.74u l=0.13u
X2884 a_33009_68880# X_uq435 VDD VDD sg13_lv_pmos ad=0.2464p pd=1.56u as=0.3808p ps=2.92u w=1.12u l=0.13u
X2885 a_9149_41546# a_8871_41783# a_8837_40975# VSS sg13_lv_nmos ad=0.2373p pd=1.97u as=79.8f ps=0.8u w=0.42u l=0.13u
X2886 C_uq62 X_uq424 a_49238_68416# VDD sg13_lv_pmos ad=0.3808p pd=2.92u as=0.1176p ps=1.33u w=1.12u l=0.13u
X2887 VSS a_7316_23601# a_6965_23458# VSS sg13_lv_nmos ad=79.8f pd=0.8u as=0.1428p ps=1.52u w=0.42u l=0.13u
X2888 a_8916_36654# a_8873_36297# VDD VDD sg13_lv_pmos ad=63f pd=0.72u as=0.1563p ps=1.22u w=0.42u l=0.13u
X2889 a_43068_10301# X_uq144 VDD VDD sg13_lv_pmos ad=0.1596p pd=1.22u as=0.2226p ps=1.535u w=0.84u l=0.13u
X2890 Y_uq286 C_uq53 a_45891_66904# VDD sg13_lv_pmos ad=0.3808p pd=2.92u as=0.2128p ps=1.5u w=1.12u l=0.13u
X2891 VSS Q_uq50 Y_uq318 VSS sg13_lv_nmos ad=0.2516p pd=2.16u as=0.1406p ps=1.12u w=0.74u l=0.13u
X2892 X_uq177 a_9233_18599# VDD VDD sg13_lv_pmos ad=0.42p pd=2.99u as=0.2114p ps=1.54u w=1.12u l=0.13u
X2893 VDD A_uq87 a_39108_10301# VDD sg13_lv_pmos ad=0.2226p pd=1.535u as=0.1596p ps=1.22u w=0.84u l=0.13u
X2894 Y_uq137 B1_uq7 a_76534_26717# VDD sg13_lv_pmos ad=0.2128p pd=1.5u as=0.2716p ps=1.605u w=1.12u l=0.13u
X2895 a_77219_28967# din[3] VDD VDD sg13_lv_pmos ad=0.2856p pd=2.36u as=0.2114p ps=1.54u w=0.84u l=0.13u
X2896 VDD a_5047_36571# a_5047_36407# VDD sg13_lv_pmos ad=1.86053p pd=12.055u as=79.8f ps=0.8u w=0.42u l=0.13u
X2897 VDD din[17] a_75679_23717# VDD sg13_lv_pmos ad=0.2114p pd=1.54u as=0.2856p ps=2.36u w=0.84u l=0.13u
X2898 VDD Y_uq40 a_10001_19387# VDD sg13_lv_pmos ad=0.2114p pd=1.54u as=0.2856p ps=2.36u w=0.84u l=0.13u
X2899 VDD a_8075_40255# a_8111_40187# VDD sg13_lv_pmos ad=0.1523p pd=1.38u as=0.34p ps=2.68u w=1u l=0.5u
X2900 Y_uq276 Y_uq277 VSS VSS sg13_lv_nmos ad=0.1694p pd=1.21u as=0.1463p ps=1.15u w=0.77u l=0.13u
X2901 VDD A_uq57 a_36510_9173# VDD sg13_lv_pmos ad=0.2114p pd=1.54u as=0.2856p ps=2.36u w=0.84u l=0.13u
X2902 VDD a_28748_64631# Q_uq48 VDD sg13_lv_pmos ad=0.2128p pd=1.5u as=0.3808p ps=2.92u w=1.12u l=0.13u
X2903 VSS a_44074_8379# Y_uq0 VSS sg13_lv_nmos ad=0.17255p pd=1.25u as=0.1406p ps=1.12u w=0.74u l=0.13u
X2904 VSS a_34715_64705# a_35382_64344# VSS sg13_lv_nmos ad=0.1406p pd=1.12u as=0.2516p ps=2.16u w=0.74u l=0.13u
X2905 VSS Q_uq49 Y_uq352 VSS sg13_lv_nmos ad=0.2516p pd=2.16u as=0.2516p ps=2.16u w=0.74u l=0.13u
X2906 VDD B_uq55 a_12533_25695# VDD sg13_lv_pmos ad=0.4032p pd=2.96u as=0.1176p ps=1.33u w=1.12u l=0.13u
X2907 VDD a_7321_35905# B_uq80 VDD sg13_lv_pmos ad=0.3808p pd=2.92u as=0.3808p ps=2.92u w=1.12u l=0.13u
X2908 a_4302_23679# B_uq66 VDD VDD sg13_lv_pmos ad=0.1176p pd=1.33u as=0.4032p ps=2.96u w=1.12u l=0.13u
X2909 D_uq18 C_uq31 VSS VSS sg13_lv_nmos ad=0.1406p pd=1.12u as=0.1406p ps=1.12u w=0.74u l=0.13u
X2910 VSS Q_uq54 Y_uq334 VSS sg13_lv_nmos ad=0.2516p pd=2.16u as=0.1406p ps=1.12u w=0.74u l=0.13u
X2911 a_76052_20693# C_uq2 Y_uq64 VDD sg13_lv_pmos ad=0.2128p pd=1.5u as=0.3808p ps=2.92u w=1.12u l=0.13u
X2912 VDD VSS VDD VDD sg13_lv_pmos ad=0.34p pd=2.68u as=0 ps=0 w=1u l=1u
X2913 VSS din[11] a_75679_26741# VSS sg13_lv_nmos ad=0.14875p pd=1.16u as=0.187p ps=1.78u w=0.55u l=0.13u
X2914 a_76555_19181# Y_uq44 VDD VDD sg13_lv_pmos ad=0.2128p pd=1.5u as=0.3808p ps=2.92u w=1.12u l=0.13u
X2915 a_5051_41401# a_5087_41723# VDD VDD sg13_lv_pmos ad=0.34p pd=2.68u as=0.2254p ps=1.53u w=1u l=0.5u
X2916 VSS VDD VSS VSS sg13_lv_nmos ad=0.1428p pd=1.52u as=0 ps=-0 w=0.42u l=1u
X2917 VDD a_78059_19145# a_78017_19181# VDD sg13_lv_pmos ad=0.2618p pd=1.63u as=0.1176p ps=1.33u w=1.12u l=0.13u
X2918 X_uq78 a_42566_9149# VSS VSS sg13_lv_nmos ad=0.2516p pd=2.16u as=0.1469p ps=1.155u w=0.74u l=0.13u
X2919 L_HI a_79701_23207# VDD VDD sg13_lv_pmos ad=0.3927p pd=2.99u as=4.72727p ps=30.285u w=1.155u l=0.13u
X2920 VSS a_80593_23681# a_80312_23983# VSS sg13_lv_nmos ad=79.8f pd=0.8u as=0.1428p ps=1.52u w=0.42u l=0.5u
X2921 a_10574_19353# C VSS VSS sg13_lv_nmos ad=0.1406p pd=1.12u as=0.14505p ps=1.15u w=0.74u l=0.13u
X2922 a_33851_69707# a_33009_69609# a_33757_69707# VSS sg13_lv_nmos ad=0.12665p pd=1.145u as=0.1428p ps=1.52u w=0.42u l=0.13u
X2923 a_50170_66606# a_49912_66606# VSS VSS sg13_lv_nmos ad=0.1428p pd=1.52u as=79.8f ps=0.8u w=0.42u l=0.13u
X2924 VSS Q_uq47 Y_uq346 VSS sg13_lv_nmos ad=0.2516p pd=2.16u as=0.2516p ps=2.16u w=0.74u l=0.13u
X2925 a_10504_31987# a_10468_31961# VDD VDD sg13_lv_pmos ad=93.45f pd=0.865u as=1.17462p ps=7.44u w=0.42u l=0.13u
X2926 a_78574_22169# a_79134_22292# a_79155_22566# VSS sg13_lv_nmos ad=0.12665p pd=1.145u as=0.3473p ps=2.71u w=0.74u l=0.13u
X2927 a_3535_36887# a_3535_37051# a_3571_37015# VSS sg13_lv_nmos ad=0.1428p pd=1.52u as=37.8f ps=0.6u w=0.42u l=0.13u
X2928 a_43377_67379# clk VSS VSS sg13_lv_nmos ad=0.2516p pd=2.16u as=2.0066p ps=12.72u w=0.74u l=0.13u
X2929 a_7316_21361# a_7059_21480# a_7478_21557# VSS sg13_lv_nmos ad=0.1428p pd=1.52u as=37.8f ps=0.6u w=0.42u l=0.13u
X2930 X_uq266 a_75295_27529# VSS VSS sg13_lv_nmos ad=0.2886p pd=2.26u as=0.14875p ps=1.16u w=0.74u l=0.13u
X2931 a_78039_23756# B_uq43 a_78002_24065# VSS sg13_lv_nmos ad=0.2176p pd=1.96u as=78.39999f ps=0.885u w=0.64u l=0.13u
X2932 a_31022_64782# L_HI_uq21 VSS VSS sg13_lv_nmos ad=60.89999f pd=0.71u as=0.1626p ps=1.415u w=0.42u l=0.13u
X2933 a_4297_36603# a_4321_36711# VSS VSS sg13_lv_nmos ad=0.1428p pd=1.52u as=0.1426p ps=1.16u w=0.42u l=0.5u
X2934 VDD B_uq89 a_6585_39650# VDD sg13_lv_pmos ad=0.1918p pd=1.5u as=0.1596p ps=1.22u w=0.84u l=0.13u
X2935 B_uq28 a_34686_10685# VSS VSS sg13_lv_nmos ad=0.2886p pd=2.26u as=0.14875p ps=1.16u w=0.74u l=0.13u
X2936 VDD din[27] a_76063_18457# VDD sg13_lv_pmos ad=0.2114p pd=1.54u as=0.2856p ps=2.36u w=0.84u l=0.13u
X2937 Q_uq18 a_3535_37434# VDD VDD sg13_lv_pmos ad=0.3808p pd=2.92u as=0.2128p ps=1.5u w=1.12u l=0.13u
X2938 VSS L_HI_uq10 a_41808_64782# VSS sg13_lv_nmos ad=0.1626p pd=1.415u as=60.89999f ps=0.71u w=0.42u l=0.13u
X2939 VDD a_35722_8379# a_35680_8709# VDD sg13_lv_pmos ad=0.2618p pd=1.63u as=0.1176p ps=1.33u w=1.12u l=0.13u
X2940 a_6559_33047# a_6559_33211# a_6595_33175# VSS sg13_lv_nmos ad=0.1428p pd=1.52u as=37.8f ps=0.6u w=0.42u l=0.13u
X2941 VDD a_6217_21130# a_6319_21130# VDD sg13_lv_pmos ad=1.37097p pd=8.54u as=0.3864p ps=2.93u w=1.12u l=0.13u
X2942 VSS B_uq64 Y_uq133 VSS sg13_lv_nmos ad=0.1463p pd=1.15u as=0.1694p ps=1.21u w=0.77u l=0.13u
X2943 X_uq314 a_7320_39999# VSS VSS sg13_lv_nmos ad=0.1628p pd=1.18u as=0.3108p ps=2.32u w=0.74u l=0.13u
X2944 VDD VSS VDD VDD sg13_lv_pmos ad=0.19p pd=1.38u as=0 ps=0 w=1u l=1u
X2945 VDD a_46402_7625# X_uq38 VDD sg13_lv_pmos ad=0.2114p pd=1.54u as=0.42p ps=2.99u w=1.12u l=0.13u
X2946 D_uq2 a_80301_23023# VDD VDD sg13_lv_pmos ad=0.4256p pd=3u as=0.2254p ps=1.53u w=1.12u l=0.13u
X2947 a_34715_64705# a_33873_64355# a_34621_64705# VSS sg13_lv_nmos ad=0.12665p pd=1.145u as=0.1428p ps=1.52u w=0.42u l=0.13u
X2948 Y_uq64 C_uq23 VSS VSS sg13_lv_nmos ad=0.1694p pd=1.21u as=0.1463p ps=1.15u w=0.77u l=0.13u
X2949 D_uq15 S_uq0 VSS VSS sg13_lv_nmos ad=0.1406p pd=1.12u as=0.2516p ps=2.16u w=0.74u l=0.13u
X2950 B_uq88 B_uq86 VDD VDD sg13_lv_pmos ad=0.2128p pd=1.5u as=0.2198p ps=1.53u w=1.12u l=0.13u
X2951 VSS a_37187_63663# a_37187_63663# VSS sg13_lv_nmos ad=3.5825p pd=23.78u as=0.111p ps=1.34u w=0.3u l=0.13u
X2952 VSS clk a_79286_20664# VSS sg13_lv_nmos ad=2.61888p pd=17.445u as=0.2516p ps=2.16u w=0.74u l=0.13u
X2953 Q_uq58 a_32406_65392# VSS VSS sg13_lv_nmos ad=0.2516p pd=2.16u as=0.1406p ps=1.12u w=0.74u l=0.13u
X2954 VDD a_40258_7625# X_uq50 VDD sg13_lv_pmos ad=0.2114p pd=1.54u as=0.42p ps=2.99u w=1.12u l=0.13u
X2955 VDD A_uq99 a_32382_9961# VDD sg13_lv_pmos ad=0.2114p pd=1.54u as=0.2856p ps=2.36u w=0.84u l=0.13u
X2956 a_4173_25993# a_4297_25692# VDD VDD sg13_lv_pmos ad=0.2442p pd=2.06u as=1.17282p ps=7.015u w=0.66u l=0.13u
X2957 a_29734_68086# Q_uq57 VDD VDD sg13_lv_pmos ad=0.1428p pd=1.52u as=0.1523p ps=1.38u w=0.42u l=0.13u
X2958 Y_uq52 Y_uq56 a_76650_21041# VSS sg13_lv_nmos ad=0.1406p pd=1.12u as=0.1406p ps=1.12u w=0.74u l=0.13u
X2959 Y_uq328 Y_uq314 VSS VSS sg13_lv_nmos ad=0.1694p pd=1.21u as=0.1463p ps=1.15u w=0.77u l=0.13u
X2960 VDD a_44482_8375# X_uq59 VDD sg13_lv_pmos ad=0.2114p pd=1.54u as=0.42p ps=2.99u w=1.12u l=0.13u
X2961 VSS Y_uq122 a_10481_25435# VSS sg13_lv_nmos ad=0.14875p pd=1.16u as=0.187p ps=1.78u w=0.55u l=0.13u
X2962 a_42326_68416# X_uq413 Y_uq337 VDD sg13_lv_pmos ad=0.1176p pd=1.33u as=0.3808p ps=2.92u w=1.12u l=0.13u
X2963 a_33348_10301# B_uq14 a_33254_10301# VDD sg13_lv_pmos ad=0.1596p pd=1.22u as=0.2856p ps=2.36u w=0.84u l=0.13u
X2964 VSS X_uq436 D_uq59 VSS sg13_lv_nmos ad=0.2618p pd=2.22u as=0.1694p ps=1.21u w=0.77u l=0.13u
X2965 Y_uq131 C_uq20 VSS VSS sg13_lv_nmos ad=0.1406p pd=1.12u as=0.2516p ps=2.16u w=0.74u l=0.13u
X2966 a_80593_25947# Q_uq7 VSS VSS sg13_lv_nmos ad=0.1428p pd=1.52u as=79.8f ps=0.8u w=0.42u l=0.13u
X2967 Y_uq29 X_uq144 VSS VSS sg13_lv_nmos ad=0.1406p pd=1.12u as=0.2516p ps=2.16u w=0.74u l=0.13u
X2968 a_51320_69594# Y_uq353 VDD VDD sg13_lv_pmos ad=0.2856p pd=2.36u as=0.2114p ps=1.54u w=0.84u l=0.13u
X2969 VSS C_uq24 a_9746_24671# VSS sg13_lv_nmos ad=0.13395p pd=1.12u as=0.198p ps=1.27u w=0.55u l=0.13u
X2970 VSS Y_uq270 a_28484_65098# VSS sg13_lv_nmos ad=79.8f pd=0.8u as=0.1428p ps=1.52u w=0.42u l=0.13u
X2971 VDD a_33862_67609# L_HI_uq24 VDD sg13_lv_pmos ad=1.19383p pd=7.16u as=0.3927p ps=2.99u w=1.155u l=0.13u
X2972 VDD A_uq90 a_34014_6937# VDD sg13_lv_pmos ad=0.2114p pd=1.54u as=0.2856p ps=2.36u w=0.84u l=0.13u
X2973 a_37378_7625# A_uq97 VDD VDD sg13_lv_pmos ad=0.2856p pd=2.36u as=0.2114p ps=1.54u w=0.84u l=0.13u
X2974 a_8916_36842# a_8871_37079# a_8837_36271# VDD sg13_lv_pmos ad=0.1428p pd=1.52u as=79.8f ps=0.8u w=0.42u l=0.13u
X2975 VDD a_30875_67729# a_31132_67610# VDD sg13_lv_pmos ad=1.19383p pd=7.16u as=79.8f ps=0.8u w=0.42u l=0.13u
X2976 Y_uq205 Q_uq19 VSS VSS sg13_lv_nmos ad=0.1694p pd=1.21u as=0.2618p ps=2.22u w=0.77u l=0.13u
X2977 VDD din[10] a_75295_26741# VDD sg13_lv_pmos ad=0.2114p pd=1.54u as=0.2856p ps=2.36u w=0.84u l=0.13u
X2978 VDD a_30982_68339# L_HI_uq32 VDD sg13_lv_pmos ad=1.42837p pd=8.61u as=0.3927p ps=2.99u w=1.155u l=0.13u
X2979 VDD a_52186_68307# X_uq412 VDD sg13_lv_pmos ad=0.2254p pd=1.53u as=0.4256p ps=3u w=1.12u l=0.13u
X2980 VSS a_8071_42647# a_8107_42579# VSS sg13_lv_nmos ad=79.8f pd=0.8u as=0.1428p ps=1.52u w=0.42u l=0.13u
X2981 VSS a_43162_63771# X_uq345 VSS sg13_lv_nmos ad=0.1426p pd=1.16u as=0.2516p ps=2.16u w=0.74u l=0.13u
X2982 a_76453_19181# Y_uq37 Y_uq47 VDD sg13_lv_pmos ad=0.2128p pd=1.5u as=0.3808p ps=2.92u w=1.12u l=0.13u
X2983 a_42562_6863# Y_uq29 VDD VDD sg13_lv_pmos ad=0.2856p pd=2.36u as=0.2114p ps=1.54u w=0.84u l=0.13u
X2984 a_5083_32983# Y_uq167 VSS VSS sg13_lv_nmos ad=37.8f pd=0.6u as=79.8f ps=0.8u w=0.42u l=0.13u
X2985 a_35074_7625# A_uq7 VSS VSS sg13_lv_nmos ad=0.187p pd=1.78u as=0.14875p ps=1.16u w=0.55u l=0.13u
X2986 VDD L_HI_uq20 a_37106_66294# VDD sg13_lv_pmos ad=0.36237p pd=2.605u as=79.8f ps=0.8u w=0.42u l=0.13u
X2987 C_uq46 X_uq379 a_31478_64344# VDD sg13_lv_pmos ad=0.3808p pd=2.92u as=0.1176p ps=1.33u w=1.12u l=0.13u
X2988 VSS L_HI_uq34 a_47568_69630# VSS sg13_lv_nmos ad=0.1626p pd=1.415u as=60.89999f ps=0.71u w=0.42u l=0.13u
X2989 VSS Y_uq265 a_38740_63620# VSS sg13_lv_nmos ad=0.14875p pd=1.16u as=0.187p ps=1.78u w=0.55u l=0.13u
X2990 a_51057_67379# clk VSS VSS sg13_lv_nmos ad=0.2516p pd=2.16u as=2.0066p ps=12.72u w=0.74u l=0.13u
X2991 VDD a_50444_65269# Q_uq43 VDD sg13_lv_pmos ad=0.2128p pd=1.5u as=0.3808p ps=2.92u w=1.12u l=0.13u
X2992 a_28064_67332# X_uq420 VSS VSS sg13_lv_nmos ad=0.187p pd=1.78u as=0.17255p ps=1.25u w=0.55u l=0.13u
X2993 a_6194_25922# a_6309_25921# VSS VSS sg13_lv_nmos ad=0.1428p pd=1.52u as=0.1426p ps=1.16u w=0.42u l=0.5u
X2994 X_uq275 a_76735_29041# VDD VDD sg13_lv_pmos ad=0.42p pd=2.99u as=0.2114p ps=1.54u w=1.12u l=0.13u
X2995 VDD a_77699_28217# X_uq267 VDD sg13_lv_pmos ad=0.2114p pd=1.54u as=0.42p ps=2.99u w=1.12u l=0.13u
X2996 X_uq168 a_32574_9173# VDD VDD sg13_lv_pmos ad=0.42p pd=2.99u as=0.2114p ps=1.54u w=1.12u l=0.13u
X2997 a_3535_41591# Y_uq230 VDD VDD sg13_lv_pmos ad=79.8f pd=0.8u as=1.31615p ps=8.395u w=0.42u l=0.13u
X2998 a_33648_68131# a_33360_68436# a_33586_68131# VSS sg13_lv_nmos ad=0.1428p pd=1.52u as=37.8f ps=0.6u w=0.42u l=0.13u
X2999 VDD L_HI_uq3 a_5774_23604# VDD sg13_lv_pmos ad=0.1563p pd=1.22u as=0.147p ps=1.54u w=0.42u l=0.13u
X3000 Y_uq174 X_uq297 VSS VSS sg13_lv_nmos ad=0.2516p pd=2.16u as=0.2516p ps=2.16u w=0.74u l=0.13u
X3001 VDD Y_uq6 a_32862_6937# VDD sg13_lv_pmos ad=0.2114p pd=1.54u as=0.2856p ps=2.36u w=0.84u l=0.13u
X3002 B_uq88 a_4297_37910# a_4703_37834# VSS sg13_lv_nmos ad=0.333p pd=2.38u as=0.1406p ps=1.12u w=0.74u l=0.13u
X3003 a_76438_22181# Y_uq73 B1 VDD sg13_lv_pmos ad=0.2744p pd=1.61u as=0.2128p ps=1.5u w=1.12u l=0.13u
X3004 a_44408_64308# Q_uq32 VSS VSS sg13_lv_nmos ad=0.187p pd=1.78u as=0.14875p ps=1.16u w=0.55u l=0.13u
X3005 VDD a_37379_66687# a_37379_66921# VDD sg13_lv_pmos ad=1.19383p pd=7.16u as=0.2442p ps=2.06u w=0.66u l=0.13u
X3006 a_43930_69819# a_44045_69820# VSS VSS sg13_lv_nmos ad=0.1428p pd=1.52u as=0.1426p ps=1.16u w=0.42u l=0.5u
X3007 VDD a_4297_43188# a_4420_42743# VDD sg13_lv_pmos ad=1.31615p pd=8.395u as=79.8f ps=0.8u w=0.42u l=0.13u
X3008 a_79068_26752# clk VSS VSS sg13_lv_nmos ad=0.2516p pd=2.16u as=2.61888p ps=17.445u w=0.74u l=0.13u
X3009 VDD Q_uq25 B_uq83 VDD sg13_lv_pmos ad=0.2198p pd=1.53u as=0.2128p ps=1.5u w=1.12u l=0.13u
X3010 a_78939_24480# a_78651_24785# a_78877_24480# VSS sg13_lv_nmos ad=0.1428p pd=1.52u as=37.8f ps=0.6u w=0.42u l=0.13u
X3011 Y_uq246 X_uq345 a_44824_63880# VDD sg13_lv_pmos ad=0.3808p pd=2.92u as=0.1176p ps=1.33u w=1.12u l=0.13u
X3012 a_45376_10685# X_uq145 Y_uq27 VDD sg13_lv_pmos ad=0.1176p pd=1.33u as=0.3808p ps=2.92u w=1.12u l=0.13u
X3013 a_29616_68884# a_29590_68848# VDD VDD sg13_lv_pmos ad=0.34p pd=2.68u as=0.36237p ps=2.605u w=1u l=0.13u
X3014 D_uq24 D_uq25 VSS VSS sg13_lv_nmos ad=0.2516p pd=2.16u as=0.2516p ps=2.16u w=0.74u l=0.13u
X3015 a_28305_64344# X_uq436 VDD VDD sg13_lv_pmos ad=0.2464p pd=1.56u as=0.3808p ps=2.92u w=1.12u l=0.13u
X3016 VDD Y_uq107 a_10001_23923# VDD sg13_lv_pmos ad=0.2114p pd=1.54u as=0.2856p ps=2.36u w=0.84u l=0.13u
X3017 VDD a_40198_68339# L_HI_uq28 VDD sg13_lv_pmos ad=1.42837p pd=8.61u as=0.3927p ps=2.99u w=1.155u l=0.13u
X3018 VSS din[4] a_76735_29041# VSS sg13_lv_nmos ad=0.14875p pd=1.16u as=0.187p ps=1.78u w=0.55u l=0.13u
X3019 a_42058_9891# X_uq141 VSS VSS sg13_lv_nmos ad=0.187p pd=1.78u as=0.17255p ps=1.25u w=0.55u l=0.13u
X3020 VSS Q_uq25 a_8115_37211# VSS sg13_lv_nmos ad=0.18575p pd=1.26u as=0.1406p ps=1.12u w=0.74u l=0.13u
X3021 a_38182_65062# Y_uq266 VDD VDD sg13_lv_pmos ad=0.1428p pd=1.52u as=0.1523p ps=1.38u w=0.42u l=0.13u
X3022 a_8956_37847# Y_uq197 VDD VDD sg13_lv_pmos ad=79.8f pd=0.8u as=1.5243p ps=9.795u w=0.42u l=0.13u
X3023 VSS a_10468_42743# a_10742_42358# VSS sg13_lv_nmos ad=79.8f pd=0.8u as=0.1428p ps=1.52u w=0.42u l=0.13u
X3024 VDD reset a_40084_69668# VDD sg13_lv_pmos ad=0.2114p pd=1.54u as=0.2856p ps=2.36u w=0.84u l=0.13u
X3025 VDD A_uq87 a_40740_8789# VDD sg13_lv_pmos ad=0.2226p pd=1.535u as=0.1596p ps=1.22u w=0.84u l=0.13u
X3026 VSS C_uq15 Y_uq33 VSS sg13_lv_nmos ad=0.2516p pd=2.16u as=0.1406p ps=1.12u w=0.74u l=0.13u
X3027 a_77699_28217# din[8] VDD VDD sg13_lv_pmos ad=0.2856p pd=2.36u as=0.2114p ps=1.54u w=0.84u l=0.13u
X3028 VSS A0 a_7715_40155# VSS sg13_lv_nmos ad=0.15245p pd=1.17u as=88.8f ps=0.98u w=0.74u l=0.13u
X3029 VSS A_uq57 a_36510_9173# VSS sg13_lv_nmos ad=0.14875p pd=1.16u as=0.187p ps=1.78u w=0.55u l=0.13u
X3030 a_5774_21087# a_6217_21130# a_6157_21166# VDD sg13_lv_pmos ad=79.8f pd=0.8u as=63f ps=0.72u w=0.42u l=0.13u
X3031 VSS a_28748_64631# Q_uq48 VSS sg13_lv_nmos ad=0.1406p pd=1.12u as=0.2516p ps=2.16u w=0.74u l=0.13u
X3032 a_8071_33019# a_8086_31722# a_8071_32685# VDD sg13_lv_pmos ad=0.2048p pd=1.63u as=0.34p ps=2.68u w=1u l=0.13u
X3033 VDD a_47480_66570# q[25] VDD sg13_lv_pmos ad=0.2114p pd=1.54u as=0.42p ps=2.99u w=1.12u l=0.13u
X3034 X_uq323 a_5047_40319# VSS VSS sg13_lv_nmos ad=0.2886p pd=2.26u as=0.14875p ps=1.16u w=0.74u l=0.13u
X3035 VDD Y_uq347 a_31732_65856# VDD sg13_lv_pmos ad=0.2114p pd=1.54u as=0.2856p ps=2.36u w=0.84u l=0.13u
X3036 VSS a_35842_7625# X_uq68 VSS sg13_lv_nmos ad=0.14875p pd=1.16u as=0.2886p ps=2.26u w=0.74u l=0.13u
X3037 VDD a_80076_28300# a_79155_28614# VDD sg13_lv_pmos ad=0.36237p pd=2.605u as=0.34p ps=2.68u w=1u l=0.13u
X3038 Q_uq7 a_80577_26741# VSS VSS sg13_lv_nmos ad=0.2516p pd=2.16u as=0.1406p ps=1.12u w=0.74u l=0.13u
X3039 VDD X_uq144 a_41508_10301# VDD sg13_lv_pmos ad=0.2226p pd=1.535u as=0.1596p ps=1.22u w=0.84u l=0.13u
X3040 D_uq56 Y_uq311 VSS VSS sg13_lv_nmos ad=0.1694p pd=1.21u as=0.1463p ps=1.15u w=0.77u l=0.13u
X3041 Y_uq155 X_uq271 VDD VDD sg13_lv_pmos ad=0.3808p pd=2.92u as=0.3808p ps=2.92u w=1.12u l=0.13u
X3042 a_47466_68370# a_47267_68433# VSS VSS sg13_lv_nmos ad=0.27427p pd=2.28u as=2.08687p ps=13.23u w=0.795u l=0.13u
X3043 Y_uq15 X_uq168 a_34722_9173# VDD sg13_lv_pmos ad=0.3808p pd=2.92u as=0.1176p ps=1.33u w=1.12u l=0.13u
X3044 Y_uq65 A_N VSS VSS sg13_lv_nmos ad=0.1694p pd=1.21u as=0.2618p ps=2.22u w=0.77u l=0.13u
X3045 Y_uq109 D_uq5 a_11659_24183# VDD sg13_lv_pmos ad=0.4368p pd=3.02u as=0.2128p ps=1.5u w=1.12u l=0.13u
X3046 VDD a_38266_66795# X_uq401 VDD sg13_lv_pmos ad=0.2254p pd=1.53u as=0.4256p ps=3u w=1.12u l=0.13u
X3047 a_38556_9149# A_uq88 VDD VDD sg13_lv_pmos ad=0.1596p pd=1.22u as=0.2226p ps=1.535u w=0.84u l=0.13u
X3048 VDD X_uq160 a_35550_6937# VDD sg13_lv_pmos ad=0.2114p pd=1.54u as=0.2856p ps=2.36u w=0.84u l=0.13u
X3049 a_10428_32924# Y_uq164 VDD VDD sg13_lv_pmos ad=79.8f pd=0.8u as=0.36237p ps=2.605u w=0.42u l=0.13u
X3050 VDD X_uq323 Y_uq236 VDD sg13_lv_pmos ad=0.3808p pd=2.92u as=0.3808p ps=2.92u w=1.12u l=0.13u
X3051 a_34766_10067# A_uq98 VSS VSS sg13_lv_nmos ad=0.1045p pd=0.93u as=0.1469p ps=1.155u w=0.55u l=0.13u
X3052 B_uq5 a_34686_8449# VSS VSS sg13_lv_nmos ad=0.2886p pd=2.26u as=0.14875p ps=1.16u w=0.74u l=0.13u
X3053 VDD a_50552_63546# q[26] VDD sg13_lv_pmos ad=0.2114p pd=1.54u as=0.42p ps=2.99u w=1.12u l=0.13u
X3054 a_51964_64586# a_51707_64705# a_52126_64782# VSS sg13_lv_nmos ad=0.1428p pd=1.52u as=37.8f ps=0.6u w=0.42u l=0.13u
X3055 a_78625_24690# a_79068_24446# a_78365_24467# VSS sg13_lv_nmos ad=79.8f pd=0.8u as=0.1296p ps=1.52u w=0.42u l=0.13u
X3056 a_4297_24154# clk VDD VDD sg13_lv_pmos ad=0.4088p pd=2.97u as=0.94357p ps=5.8u w=1.12u l=0.13u
X3057 VDD a_78181_21632# X_uq201 VDD sg13_lv_pmos ad=0.2254p pd=1.53u as=0.4256p ps=3u w=1.12u l=0.13u
X3058 D_uq35 a_29250_63650# VDD VDD sg13_lv_pmos ad=0.4256p pd=3u as=0.2254p ps=1.53u w=1.12u l=0.13u
X3059 VSS VDD VSS VSS sg13_lv_nmos ad=0.1428p pd=1.52u as=0 ps=-0 w=0.42u l=1u
X3060 VDD a_8835_37148# a_8871_37079# VDD sg13_lv_pmos ad=1.5243p pd=9.795u as=0.3864p ps=2.93u w=1.12u l=0.13u
X3061 VDD X_uq446 a_52504_63880# VDD sg13_lv_pmos ad=0.4032p pd=2.96u as=0.1176p ps=1.33u w=1.12u l=0.13u
X3062 a_33072_66606# D_uq49 a_32978_66606# VSS sg13_lv_nmos ad=60.89999f pd=0.71u as=0.1428p ps=1.52u w=0.42u l=0.13u
X3063 a_42010_65283# a_42125_65284# VSS VSS sg13_lv_nmos ad=0.1428p pd=1.52u as=0.1426p ps=1.16u w=0.42u l=0.5u
X3064 a_49778_65098# a_49508_65098# VSS VSS sg13_lv_nmos ad=0.1428p pd=1.52u as=79.8f ps=0.8u w=0.42u l=0.5u
X3065 VDD a_79502_29084# a_79502_29318# VDD sg13_lv_pmos ad=4.72727p pd=30.285u as=0.2442p ps=2.06u w=0.66u l=0.13u
X3066 a_31132_69122# a_30875_69241# a_31294_69318# VSS sg13_lv_nmos ad=0.1428p pd=1.52u as=37.8f ps=0.6u w=0.42u l=0.13u
X3067 a_35868_10301# A_uq98 VDD VDD sg13_lv_pmos ad=0.1596p pd=1.22u as=0.2226p ps=1.535u w=0.84u l=0.13u
X3068 VSS Y_uq250 a_41236_63620# VSS sg13_lv_nmos ad=0.14875p pd=1.16u as=0.187p ps=1.78u w=0.55u l=0.13u
X3069 C1_uq2 C_uq23 VSS VSS sg13_lv_nmos ad=0.1694p pd=1.21u as=0.1463p ps=1.15u w=0.77u l=0.13u
X3070 a_10428_35594# D_uq19 VDD VDD sg13_lv_pmos ad=79.8f pd=0.8u as=0.1428p ps=1.52u w=0.42u l=0.13u
X3071 a_4337_32361# a_4335_33143# a_4297_34356# VSS sg13_lv_nmos ad=0.3473p pd=2.71u as=0.12665p ps=1.145u w=0.74u l=0.13u
X3072 a_36533_69218# a_36657_68917# VDD VDD sg13_lv_pmos ad=0.2442p pd=2.06u as=1.42837p ps=8.61u w=0.66u l=0.13u
X3073 VDD din[9] a_75295_27529# VDD sg13_lv_pmos ad=0.2114p pd=1.54u as=0.2856p ps=2.36u w=0.84u l=0.13u
X3074 a_4297_34766# X_uq294 a_4681_34894# VSS sg13_lv_nmos ad=0.2176p pd=1.96u as=0.1216p ps=1.02u w=0.64u l=0.13u
X3075 X_uq72 a_45350_9149# VDD VDD sg13_lv_pmos ad=0.3976p pd=2.95u as=0.2226p ps=1.535u w=1.12u l=0.13u
X3076 a_6125_41738# a_5849_41193# a_6270_41419# VSS sg13_lv_nmos ad=0.1428p pd=1.52u as=37.8f ps=0.6u w=0.42u l=0.13u
X3077 VDD a_30982_63550# a_30701_63772# VDD sg13_lv_pmos ad=0.1523p pd=1.38u as=0.34p ps=2.68u w=1u l=0.5u
X3078 VDD Y_uq283 a_27796_65856# VDD sg13_lv_pmos ad=0.2114p pd=1.54u as=0.2856p ps=2.36u w=0.84u l=0.13u
X3079 VSS X_uq449 a_43738_68936# VSS sg13_lv_nmos ad=0.17255p pd=1.25u as=0.187p ps=1.78u w=0.55u l=0.13u
X3080 B2 X_uq189 VDD VDD sg13_lv_pmos ad=0.3808p pd=2.92u as=0.3808p ps=2.92u w=1.12u l=0.13u
X3081 a_32536_65856# a_32314_65912# VDD VDD sg13_lv_pmos ad=0.1176p pd=1.33u as=0.2618p ps=1.63u w=1.12u l=0.13u
X3082 a_45644_67655# a_45763_67332# VSS VSS sg13_lv_nmos ad=0.2516p pd=2.16u as=0.1406p ps=1.12u w=0.74u l=0.13u
X3083 VDD A_uq93 a_32766_8449# VDD sg13_lv_pmos ad=0.2114p pd=1.54u as=0.2856p ps=2.36u w=0.84u l=0.13u
X3084 a_34688_63550# X_uq433 VDD VDD sg13_lv_pmos ad=0.2856p pd=2.36u as=0.2618p ps=1.63u w=0.84u l=0.13u
X3085 a_5047_32855# Y_uq167 VDD VDD sg13_lv_pmos ad=79.8f pd=0.8u as=1.86053p ps=12.055u w=0.42u l=0.13u
X3086 VSS X_uq450 a_49690_67424# VSS sg13_lv_nmos ad=0.17255p pd=1.25u as=0.187p ps=1.78u w=0.55u l=0.13u
X3087 VDD a_34619_68195# a_35286_68416# VDD sg13_lv_pmos ad=0.2128p pd=1.5u as=0.3864p ps=2.93u w=1.12u l=0.13u
X3088 C_uq15 C VDD VDD sg13_lv_pmos ad=0.2128p pd=1.5u as=0.2198p ps=1.53u w=1.12u l=0.13u
X3089 VSS a_36316_66098# a_35965_66217# VSS sg13_lv_nmos ad=79.8f pd=0.8u as=0.1428p ps=1.52u w=0.42u l=0.13u
X3090 a_76953_25229# B2_uq7 a_76741_25229# VDD sg13_lv_pmos ad=0.2128p pd=1.5u as=0.2128p ps=1.5u w=1.12u l=0.13u
X3091 a_9247_38875# Q_uq23 VSS VSS sg13_lv_nmos ad=0.1406p pd=1.12u as=0.1406p ps=1.12u w=0.74u l=0.15u
X3092 a_33430_64312# a_33873_64355# a_33813_64391# VDD sg13_lv_pmos ad=79.8f pd=0.8u as=63f ps=0.72u w=0.42u l=0.13u
X3093 a_43058_66294# a_43863_65867# a_43318_65824# VDD sg13_lv_pmos ad=0.1428p pd=1.52u as=79.8f ps=0.8u w=0.42u l=0.13u
X3094 a_4301_32335# a_4299_33212# a_4380_32718# VDD sg13_lv_pmos ad=79.8f pd=0.8u as=63f ps=0.72u w=0.42u l=0.13u
X3095 X_uq168 a_32574_9173# VSS VSS sg13_lv_nmos ad=0.2886p pd=2.26u as=0.14875p ps=1.16u w=0.74u l=0.13u
X3096 VSS a_77699_28217# X_uq267 VSS sg13_lv_nmos ad=0.14875p pd=1.16u as=0.2886p ps=2.26u w=0.74u l=0.13u
X3097 VDD Y_uq186 a_10349_35023# VDD sg13_lv_pmos ad=0.1563p pd=1.22u as=0.147p ps=1.54u w=0.42u l=0.13u
X3098 VSS a_35246_10067# A_uq91 VSS sg13_lv_nmos ad=0.1469p pd=1.155u as=0.2516p ps=2.16u w=0.74u l=0.13u
X3099 a_52376_68844# Q_uq40 VSS VSS sg13_lv_nmos ad=0.187p pd=1.78u as=0.14875p ps=1.16u w=0.55u l=0.13u
X3100 Y_uq74 B_uq38 VSS VSS sg13_lv_nmos ad=0.1406p pd=1.12u as=0.2516p ps=2.16u w=0.74u l=0.13u
X3101 VSS C_uq52 Y_uq270 VSS sg13_lv_nmos ad=0.1463p pd=1.15u as=0.2618p ps=2.22u w=0.77u l=0.13u
X3102 VSS B_uq67 a_77144_22553# VSS sg13_lv_nmos ad=0.2516p pd=2.16u as=0.1406p ps=1.12u w=0.74u l=0.13u
X3103 VSS a_40952_63546# q[17] VSS sg13_lv_nmos ad=0.14875p pd=1.16u as=0.2886p ps=2.26u w=0.74u l=0.13u
X3104 a_45974_68416# X_uq448 VDD VDD sg13_lv_pmos ad=0.1176p pd=1.33u as=0.4032p ps=2.96u w=1.12u l=0.13u
X3105 VSS a_4152_22595# Y_uq94 VSS sg13_lv_nmos ad=0.17255p pd=1.25u as=0.1406p ps=1.12u w=0.74u l=0.13u
X3106 a_43036_69850# L_HI_uq36 VDD VDD sg13_lv_pmos ad=79.8f pd=0.8u as=1.6733p ps=10.405u w=0.42u l=0.13u
X3107 X_uq325 a_9583_43295# VDD VDD sg13_lv_pmos ad=0.42p pd=2.99u as=0.2114p ps=1.54u w=1.12u l=0.13u
X3108 a_9583_39451# a_9598_38154# a_9619_39219# VSS sg13_lv_nmos ad=0.12665p pd=1.145u as=0.1428p ps=1.52u w=0.42u l=0.13u
X3109 a_5047_36237# a_5092_34839# VDD VDD sg13_lv_pmos ad=0.34p pd=2.68u as=0.36237p ps=2.605u w=1u l=0.13u
X3110 VDD A_uq87 a_39588_10301# VDD sg13_lv_pmos ad=0.2226p pd=1.535u as=0.1596p ps=1.22u w=0.84u l=0.13u
X3111 a_10345_43188# a_10347_42044# a_10742_42358# VSS sg13_lv_nmos ad=0.12665p pd=1.145u as=0.1428p ps=1.52u w=0.42u l=0.13u
X3112 a_40277_68064# a_40401_68161# VDD VDD sg13_lv_pmos ad=0.2442p pd=2.06u as=1.42837p ps=8.61u w=0.66u l=0.13u
X3113 VSS a_3535_37051# a_3535_37434# VSS sg13_lv_nmos ad=0.1406p pd=1.12u as=0.2516p ps=2.16u w=0.74u l=0.13u
X3114 a_32049_66649# a_32049_66649# VSS VSS sg13_lv_nmos ad=0.111p pd=1.34u as=1.8643p ps=11.96u w=0.3u l=0.13u
X3115 a_5523_21946# a_4681_21848# a_5429_21946# VSS sg13_lv_nmos ad=0.12665p pd=1.145u as=0.1428p ps=1.52u w=0.42u l=0.13u
X3116 a_31185_68161# a_31185_68161# VSS VSS sg13_lv_nmos ad=0.111p pd=1.34u as=2.08687p ps=13.23u w=0.3u l=0.13u
X3117 Y_uq240 Y_uq256 VSS VSS sg13_lv_nmos ad=0.1694p pd=1.21u as=0.1463p ps=1.15u w=0.77u l=0.13u
X3118 a_8845_33355# Q_uq14 VDD VDD sg13_lv_pmos ad=0.1596p pd=1.22u as=0.2226p ps=1.535u w=0.84u l=0.13u
X3119 VDD Y_uq189 a_5083_34571# VDD sg13_lv_pmos ad=0.36237p pd=2.605u as=79.8f ps=0.8u w=0.42u l=0.13u
X3120 VSS a_5809_35739# B_uq78 VSS sg13_lv_nmos ad=0.1426p pd=1.16u as=0.2516p ps=2.16u w=0.74u l=0.13u
X3121 a_36466_69643# L_HI_uq38 VSS VSS sg13_lv_nmos ad=37.8f pd=0.6u as=0.1701p ps=1.65u w=0.42u l=0.13u
X3122 VDD X_uq433 a_36826_66648# VDD sg13_lv_pmos ad=0.2618p pd=1.63u as=0.2856p ps=2.36u w=0.84u l=0.13u
X3123 VDD X_uq239 a_10481_23135# VDD sg13_lv_pmos ad=0.2114p pd=1.54u as=0.2856p ps=2.36u w=0.84u l=0.13u
X3124 VDD a_4297_43188# a_4297_43290# VDD sg13_lv_pmos ad=0.2128p pd=1.5u as=0.3864p ps=2.93u w=1.12u l=0.13u
X3125 a_50289_68917# a_50289_68917# VSS VSS sg13_lv_nmos ad=0.111p pd=1.34u as=2.01085p ps=12.81u w=0.3u l=0.13u
X3126 a_11238_18599# C_uq1 Y_uq34 VDD sg13_lv_pmos ad=0.2128p pd=1.5u as=0.3808p ps=2.92u w=1.12u l=0.13u
X3127 a_77699_28217# din[8] VSS VSS sg13_lv_nmos ad=0.187p pd=1.78u as=0.14875p ps=1.16u w=0.55u l=0.13u
X3128 a_43138_7625# A VDD VDD sg13_lv_pmos ad=0.2856p pd=2.36u as=0.2114p ps=1.54u w=0.84u l=0.13u
X3129 VSS a_79910_24544# a_80577_24765# VSS sg13_lv_nmos ad=0.1406p pd=1.12u as=0.2516p ps=2.16u w=0.74u l=0.13u
X3130 a_38266_66795# a_38381_66796# VSS VSS sg13_lv_nmos ad=0.1428p pd=1.52u as=0.1426p ps=1.16u w=0.42u l=0.5u
X3131 Y_uq329 X_uq411 VSS VSS sg13_lv_nmos ad=0.1406p pd=1.12u as=0.2516p ps=2.16u w=0.74u l=0.13u
X3132 a_50746_69147# a_50861_69146# VSS VSS sg13_lv_nmos ad=0.1428p pd=1.52u as=0.1426p ps=1.16u w=0.42u l=0.5u
X3133 a_76747_23253# Y_uq80 VDD VDD sg13_lv_pmos ad=0.2128p pd=1.5u as=0.3808p ps=2.92u w=1.12u l=0.13u
X3134 D_uq27 C_uq37 a_9917_37212# VDD sg13_lv_pmos ad=0.3808p pd=2.92u as=0.2128p ps=1.5u w=1.12u l=0.13u
X3135 a_79910_27102# a_79068_26752# a_79816_27102# VSS sg13_lv_nmos ad=0.12665p pd=1.145u as=0.1428p ps=1.52u w=0.42u l=0.13u
X3136 VSS Y_uq180 a_6591_35227# VSS sg13_lv_nmos ad=0.1406p pd=1.12u as=0.2516p ps=2.16u w=0.74u l=0.15u
X3137 a_4380_41550# a_4337_41193# VDD VDD sg13_lv_pmos ad=63f pd=0.72u as=0.1563p ps=1.22u w=0.42u l=0.13u
X3138 a_34523_66683# a_33681_66585# a_33264_66924# VDD sg13_lv_pmos ad=0.2048p pd=1.63u as=0.34p ps=2.68u w=1u l=0.13u
X3139 VDD a_9583_39287# a_9934_39198# VDD sg13_lv_pmos ad=1.17462p pd=7.44u as=93.45f ps=0.865u w=0.42u l=0.13u
X3140 a_40451_68927# D_uq62 a_41198_69318# VSS sg13_lv_nmos ad=0.1428p pd=1.52u as=60.89999f ps=0.71u w=0.42u l=0.13u
X3141 a_32818_69643# L_HI_uq39 VSS VSS sg13_lv_nmos ad=37.8f pd=0.6u as=0.1701p ps=1.65u w=0.42u l=0.13u
X3142 Y_uq3 A_uq88 a_39042_8709# VDD sg13_lv_pmos ad=0.3808p pd=2.92u as=0.1176p ps=1.33u w=1.12u l=0.13u
X3143 VSS VDD VSS VSS sg13_lv_nmos ad=79.8f pd=0.8u as=0 ps=-0 w=0.42u l=1u
X3144 VDD X_uq446 a_48154_66648# VDD sg13_lv_pmos ad=0.2618p pd=1.63u as=0.2856p ps=2.36u w=0.84u l=0.13u
X3145 X_uq31 a_34398_6937# VSS VSS sg13_lv_nmos ad=0.2886p pd=2.26u as=0.14875p ps=1.16u w=0.74u l=0.13u
X3146 X_uq176 a_12209_18599# VSS VSS sg13_lv_nmos ad=0.2886p pd=2.26u as=0.14875p ps=1.16u w=0.74u l=0.13u
X3147 L_HI_uq8 a_79701_29255# VDD VDD sg13_lv_pmos ad=0.3927p pd=2.99u as=4.72727p ps=30.285u w=1.155u l=0.13u
X3148 a_50776_65094# a_50563_65058# VDD VDD sg13_lv_pmos ad=79.8f pd=0.8u as=1.41367p ps=8.85u w=0.42u l=0.13u
X3149 a_37048_66904# a_36826_66648# VDD VDD sg13_lv_pmos ad=0.1176p pd=1.33u as=0.2618p ps=1.63u w=1.12u l=0.13u
X3150 a_37122_9173# a_36900_9229# VDD VDD sg13_lv_pmos ad=0.1176p pd=1.33u as=0.2618p ps=1.63u w=1.12u l=0.13u
X3151 B2_uq8 X_uq264 VDD VDD sg13_lv_pmos ad=0.3808p pd=2.92u as=0.3808p ps=2.92u w=1.12u l=0.13u
X3152 VDD a_6194_25922# D_uq9 VDD sg13_lv_pmos ad=0.2254p pd=1.53u as=0.4256p ps=3u w=1.12u l=0.13u
X3153 VDD Y_uq232 a_8837_40975# VDD sg13_lv_pmos ad=0.1563p pd=1.22u as=0.147p ps=1.54u w=0.42u l=0.13u
X3154 VSS Y_uq239 a_35668_63620# VSS sg13_lv_nmos ad=0.14875p pd=1.16u as=0.187p ps=1.78u w=0.55u l=0.13u
X3155 VDD Q_uq4 a_7340_25655# VDD sg13_lv_pmos ad=0.2114p pd=1.54u as=0.2856p ps=2.36u w=0.84u l=0.13u
X3156 a_5092_34839# a_5062_35274# a_5474_35214# VDD sg13_lv_pmos ad=79.8f pd=0.8u as=63f ps=0.72u w=0.42u l=0.13u
X3157 a_36242_67806# D_uq55 VDD VDD sg13_lv_pmos ad=79.8f pd=0.8u as=0.1428p ps=1.52u w=0.42u l=0.13u
X3158 VDD Q_uq0 a_6572_20395# VDD sg13_lv_pmos ad=0.2114p pd=1.54u as=0.2856p ps=2.36u w=0.84u l=0.13u
X3159 a_33828_10301# B_uq13 a_33734_10301# VDD sg13_lv_pmos ad=0.1596p pd=1.22u as=0.2856p ps=2.36u w=0.84u l=0.13u
X3160 VDD X_uq294 a_4333_31825# VDD sg13_lv_pmos ad=0.4032p pd=2.96u as=0.1176p ps=1.33u w=1.12u l=0.13u
X3161 VSS Y_uq309 a_34132_63620# VSS sg13_lv_nmos ad=0.14875p pd=1.16u as=0.187p ps=1.78u w=0.55u l=0.13u
X3162 VSS a_34108_69850# a_33757_69707# VSS sg13_lv_nmos ad=79.8f pd=0.8u as=0.1428p ps=1.52u w=0.42u l=0.13u
X3163 a_5396_24385# a_5139_24504# a_5558_24581# VSS sg13_lv_nmos ad=0.1428p pd=1.52u as=37.8f ps=0.6u w=0.42u l=0.13u
X3164 a_33717_68509# a_33360_68436# VDD VDD sg13_lv_pmos ad=63f pd=0.72u as=0.1563p ps=1.22u w=0.42u l=0.13u
X3165 a_6590_25619# Y_uq133 VDD VDD sg13_lv_pmos ad=0.1428p pd=1.52u as=0.1523p ps=1.38u w=0.42u l=0.13u
X3166 VSS Y_uq25 a_35934_6937# VSS sg13_lv_nmos ad=0.14875p pd=1.16u as=0.187p ps=1.78u w=0.55u l=0.13u
X3167 a_36945_67379# clk VDD VDD sg13_lv_pmos ad=0.4088p pd=2.97u as=1.17087p ps=7.02u w=1.12u l=0.13u
X3168 VSS Q_uq44 Y_uq239 VSS sg13_lv_nmos ad=0.2516p pd=2.16u as=0.2516p ps=2.16u w=0.74u l=0.13u
X3169 VDD a_43906_7625# X_uq43 VDD sg13_lv_pmos ad=0.2114p pd=1.54u as=0.42p ps=2.99u w=1.12u l=0.13u
X3170 VDD a_4297_40155# X_uq315 VDD sg13_lv_pmos ad=0.2254p pd=1.53u as=0.4256p ps=3u w=1.12u l=0.13u
X3171 Q_uq22 a_3535_42138# VSS VSS sg13_lv_nmos ad=0.2516p pd=2.16u as=0.1406p ps=1.12u w=0.74u l=0.13u
X3172 a_11278_22671# X_uq236 VDD VDD sg13_lv_pmos ad=0.2464p pd=1.56u as=0.3808p ps=2.92u w=1.12u l=0.13u
X3173 a_3584_35563# Y_uq194 VSS VSS sg13_lv_nmos ad=37.8f pd=0.6u as=0.1701p ps=1.65u w=0.42u l=0.13u
X3174 VDD Q_uq3 a_77807_22959# VDD sg13_lv_pmos ad=0.1523p pd=1.38u as=0.1428p ps=1.52u w=0.42u l=0.13u
X3175 a_79008_24858# a_78651_24785# VDD VDD sg13_lv_pmos ad=63f pd=0.72u as=0.1563p ps=1.22u w=0.42u l=0.13u
X3176 VDD a_30586_63771# X_uq406 VDD sg13_lv_pmos ad=0.2254p pd=1.53u as=0.4256p ps=3u w=1.12u l=0.13u
X3177 a_28918_65824# a_29361_65867# a_28658_66294# VSS sg13_lv_nmos ad=79.8f pd=0.8u as=0.1296p ps=1.52u w=0.42u l=0.13u
X3178 VSS B_uq63 a_10727_20907# VSS sg13_lv_nmos ad=0.18575p pd=1.26u as=0.187p ps=1.78u w=0.55u l=0.13u
X3179 VDD a_9583_42737# VEVAL1 VDD sg13_lv_pmos ad=0.2114p pd=1.54u as=0.42p ps=2.99u w=1.12u l=0.13u
X3180 a_37682_64782# D_uq39 VDD VDD sg13_lv_pmos ad=79.8f pd=0.8u as=0.1428p ps=1.52u w=0.42u l=0.13u
X3181 VDD a_44219_67729# a_44476_67610# VDD sg13_lv_pmos ad=1.19383p pd=7.16u as=79.8f ps=0.8u w=0.42u l=0.13u
X3182 a_39832_65856# Q_uq37 C_uq59 VDD sg13_lv_pmos ad=0.1176p pd=1.33u as=0.3808p ps=2.92u w=1.12u l=0.13u
X3183 a_78059_19145# C_uq23 VDD VDD sg13_lv_pmos ad=0.2856p pd=2.36u as=0.2618p ps=1.63u w=0.84u l=0.13u
X3184 VSS a_43042_10649# B_uq19 VSS sg13_lv_nmos ad=0.14875p pd=1.16u as=0.2886p ps=2.26u w=0.74u l=0.13u
X3185 a_30194_65094# a_30999_65216# a_30454_65317# VDD sg13_lv_pmos ad=0.1428p pd=1.52u as=79.8f ps=0.8u w=0.42u l=0.13u
X3186 a_35110_65062# Y_uq276 VDD VDD sg13_lv_pmos ad=0.1428p pd=1.52u as=0.1523p ps=1.38u w=0.42u l=0.13u
X3187 VSS VDD VSS VSS sg13_lv_nmos ad=0.1428p pd=1.52u as=0 ps=-0 w=0.42u l=1u
X3188 D_uq42 X_uq445 VSS VSS sg13_lv_nmos ad=0.1694p pd=1.21u as=0.2618p ps=2.22u w=0.77u l=0.13u
X3189 Q_uq54 a_43446_69928# VSS VSS sg13_lv_nmos ad=0.2516p pd=2.16u as=0.1406p ps=1.12u w=0.74u l=0.13u
X3190 VSS X_uq387 Y_uq280 VSS sg13_lv_nmos ad=0.2516p pd=2.16u as=0.1406p ps=1.12u w=0.74u l=0.13u
X3191 a_78787_28691# a_78574_28217# VDD VDD sg13_lv_pmos ad=79.8f pd=0.8u as=1.59725p ps=10.05u w=0.42u l=0.13u
X3192 a_6913_35325# Y_uq180 VDD VDD sg13_lv_pmos ad=0.2128p pd=1.5u as=0.3808p ps=2.92u w=1.12u l=0.15u
X3193 VDD a_78757_23984# B_uq48 VDD sg13_lv_pmos ad=0.2254p pd=1.53u as=0.4256p ps=3u w=1.12u l=0.13u
X3194 a_10689_24647# C_uq22 a_10587_24647# VDD sg13_lv_pmos ad=0.2128p pd=1.5u as=0.2128p ps=1.5u w=1.12u l=0.13u
X3195 VDD a_31832_68082# A_uq8 VDD sg13_lv_pmos ad=0.2114p pd=1.54u as=0.42p ps=2.99u w=1.12u l=0.13u
X3196 VSS Y_uq57 a_12593_18599# VSS sg13_lv_nmos ad=0.14875p pd=1.16u as=0.187p ps=1.78u w=0.55u l=0.13u
X3197 a_5514_23381# D_uq6 VDD VDD sg13_lv_pmos ad=79.8f pd=0.8u as=0.1428p ps=1.52u w=0.42u l=0.13u
X3198 VSS X_uq436 D_uq65 VSS sg13_lv_nmos ad=0.2618p pd=2.22u as=0.1694p ps=1.21u w=0.77u l=0.13u
X3199 VSS a_50933_69576# a_50854_69851# VSS sg13_lv_nmos ad=2.01085p pd=12.81u as=0.27427p ps=2.28u w=0.795u l=0.13u
X3200 a_4380_41738# a_4335_41975# a_4301_41167# VDD sg13_lv_pmos ad=0.1428p pd=1.52u as=79.8f ps=0.8u w=0.42u l=0.13u
X3201 VSS VDD VSS VSS sg13_lv_nmos ad=0.1428p pd=1.52u as=0 ps=-0 w=0.42u l=1u
X3202 a_6494_22595# Y_uq91 VDD VDD sg13_lv_pmos ad=0.1428p pd=1.52u as=0.1523p ps=1.38u w=0.42u l=0.13u
X3203 X_uq20 a_38622_6937# VDD VDD sg13_lv_pmos ad=0.42p pd=2.99u as=0.2114p ps=1.54u w=1.12u l=0.13u
X3204 VSS C_uq36 a_7321_31295# VSS sg13_lv_nmos ad=0.14875p pd=1.16u as=0.187p ps=1.78u w=0.55u l=0.13u
X3205 VSS A2_uq6 a_77245_27517# VSS sg13_lv_nmos ad=0.2516p pd=2.16u as=0.1406p ps=1.12u w=0.74u l=0.13u
X3206 B_uq93 a_4297_39674# VDD VDD sg13_lv_pmos ad=0.2128p pd=1.5u as=0.3808p ps=2.92u w=1.12u l=0.13u
X3207 X_uq36 a_32478_6937# VDD VDD sg13_lv_pmos ad=0.42p pd=2.99u as=0.2114p ps=1.54u w=1.12u l=0.13u
X3208 a_49112_63546# Q_uq54 VSS VSS sg13_lv_nmos ad=0.187p pd=1.78u as=0.14875p ps=1.16u w=0.55u l=0.13u
X3209 a_6194_25922# a_6309_25921# VDD VDD sg13_lv_pmos ad=0.34p pd=2.68u as=0.2254p ps=1.53u w=1u l=0.5u
X3210 VSS a_46786_6863# X_uq0 VSS sg13_lv_nmos ad=0.14875p pd=1.16u as=0.2886p ps=2.26u w=0.74u l=0.13u
X3211 C_uq22 a_10009_25775# VSS VSS sg13_lv_nmos ad=0.2516p pd=2.16u as=0.1469p ps=1.155u w=0.74u l=0.13u
X3212 VSS a_33873_64355# a_33975_64355# VSS sg13_lv_nmos ad=4.5737p pd=28.36u as=0.2516p ps=2.16u w=0.74u l=0.13u
X3213 Y_uq317 a_48154_66648# VSS VSS sg13_lv_nmos ad=0.1406p pd=1.12u as=0.17255p ps=1.25u w=0.74u l=0.13u
X3214 SLN[5] a_31732_65856# VSS VSS sg13_lv_nmos ad=0.2886p pd=2.26u as=0.14875p ps=1.16u w=0.74u l=0.13u
X3215 Y_uq295 a_40186_65136# VSS VSS sg13_lv_nmos ad=0.1406p pd=1.12u as=0.17255p ps=1.25u w=0.74u l=0.13u
X3216 a_36885_67415# a_36528_67372# VDD VDD sg13_lv_pmos ad=63f pd=0.72u as=0.1563p ps=1.22u w=0.42u l=0.13u
X3217 a_36816_67793# a_37047_67379# a_36502_67336# VSS sg13_lv_nmos ad=0.2373p pd=1.97u as=79.8f ps=0.8u w=0.42u l=0.13u
X3218 a_5166_21119# B_uq50 Y_uq66 VDD sg13_lv_pmos ad=0.1176p pd=1.33u as=0.3808p ps=2.92u w=1.12u l=0.13u
X3219 D_uq37 a_49026_65162# VDD VDD sg13_lv_pmos ad=0.4256p pd=3u as=0.2254p ps=1.53u w=1.12u l=0.13u
X3220 VSS Y_uq344 D_uq64 VSS sg13_lv_nmos ad=0.1463p pd=1.15u as=0.1694p ps=1.21u w=0.77u l=0.13u
X3221 a_34330_67635# a_34445_67634# VSS VSS sg13_lv_nmos ad=0.1428p pd=1.52u as=0.1426p ps=1.16u w=0.42u l=0.5u
X3222 VSS X_uq239 a_10481_23135# VSS sg13_lv_nmos ad=0.14875p pd=1.16u as=0.187p ps=1.78u w=0.55u l=0.13u
X3223 VDD a_44194_10649# X_uq138 VDD sg13_lv_pmos ad=0.2114p pd=1.54u as=0.42p ps=2.99u w=1.12u l=0.13u
X3224 B2_uq7 B1_uq6 a_76459_24493# VSS sg13_lv_nmos ad=0.2516p pd=2.16u as=0.1406p ps=1.12u w=0.74u l=0.13u
X3225 VSS S Y_uq205 VSS sg13_lv_nmos ad=0.1463p pd=1.15u as=0.1694p ps=1.21u w=0.77u l=0.13u
X3226 a_51142_68844# Q_uq41 VDD VDD sg13_lv_pmos ad=0.1428p pd=1.52u as=0.1523p ps=1.38u w=0.42u l=0.13u
X3227 VSS B_uq68 D_uq10 VSS sg13_lv_nmos ad=0.1463p pd=1.15u as=0.1694p ps=1.21u w=0.77u l=0.13u
X3228 VDD a_5396_24385# a_5341_24266# VDD sg13_lv_pmos ad=1.02937p pd=6.325u as=93.45f ps=0.865u w=0.42u l=0.13u
X3229 VSS a_49778_65856# a_49890_65880# VSS sg13_lv_nmos ad=0.1426p pd=1.16u as=0.1428p ps=1.52u w=0.42u l=0.5u
X3230 a_37070_11001# X_uq162 VSS VSS sg13_lv_nmos ad=0.1045p pd=0.93u as=0.1469p ps=1.155u w=0.55u l=0.13u
X3231 a_46051_64308# a_46611_64431# a_46522_64467# VDD sg13_lv_pmos ad=0.2048p pd=1.63u as=93.45f ps=0.865u w=0.42u l=0.13u
X3232 a_30214_66574# Q_uq39 VSS VSS sg13_lv_nmos ad=0.1428p pd=1.52u as=79.8f ps=0.8u w=0.42u l=0.13u
X3233 VDD a_9583_31222# Q_uq9 VDD sg13_lv_pmos ad=0.2128p pd=1.5u as=0.3808p ps=2.92u w=1.12u l=0.13u
X3234 C_uq2 a_75295_19969# VSS VSS sg13_lv_nmos ad=0.2886p pd=2.26u as=0.14875p ps=1.16u w=0.74u l=0.13u
X3235 a_38256_64769# a_38487_64355# a_37942_64312# VSS sg13_lv_nmos ad=0.2373p pd=1.97u as=79.8f ps=0.8u w=0.42u l=0.13u
X3236 VSS Q_uq58 Y_uq256 VSS sg13_lv_nmos ad=0.2516p pd=2.16u as=0.1406p ps=1.12u w=0.74u l=0.13u
X3237 VDD X_uq74 a_43908_9229# VDD sg13_lv_pmos ad=0.2618p pd=1.63u as=0.2856p ps=2.36u w=0.84u l=0.13u
X3238 a_3854_24111# a_4297_24154# a_4237_24190# VDD sg13_lv_pmos ad=79.8f pd=0.8u as=63f ps=0.72u w=0.42u l=0.13u
X3239 VDD VSS VDD VDD sg13_lv_pmos ad=0.34p pd=2.68u as=0 ps=0 w=1u l=1u
X3240 VSS VDD VSS VSS sg13_lv_nmos ad=79.8f pd=0.8u as=0 ps=-0 w=0.42u l=1u
X3241 VDD a_35014_63803# L_HI_uq15 VDD sg13_lv_pmos ad=1.4745p pd=9.07u as=0.3927p ps=2.99u w=1.155u l=0.13u
X3242 a_41714_64782# D_uq38 VDD VDD sg13_lv_pmos ad=79.8f pd=0.8u as=0.1428p ps=1.52u w=0.42u l=0.13u
X3243 VDD L_HI_uq14 a_40082_66294# VDD sg13_lv_pmos ad=0.36237p pd=2.605u as=79.8f ps=0.8u w=0.42u l=0.13u
X3244 a_7261_21242# a_6319_21130# a_7059_21480# VDD sg13_lv_pmos ad=93.45f pd=0.865u as=0.2048p ps=1.63u w=0.42u l=0.13u
X3245 Y_uq214 C_uq36 a_9247_38875# VSS sg13_lv_nmos ad=0.2516p pd=2.16u as=0.1406p ps=1.12u w=0.74u l=0.15u
X3246 VDD B1_uq6 a_76556_20693# VDD sg13_lv_pmos ad=0.2128p pd=1.5u as=0.3808p ps=2.92u w=1.12u l=0.13u
X3247 VSS a_7321_33723# X_uq286 VSS sg13_lv_nmos ad=0.1426p pd=1.16u as=0.2516p ps=2.16u w=0.74u l=0.13u
X3248 a_5051_42745# a_5087_43067# VSS VSS sg13_lv_nmos ad=0.1428p pd=1.52u as=0.1426p ps=1.16u w=0.42u l=0.5u
X3249 VDD a_46210_10649# B_uq16 VDD sg13_lv_pmos ad=0.2114p pd=1.54u as=0.42p ps=2.99u w=1.12u l=0.13u
X3250 VSS Q_uq10 a_8833_31967# VSS sg13_lv_nmos ad=0.14875p pd=1.16u as=0.187p ps=1.78u w=0.55u l=0.13u
X3251 Y_uq344 X_uq434 VSS VSS sg13_lv_nmos ad=0.1406p pd=1.12u as=0.2516p ps=2.16u w=0.74u l=0.13u
X3252 a_78574_20657# a_79134_20780# a_79045_20816# VDD sg13_lv_pmos ad=0.2048p pd=1.63u as=93.45f ps=0.865u w=0.42u l=0.13u
X3253 a_44194_10649# X_uq333 VDD VDD sg13_lv_pmos ad=0.2856p pd=2.36u as=0.2114p ps=1.54u w=0.84u l=0.13u
X3254 a_32566_69853# a_33009_69609# a_32949_70021# VDD sg13_lv_pmos ad=79.8f pd=0.8u as=63f ps=0.72u w=0.42u l=0.13u
X3255 A_uq7 a_27796_65856# VSS VSS sg13_lv_nmos ad=0.2886p pd=2.26u as=0.14875p ps=1.16u w=0.74u l=0.13u
X3256 Y_uq235 a_5051_42266# VDD VDD sg13_lv_pmos ad=0.2128p pd=1.5u as=0.3808p ps=2.92u w=1.12u l=0.13u
X3257 VSS a_47644_66098# a_47293_66217# VSS sg13_lv_nmos ad=79.8f pd=0.8u as=0.1428p ps=1.52u w=0.42u l=0.13u
X3258 VDD a_51964_64586# a_51909_64467# VDD sg13_lv_pmos ad=1.4745p pd=9.07u as=93.45f ps=0.865u w=0.42u l=0.13u
X3259 C_uq32 X_uq294 VSS VSS sg13_lv_nmos ad=0.1406p pd=1.12u as=0.2516p ps=2.16u w=0.74u l=0.13u
X3260 VSS Y_uq197 a_9307_36105# VSS sg13_lv_nmos ad=0.1626p pd=1.415u as=60.89999f ps=0.71u w=0.42u l=0.13u
X3261 a_9619_40043# D_uq26 VDD VDD sg13_lv_pmos ad=79.8f pd=0.8u as=0.1428p ps=1.52u w=0.42u l=0.13u
X3262 VDD a_10468_42743# a_10504_42654# VDD sg13_lv_pmos ad=1.17462p pd=7.44u as=93.45f ps=0.865u w=0.42u l=0.13u
X3263 VSS a_40642_6863# X_uq15 VSS sg13_lv_nmos ad=0.14875p pd=1.16u as=0.2886p ps=2.26u w=0.74u l=0.13u
X3264 VSS A_uq75 a_44294_10301# VSS sg13_lv_nmos ad=0.1469p pd=1.155u as=0.1045p ps=0.93u w=0.55u l=0.13u
X3265 VSS a_80167_26983# a_79816_27102# VSS sg13_lv_nmos ad=79.8f pd=0.8u as=0.1428p ps=1.52u w=0.42u l=0.13u
X3266 D_uq1 C_uq24 VDD VDD sg13_lv_pmos ad=0.2128p pd=1.5u as=0.2198p ps=1.53u w=1.12u l=0.13u
X3267 VDD Y_uq49 a_12209_18599# VDD sg13_lv_pmos ad=0.2114p pd=1.54u as=0.2856p ps=2.36u w=0.84u l=0.13u
X3268 a_8916_36842# D_uq23 VDD VDD sg13_lv_pmos ad=79.8f pd=0.8u as=0.1428p ps=1.52u w=0.42u l=0.13u
X3269 VDD a_47553_64391# a_46632_64705# VDD sg13_lv_pmos ad=0.36237p pd=2.605u as=0.34p ps=2.68u w=1u l=0.13u
X3270 a_48646_67332# Q_uq51 VSS VSS sg13_lv_nmos ad=0.1428p pd=1.52u as=79.8f ps=0.8u w=0.42u l=0.13u
X3271 a_45250_7625# X_uq97 VDD VDD sg13_lv_pmos ad=0.2856p pd=2.36u as=0.2114p ps=1.54u w=0.84u l=0.13u
X3272 VDD C_uq20 a_11861_18135# VDD sg13_lv_pmos ad=0.4032p pd=2.96u as=0.1176p ps=1.33u w=1.12u l=0.13u
X3273 VDD a_44866_6863# X_uq4 VDD sg13_lv_pmos ad=0.2114p pd=1.54u as=0.42p ps=2.99u w=1.12u l=0.13u
X3274 Q_uq0 a_7726_21119# VDD VDD sg13_lv_pmos ad=0.3808p pd=2.92u as=0.2128p ps=1.5u w=1.12u l=0.13u
X3275 a_3571_37015# Y_uq194 VSS VSS sg13_lv_nmos ad=37.8f pd=0.6u as=79.8f ps=0.8u w=0.42u l=0.13u
X3276 VDD a_4299_33212# a_4335_33143# VDD sg13_lv_pmos ad=1.31615p pd=8.395u as=0.3864p ps=2.93u w=1.12u l=0.13u
X3277 a_76549_26277# B1_uq6 a_76651_26277# VDD sg13_lv_pmos ad=0.3808p pd=2.92u as=0.2128p ps=1.5u w=1.12u l=0.13u
X3278 a_37838_8555# B a_37980_8789# VDD sg13_lv_pmos ad=0.2856p pd=2.36u as=0.1596p ps=1.22u w=0.84u l=0.13u
X3279 a_40546_10649# X_uq339 VDD VDD sg13_lv_pmos ad=0.2856p pd=2.36u as=0.2114p ps=1.54u w=0.84u l=0.13u
X3280 VDD a_38986_9137# a_38944_9173# VDD sg13_lv_pmos ad=0.2618p pd=1.63u as=0.1176p ps=1.33u w=1.12u l=0.13u
X3281 a_42634_8379# X_uq77 VDD VDD sg13_lv_pmos ad=0.2856p pd=2.36u as=0.2618p ps=1.63u w=0.84u l=0.13u
X3282 VSS Y_uq317 D_uq53 VSS sg13_lv_nmos ad=0.1463p pd=1.15u as=0.1694p ps=1.21u w=0.77u l=0.13u
X3283 VDD Y_uq194 a_3580_35319# VDD sg13_lv_pmos ad=0.1563p pd=1.22u as=0.147p ps=1.54u w=0.42u l=0.13u
X3284 VSS a_36730_68307# D_uq55 VSS sg13_lv_nmos ad=0.1426p pd=1.16u as=0.2516p ps=2.16u w=0.74u l=0.13u
X3285 a_39032_68082# X_uq426 VDD VDD sg13_lv_pmos ad=0.2856p pd=2.36u as=0.2114p ps=1.54u w=0.84u l=0.13u
X3286 a_9149_36842# a_8871_37079# a_8837_36271# VSS sg13_lv_nmos ad=0.2373p pd=1.97u as=79.8f ps=0.8u w=0.42u l=0.13u
X3287 VDD VSS VDD VDD sg13_lv_pmos ad=0.34p pd=2.68u as=0 ps=0 w=1u l=1u
X3288 VSS Y_uq172 a_3571_31535# VSS sg13_lv_nmos ad=79.8f pd=0.8u as=37.8f ps=0.6u w=0.42u l=0.13u
X3289 X_uq16 a_40158_6937# VSS VSS sg13_lv_nmos ad=0.2886p pd=2.26u as=0.14875p ps=1.16u w=0.74u l=0.13u
X3290 a_5062_35274# clk VDD VDD sg13_lv_pmos ad=0.4088p pd=2.97u as=1.72762p ps=11.19u w=1.12u l=0.13u
X3291 X_uq226 a_3500_23419# VDD VDD sg13_lv_pmos ad=0.42p pd=2.99u as=0.2114p ps=1.54u w=1.12u l=0.13u
X3292 a_30682_66795# a_30797_66796# VDD VDD sg13_lv_pmos ad=0.34p pd=2.68u as=0.2254p ps=1.53u w=1u l=0.5u
X3293 VSS X_uq433 a_35194_68936# VSS sg13_lv_nmos ad=0.17255p pd=1.25u as=0.187p ps=1.78u w=0.55u l=0.13u
X3294 a_8873_41001# a_8837_40975# VSS VSS sg13_lv_nmos ad=0.2516p pd=2.16u as=0.1626p ps=1.415u w=0.74u l=0.13u
X3295 C_uq49 X_uq446 VSS VSS sg13_lv_nmos ad=0.1406p pd=1.12u as=0.2516p ps=2.16u w=0.74u l=0.13u
X3296 VSS X_uq433 a_36826_66648# VSS sg13_lv_nmos ad=0.17255p pd=1.25u as=0.187p ps=1.78u w=0.55u l=0.13u
X3297 VDD X_uq445 a_47855_68880# VDD sg13_lv_pmos ad=0.3808p pd=2.92u as=0.2464p ps=1.56u w=1.12u l=0.13u
X3298 VDD a_50746_69147# X_uq424 VDD sg13_lv_pmos ad=0.2254p pd=1.53u as=0.4256p ps=3u w=1.12u l=0.13u
X3299 VSS a_80189_22959# a_80301_23023# VSS sg13_lv_nmos ad=0.1426p pd=1.16u as=0.1428p ps=1.52u w=0.42u l=0.5u
X3300 a_4621_22260# a_4264_22187# VDD VDD sg13_lv_pmos ad=63f pd=0.72u as=0.1563p ps=1.22u w=0.42u l=0.13u
X3301 D_uq7 a_10372_19391# a_10574_19353# VSS sg13_lv_nmos ad=0.333p pd=2.38u as=0.1406p ps=1.12u w=0.74u l=0.13u
X3302 a_78455_28540# a_78574_28217# VDD VDD sg13_lv_pmos ad=0.3864p pd=2.93u as=0.2128p ps=1.5u w=1.12u l=0.13u
X3303 VSS a_46418_66610# a_46530_66674# VSS sg13_lv_nmos ad=0.1426p pd=1.16u as=0.1428p ps=1.52u w=0.42u l=0.5u
X3304 a_32150_63880# Q_uq48 Y_uq253 VDD sg13_lv_pmos ad=0.1176p pd=1.33u as=0.3808p ps=2.92u w=1.12u l=0.13u
X3305 VDD a_10349_33537# a_10385_33469# VDD sg13_lv_pmos ad=0.36237p pd=2.605u as=0.34p ps=2.68u w=1u l=0.13u
X3306 a_43761_65867# clk VDD VDD sg13_lv_pmos ad=0.4088p pd=2.97u as=1.37835p ps=8.63u w=1.12u l=0.13u
X3307 VDD a_5780_22089# a_5725_22184# VDD sg13_lv_pmos ad=1.37097p pd=8.54u as=93.45f ps=0.865u w=0.42u l=0.13u
X3308 Y_uq360 Y_uq338 VSS VSS sg13_lv_nmos ad=0.1694p pd=1.21u as=0.1463p ps=1.15u w=0.77u l=0.13u
X3309 VSS a_41602_8375# X_uq62 VSS sg13_lv_nmos ad=0.14875p pd=1.16u as=0.2886p ps=2.26u w=0.74u l=0.13u
X3310 a_33898_9137# X_uq93 VSS VSS sg13_lv_nmos ad=0.187p pd=1.78u as=0.17255p ps=1.25u w=0.55u l=0.13u
X3311 a_3571_39849# D_uq28 a_3571_39755# VSS sg13_lv_nmos ad=60.89999f pd=0.71u as=0.1428p ps=1.52u w=0.42u l=0.13u
X3312 a_5892_41738# D_uq32 VDD VDD sg13_lv_pmos ad=79.8f pd=0.8u as=0.1428p ps=1.52u w=0.42u l=0.13u
X3313 a_30288_65094# D_uq41 a_30194_65094# VSS sg13_lv_nmos ad=60.89999f pd=0.71u as=0.1428p ps=1.52u w=0.42u l=0.13u
X3314 a_45297_69673# a_45297_69673# VSS VSS sg13_lv_nmos ad=0.111p pd=1.34u as=2.01085p ps=12.81u w=0.3u l=0.13u
X3315 Y_uq129 B_uq58 VSS VSS sg13_lv_nmos ad=0.1406p pd=1.12u as=0.1406p ps=1.12u w=0.74u l=0.13u
X3316 Y_uq42 X_uq188 VSS VSS sg13_lv_nmos ad=0.2516p pd=2.16u as=0.2516p ps=2.16u w=0.74u l=0.13u
X3317 a_4297_40155# a_4321_40263# VDD VDD sg13_lv_pmos ad=0.34p pd=2.68u as=0.2254p ps=1.53u w=1u l=0.5u
X3318 a_31078_66574# Q_uq59 VDD VDD sg13_lv_pmos ad=0.1428p pd=1.52u as=0.1523p ps=1.38u w=0.42u l=0.13u
X3319 a_45444_9149# B_uq1 a_45350_9149# VDD sg13_lv_pmos ad=0.1596p pd=1.22u as=0.2856p ps=2.36u w=0.84u l=0.13u
X3320 a_47810_64769# a_46632_64705# a_47414_64624# VSS sg13_lv_nmos ad=37.8f pd=0.6u as=0.1428p ps=1.52u w=0.42u l=0.13u
X3321 VDD Y_uq84 a_79919_22959# VDD sg13_lv_pmos ad=0.1523p pd=1.38u as=0.1428p ps=1.52u w=0.42u l=0.13u
X3322 VSS X_uq446 a_48154_66648# VSS sg13_lv_nmos ad=0.17255p pd=1.25u as=0.187p ps=1.78u w=0.55u l=0.13u
X3323 VSS a_78638_27572# a_78638_27572# VSS sg13_lv_nmos ad=2.61888p pd=17.445u as=0.111p ps=1.34u w=0.3u l=0.13u
X3324 VSS a_43354_65283# D_uq43 VSS sg13_lv_nmos ad=0.1426p pd=1.16u as=0.2516p ps=2.16u w=0.74u l=0.13u
X3325 a_29039_67368# Y_uq314 a_28937_67368# VDD sg13_lv_pmos ad=0.2464p pd=1.56u as=0.2128p ps=1.5u w=1.12u l=0.13u
X3326 a_80076_20740# a_79134_20780# a_79937_20973# VSS sg13_lv_nmos ad=79.8f pd=0.8u as=0.2373p ps=1.97u w=0.42u l=0.13u
X3327 VSS Y_uq340 a_32596_63620# VSS sg13_lv_nmos ad=0.14875p pd=1.16u as=0.187p ps=1.78u w=0.55u l=0.13u
X3328 VDD VSS VDD VDD sg13_lv_pmos ad=0.19p pd=1.38u as=0 ps=0 w=1u l=1u
X3329 VSS a_43377_67379# a_43479_67379# VSS sg13_lv_nmos ad=2.08687p pd=13.23u as=0.2516p ps=2.16u w=0.74u l=0.13u
X3330 VDD a_40930_10649# B_uq21 VDD sg13_lv_pmos ad=0.2114p pd=1.54u as=0.42p ps=2.99u w=1.12u l=0.13u
X3331 D_uq17 C_uq31 VDD VDD sg13_lv_pmos ad=0.2128p pd=1.5u as=0.3808p ps=2.92u w=1.12u l=0.15u
X3332 a_6237_37924# Y_uq199 VSS VSS sg13_lv_nmos ad=0.13875p pd=1.115u as=0.2553p ps=2.17u w=0.74u l=0.13u
X3333 VSS a_5051_41401# D_uq33 VSS sg13_lv_nmos ad=0.1426p pd=1.16u as=0.2516p ps=2.16u w=0.74u l=0.13u
X3334 Y_uq349 X_uq437 a_28024_68880# VDD sg13_lv_pmos ad=0.3808p pd=2.92u as=0.1176p ps=1.33u w=1.12u l=0.13u
X3335 a_9294_41227# Y_uq232 VSS VSS sg13_lv_nmos ad=37.8f pd=0.6u as=0.1701p ps=1.65u w=0.42u l=0.13u
X3336 VDD a_5809_39675# B_uq91 VDD sg13_lv_pmos ad=0.2198p pd=1.52u as=0.6048p ps=3.32u w=1.12u l=0.13u
X3337 VSS B_uq55 Y_uq131 VSS sg13_lv_nmos ad=0.2516p pd=2.16u as=0.1406p ps=1.12u w=0.74u l=0.13u
X3338 C_uq14 a_75295_24505# VSS VSS sg13_lv_nmos ad=0.2886p pd=2.26u as=0.14875p ps=1.16u w=0.74u l=0.13u
X3339 VSS C_uq30 D_uq16 VSS sg13_lv_nmos ad=0.1463p pd=1.15u as=0.2618p ps=2.22u w=0.77u l=0.13u
X3340 Y_uq258 X_uq431 VSS VSS sg13_lv_nmos ad=0.1694p pd=1.21u as=0.2618p ps=2.22u w=0.77u l=0.13u
X3341 D_uq36 a_49890_65162# VDD VDD sg13_lv_pmos ad=0.4256p pd=3u as=0.2254p ps=1.53u w=1.12u l=0.13u
X3342 VDD C_uq24 a_10343_22419# VDD sg13_lv_pmos ad=0.2198p pd=1.53u as=0.2856p ps=2.36u w=0.84u l=0.13u
X3343 a_9583_31222# a_9583_31324# VSS VSS sg13_lv_nmos ad=0.2516p pd=2.16u as=0.1406p ps=1.12u w=0.74u l=0.13u
X3344 VDD L_HI_uq15 a_34514_66294# VDD sg13_lv_pmos ad=0.36237p pd=2.605u as=79.8f ps=0.8u w=0.42u l=0.13u
X3345 D_uq44 X_uq435 VSS VSS sg13_lv_nmos ad=0.1694p pd=1.21u as=0.2618p ps=2.22u w=0.77u l=0.13u
X3346 Y_uq103 B1_uq2 a_79340_25229# VDD sg13_lv_pmos ad=0.3808p pd=2.92u as=0.2128p ps=1.5u w=1.12u l=0.13u
X3347 a_10428_41550# a_10385_41193# VDD VDD sg13_lv_pmos ad=63f pd=0.72u as=0.1563p ps=1.22u w=0.42u l=0.13u
X3348 VDD a_46306_9137# X_uq136 VDD sg13_lv_pmos ad=0.2114p pd=1.54u as=0.42p ps=2.99u w=1.12u l=0.13u
X3349 VSS a_44998_68086# a_44717_68308# VSS sg13_lv_nmos ad=79.8f pd=0.8u as=0.1428p ps=1.52u w=0.42u l=0.5u
X3350 a_6893_37482# Q_uq19 VDD VDD sg13_lv_pmos ad=0.2464p pd=1.56u as=0.3808p ps=2.92u w=1.12u l=0.13u
X3351 a_9934_31795# a_9583_31769# VDD VDD sg13_lv_pmos ad=93.45f pd=0.865u as=1.17462p ps=7.44u w=0.42u l=0.13u
X3352 a_6604_41175# a_6574_41610# a_6595_40907# VSS sg13_lv_nmos ad=79.8f pd=0.8u as=0.1296p ps=1.52u w=0.42u l=0.13u
X3353 a_7705_38415# Q_uq25 a_7705_38313# VSS sg13_lv_nmos ad=0.1216p pd=1.02u as=0.1216p ps=1.02u w=0.64u l=0.13u
X3354 C1 X_uq251 VSS VSS sg13_lv_nmos ad=0.1694p pd=1.21u as=0.2618p ps=2.22u w=0.77u l=0.13u
X3355 VDD X_uq255 a_8561_24647# VDD sg13_lv_pmos ad=0.2114p pd=1.54u as=0.2856p ps=2.36u w=0.84u l=0.13u
X3356 Y_uq266 C_uq45 VSS VSS sg13_lv_nmos ad=0.2618p pd=2.22u as=0.1463p ps=1.15u w=0.77u l=0.13u
X3357 a_43192_66904# a_42970_66648# VDD VDD sg13_lv_pmos ad=0.1176p pd=1.33u as=0.2618p ps=1.63u w=1.12u l=0.13u
X3358 a_35534_9489# A_uq98 VSS VSS sg13_lv_nmos ad=0.1045p pd=0.93u as=0.1469p ps=1.155u w=0.55u l=0.13u
X3359 VSS Y_uq208 Y_uq229 VSS sg13_lv_nmos ad=0.2516p pd=2.16u as=0.1406p ps=1.12u w=0.74u l=0.13u
X3360 a_44913_68891# clk VDD VDD sg13_lv_pmos ad=0.4088p pd=2.97u as=1.39265p ps=8.395u w=1.12u l=0.13u
X3361 VDD C_uq16 a_9671_18965# VDD sg13_lv_pmos ad=0.2198p pd=1.53u as=0.2856p ps=2.36u w=0.84u l=0.13u
X3362 a_4337_32361# a_4301_32335# VSS VSS sg13_lv_nmos ad=0.2516p pd=2.16u as=0.1626p ps=1.415u w=0.74u l=0.13u
X3363 VSS a_38414_9489# X_uq83 VSS sg13_lv_nmos ad=0.1469p pd=1.155u as=0.2516p ps=2.16u w=0.74u l=0.13u
X3364 a_8133_36024# X_uq312 VSS VSS sg13_lv_nmos ad=0.1406p pd=1.12u as=0.2516p ps=2.16u w=0.74u l=0.13u
X3365 a_44134_68086# Q_uq53 VDD VDD sg13_lv_pmos ad=0.1428p pd=1.52u as=0.1523p ps=1.38u w=0.42u l=0.13u
X3366 Y_uq311 X_uq409 a_33592_67368# VDD sg13_lv_pmos ad=0.3808p pd=2.92u as=0.1176p ps=1.33u w=1.12u l=0.13u
X3367 VDD a_46714_65283# X_uq373 VDD sg13_lv_pmos ad=0.2254p pd=1.53u as=0.4256p ps=3u w=1.12u l=0.13u
X3368 a_31077_69003# a_30135_68891# a_30875_69241# VDD sg13_lv_pmos ad=93.45f pd=0.865u as=0.2048p ps=1.63u w=0.42u l=0.13u
X3369 VDD L_HI_uq13 a_45842_66294# VDD sg13_lv_pmos ad=0.36237p pd=2.605u as=79.8f ps=0.8u w=0.42u l=0.13u
X3370 a_34908_10301# A_uq98 VDD VDD sg13_lv_pmos ad=0.1596p pd=1.22u as=0.2226p ps=1.535u w=0.84u l=0.13u
X3371 VSS a_46402_7625# X_uq38 VSS sg13_lv_nmos ad=0.14875p pd=1.16u as=0.2886p ps=2.26u w=0.74u l=0.13u
X3372 a_47576_63546# Y_uq304 VSS VSS sg13_lv_nmos ad=0.187p pd=1.78u as=0.14875p ps=1.16u w=0.55u l=0.13u
X3373 X_uq171 a_9329_17875# VDD VDD sg13_lv_pmos ad=0.42p pd=2.99u as=0.2114p ps=1.54u w=1.12u l=0.13u
X3374 VDD Y_uq228 a_9628_40311# VDD sg13_lv_pmos ad=0.1563p pd=1.22u as=0.147p ps=1.54u w=0.42u l=0.13u
X3375 a_3535_36887# Y_uq194 VDD VDD sg13_lv_pmos ad=79.8f pd=0.8u as=1.31615p ps=8.395u w=0.42u l=0.13u
X3376 VDD a_46786_8375# X_uq58 VDD sg13_lv_pmos ad=0.2114p pd=1.54u as=0.42p ps=2.99u w=1.12u l=0.13u
X3377 VSS a_40258_7625# X_uq50 VSS sg13_lv_nmos ad=0.14875p pd=1.16u as=0.2886p ps=2.26u w=0.74u l=0.13u
X3378 VDD din[16] a_75295_23717# VDD sg13_lv_pmos ad=0.2114p pd=1.54u as=0.2856p ps=2.36u w=0.84u l=0.13u
X3379 a_28848_69948# a_29367_69752# a_30107_69707# VSS sg13_lv_nmos ad=0.3473p pd=2.71u as=0.12665p ps=1.145u w=0.74u l=0.13u
X3380 VDD a_9583_39451# a_9583_39287# VDD sg13_lv_pmos ad=1.17462p pd=7.44u as=79.8f ps=0.8u w=0.42u l=0.13u
X3381 a_50448_64348# a_50422_64312# VSS VSS sg13_lv_nmos ad=0.2516p pd=2.16u as=0.1626p ps=1.415u w=0.74u l=0.13u
X3382 a_4777_22631# X_uq259 VDD VDD sg13_lv_pmos ad=0.2464p pd=1.56u as=0.3808p ps=2.92u w=1.12u l=0.13u
X3383 VSS X_uq430 C_uq70 VSS sg13_lv_nmos ad=0.2516p pd=2.16u as=0.1406p ps=1.12u w=0.74u l=0.13u
X3384 Y_uq45 B1_uq7 a_77323_19529# VSS sg13_lv_nmos ad=0.2516p pd=2.16u as=0.1406p ps=1.12u w=0.74u l=0.13u
X3385 VSS Y_uq55 a_9809_20111# VSS sg13_lv_nmos ad=0.14875p pd=1.16u as=0.187p ps=1.78u w=0.55u l=0.13u
X3386 VDD X_uq85 a_36318_6937# VDD sg13_lv_pmos ad=0.2114p pd=1.54u as=0.2856p ps=2.36u w=0.84u l=0.13u
X3387 VSS B_uq73 D_uq13 VSS sg13_lv_nmos ad=0.2516p pd=2.16u as=0.1406p ps=1.12u w=0.74u l=0.13u
X3388 VDD a_6559_42907# a_6559_43290# VDD sg13_lv_pmos ad=0.2128p pd=1.5u as=0.3864p ps=2.93u w=1.12u l=0.13u
X3389 a_6088_24906# a_6319_25015# a_5774_25116# VSS sg13_lv_nmos ad=0.2373p pd=1.97u as=79.8f ps=0.8u w=0.42u l=0.13u
X3390 VDD B_uq55 a_12149_25695# VDD sg13_lv_pmos ad=0.4032p pd=2.96u as=0.1176p ps=1.33u w=1.12u l=0.13u
X3391 D C_uq3 a_6139_20655# VDD sg13_lv_pmos ad=0.3808p pd=2.92u as=0.2128p ps=1.5u w=1.12u l=0.13u
X3392 a_44866_6863# X_uq99 VDD VDD sg13_lv_pmos ad=0.2856p pd=2.36u as=0.2114p ps=1.54u w=0.84u l=0.13u
X3393 a_37378_7625# A_uq97 VSS VSS sg13_lv_nmos ad=0.187p pd=1.78u as=0.14875p ps=1.16u w=0.55u l=0.13u
X3394 VSS a_79068_26752# a_79170_26752# VSS sg13_lv_nmos ad=2.61888p pd=17.445u as=0.2516p ps=2.16u w=0.74u l=0.13u
X3395 VSS a_29138_63586# a_29250_63650# VSS sg13_lv_nmos ad=0.1426p pd=1.16u as=0.1428p ps=1.52u w=0.42u l=0.5u
X3396 VDD X_uq237 a_6992_24143# VDD sg13_lv_pmos ad=0.4032p pd=2.96u as=0.1176p ps=1.33u w=1.12u l=0.13u
X3397 VSS din[10] a_75295_26741# VSS sg13_lv_nmos ad=0.14875p pd=1.16u as=0.187p ps=1.78u w=0.55u l=0.13u
X3398 VDD Y_uq172 a_3535_31673# VDD sg13_lv_pmos ad=1.31615p pd=8.395u as=79.8f ps=0.8u w=0.42u l=0.13u
X3399 a_33071_67368# Y_uq311 a_32969_67368# VDD sg13_lv_pmos ad=0.2464p pd=1.56u as=0.2128p ps=1.5u w=1.12u l=0.13u
X3400 a_52126_64782# L_HI_uq33 VSS VSS sg13_lv_nmos ad=37.8f pd=0.6u as=79.8f ps=0.8u w=0.42u l=0.13u
X3401 a_35002_69819# a_35117_69820# VDD VDD sg13_lv_pmos ad=0.34p pd=2.68u as=0.2254p ps=1.53u w=1u l=0.5u
X3402 Y_uq247 Q_uq31 VSS VSS sg13_lv_nmos ad=0.2516p pd=2.16u as=0.2516p ps=2.16u w=0.74u l=0.13u
X3403 a_79134_22292# a_79286_22176# VSS VSS sg13_lv_nmos ad=0.2516p pd=2.16u as=2.83008p ps=17.885u w=0.74u l=0.13u
X3404 VDD a_34523_66683# a_35190_66904# VDD sg13_lv_pmos ad=0.2128p pd=1.5u as=0.3864p ps=2.93u w=1.12u l=0.13u
X3405 VSS Y_uq203 a_6237_38195# VSS sg13_lv_nmos ad=0.2516p pd=2.16u as=96.2f ps=1u w=0.74u l=0.13u
X3406 a_32192_63550# X_uq458 VDD VDD sg13_lv_pmos ad=0.2856p pd=2.36u as=0.2618p ps=1.63u w=0.84u l=0.13u
X3407 VSS a_41116_67610# a_40765_67729# VSS sg13_lv_nmos ad=79.8f pd=0.8u as=0.1428p ps=1.52u w=0.42u l=0.13u
X3408 VDD a_35674_66795# X_uq409 VDD sg13_lv_pmos ad=0.2254p pd=1.53u as=0.4256p ps=3u w=1.12u l=0.13u
X3409 Y_uq237 X_uq319 VSS VSS sg13_lv_nmos ad=0.2516p pd=2.16u as=0.2516p ps=2.16u w=0.74u l=0.13u
X3410 VDD din[30] a_77215_18457# VDD sg13_lv_pmos ad=0.2114p pd=1.54u as=0.2856p ps=2.36u w=0.84u l=0.13u
X3411 a_78455_28540# a_78574_28217# VSS VSS sg13_lv_nmos ad=0.2516p pd=2.16u as=0.1406p ps=1.12u w=0.74u l=0.13u
X3412 a_51107_66997# L_HI_uq18 VDD VDD sg13_lv_pmos ad=79.8f pd=0.8u as=0.36237p ps=2.605u w=0.42u l=0.13u
X3413 Y_uq70 D_uq1 VSS VSS sg13_lv_nmos ad=0.2618p pd=2.22u as=0.1463p ps=1.15u w=0.77u l=0.13u
X3414 VSS A_uq87 Y_uq20 VSS sg13_lv_nmos ad=0.2516p pd=2.16u as=0.1406p ps=1.12u w=0.74u l=0.13u
X3415 Y_uq337 X_uq413 VSS VSS sg13_lv_nmos ad=0.1406p pd=1.12u as=0.2516p ps=2.16u w=0.74u l=0.13u
X3416 A_uq99 a_32382_8449# VDD VDD sg13_lv_pmos ad=0.42p pd=2.99u as=0.2114p ps=1.54u w=1.12u l=0.13u
X3417 X_uq268 a_77215_28253# VDD VDD sg13_lv_pmos ad=0.42p pd=2.99u as=0.2114p ps=1.54u w=1.12u l=0.13u
X3418 a_36528_67372# a_36502_67336# VDD VDD sg13_lv_pmos ad=0.34p pd=2.68u as=0.36237p ps=2.605u w=1u l=0.13u
X3419 X_uq445 a_47092_69668# VDD VDD sg13_lv_pmos ad=0.42p pd=2.99u as=0.2114p ps=1.54u w=1.12u l=0.13u
X3420 A_uq95 a_33254_10301# VSS VSS sg13_lv_nmos ad=0.2516p pd=2.16u as=0.1469p ps=1.155u w=0.74u l=0.13u
X3421 Y_uq231 X_uq323 VSS VSS sg13_lv_nmos ad=0.2516p pd=2.16u as=0.2516p ps=2.16u w=0.74u l=0.13u
X3422 VSS clk a_46475_67339# VSS sg13_lv_nmos ad=2.0066p pd=12.72u as=0.2516p ps=2.16u w=0.74u l=0.13u
X3423 a_42588_10301# X_uq144 VDD VDD sg13_lv_pmos ad=0.1596p pd=1.22u as=0.2226p ps=1.535u w=0.84u l=0.13u
X3424 a_78939_24480# a_79170_24589# a_78625_24690# VSS sg13_lv_nmos ad=0.2373p pd=1.97u as=79.8f ps=0.8u w=0.42u l=0.13u
X3425 a_7320_39999# Q_uq25 VSS VSS sg13_lv_nmos ad=0.17462p pd=1.185u as=0.15245p ps=1.17u w=0.55u l=0.13u
X3426 a_49276_69850# L_HI_uq34 VDD VDD sg13_lv_pmos ad=79.8f pd=0.8u as=1.6733p ps=10.405u w=0.42u l=0.13u
X3427 a_10428_41738# a_10383_41975# a_10349_41167# VDD sg13_lv_pmos ad=0.1428p pd=1.52u as=79.8f ps=0.8u w=0.42u l=0.13u
X3428 a_36754_67793# L_HI_uq29 VSS VSS sg13_lv_nmos ad=37.8f pd=0.6u as=0.1701p ps=1.65u w=0.42u l=0.13u
X3429 a_10347_42044# clk VSS VSS sg13_lv_nmos ad=0.2516p pd=2.16u as=4.4154p ps=28.205u w=0.74u l=0.13u
X3430 VSS a_38908_66098# a_38557_66217# VSS sg13_lv_nmos ad=79.8f pd=0.8u as=0.1428p ps=1.52u w=0.42u l=0.13u
X3431 a_34821_68433# a_33879_68240# a_34619_68195# VDD sg13_lv_pmos ad=93.45f pd=0.865u as=0.2048p ps=1.63u w=0.42u l=0.13u
X3432 a_42658_10649# X_uq362 VDD VDD sg13_lv_pmos ad=0.2856p pd=2.36u as=0.2114p ps=1.54u w=0.84u l=0.13u
X3433 a_5809_38522# Q_uq25 VDD VDD sg13_lv_pmos ad=0.2856p pd=2.36u as=0.2198p ps=1.53u w=0.84u l=0.13u
X3434 VSS a_37786_65283# D_uq39 VSS sg13_lv_nmos ad=0.1426p pd=1.16u as=0.2516p ps=2.16u w=0.74u l=0.13u
X3435 a_10468_36599# a_10345_37044# a_10819_36727# VSS sg13_lv_nmos ad=0.1428p pd=1.52u as=37.8f ps=0.6u w=0.42u l=0.13u
X3436 a_40006_66574# Q_uq34 VSS VSS sg13_lv_nmos ad=0.1428p pd=1.52u as=79.8f ps=0.8u w=0.42u l=0.13u
X3437 VSS C_uq24 a_10009_25775# VSS sg13_lv_nmos ad=0.1469p pd=1.155u as=0.1045p ps=0.93u w=0.55u l=0.13u
X3438 VDD L_HI_uq40 a_28822_69853# VDD sg13_lv_pmos ad=0.1563p pd=1.22u as=0.147p ps=1.54u w=0.42u l=0.13u
X3439 VDD S_uq0 Y_uq201 VDD sg13_lv_pmos ad=0.3808p pd=2.92u as=0.2128p ps=1.5u w=1.12u l=0.13u
X3440 a_38470_68844# Q_uq55 VDD VDD sg13_lv_pmos ad=0.1428p pd=1.52u as=0.1523p ps=1.38u w=0.42u l=0.13u
X3441 a_80189_22959# a_79919_22959# VDD VDD sg13_lv_pmos ad=0.34p pd=2.68u as=0.1523p ps=1.38u w=1u l=0.5u
X3442 VDD a_51610_63771# X_uq444 VDD sg13_lv_pmos ad=0.2254p pd=1.53u as=0.4256p ps=3u w=1.12u l=0.13u
X3443 a_3580_33241# Y_uq172 VDD VDD sg13_lv_pmos ad=0.147p pd=1.54u as=0.1563p ps=1.22u w=0.42u l=0.13u
X3444 VDD a_4297_24154# a_4399_24154# VDD sg13_lv_pmos ad=1.02937p pd=6.325u as=0.3864p ps=2.93u w=1.12u l=0.13u
X3445 a_35954_69630# D_uq63 VDD VDD sg13_lv_pmos ad=79.8f pd=0.8u as=0.1428p ps=1.52u w=0.42u l=0.13u
X3446 a_4297_40155# a_4321_40263# VSS VSS sg13_lv_nmos ad=0.1428p pd=1.52u as=0.1426p ps=1.16u w=0.42u l=0.5u
X3447 VSS X_uq447 a_47092_69668# VSS sg13_lv_nmos ad=0.14875p pd=1.16u as=0.187p ps=1.78u w=0.55u l=0.13u
X3448 VDD a_39624_69241# a_40647_68927# VDD sg13_lv_pmos ad=0.1563p pd=1.22u as=63f ps=0.72u w=0.42u l=0.13u
X3449 a_4110_22631# X_uq226 Y_uq94 VDD sg13_lv_pmos ad=0.1176p pd=1.33u as=0.3808p ps=2.92u w=1.12u l=0.13u
X3450 a_39256_69318# a_39043_68844# VDD VDD sg13_lv_pmos ad=79.8f pd=0.8u as=1.42837p ps=8.61u w=0.42u l=0.13u
X3451 VDD q[11] a_35070_10685# VDD sg13_lv_pmos ad=0.2114p pd=1.54u as=0.2856p ps=2.36u w=0.84u l=0.13u
X3452 VDD a_5073_40834# X_uq321 VDD sg13_lv_pmos ad=0.3808p pd=2.92u as=0.3808p ps=2.92u w=1.12u l=0.13u
X3453 VDD D_uq35 a_30275_64391# VDD sg13_lv_pmos ad=0.1428p pd=1.52u as=79.8f ps=0.8u w=0.42u l=0.13u
X3454 VSS Q_uq34 a_38356_63620# VSS sg13_lv_nmos ad=0.14875p pd=1.16u as=0.187p ps=1.78u w=0.55u l=0.13u
X3455 a_10819_34857# D_uq19 a_10428_35594# VSS sg13_lv_nmos ad=60.89999f pd=0.71u as=0.1428p ps=1.52u w=0.42u l=0.13u
X3456 a_48914_65098# a_48644_65098# VDD VDD sg13_lv_pmos ad=0.34p pd=2.68u as=0.1523p ps=1.38u w=1u l=0.5u
X3457 X_uq164 a_33542_10661# VDD VDD sg13_lv_pmos ad=0.3976p pd=2.95u as=0.2226p ps=1.535u w=1.12u l=0.13u
X3458 VSS Y_uq36 a_8849_18599# VSS sg13_lv_nmos ad=0.14875p pd=1.16u as=0.187p ps=1.78u w=0.55u l=0.13u
X3459 VDD B_uq33 C_uq15 VDD sg13_lv_pmos ad=0.2128p pd=1.5u as=0.2128p ps=1.5u w=1.12u l=0.13u
X3460 a_3535_37051# a_3550_35754# a_3571_36819# VSS sg13_lv_nmos ad=0.12665p pd=1.145u as=0.1428p ps=1.52u w=0.42u l=0.13u
X3461 a_48922_69147# a_49037_69146# VDD VDD sg13_lv_pmos ad=0.34p pd=2.68u as=0.2254p ps=1.53u w=1u l=0.5u
X3462 VSS a_46306_9137# X_uq136 VSS sg13_lv_nmos ad=0.14875p pd=1.16u as=0.2886p ps=2.26u w=0.74u l=0.13u
X3463 VSS a_47267_68199# a_47267_68199# VSS sg13_lv_nmos ad=2.08687p pd=13.23u as=0.111p ps=1.34u w=0.3u l=0.13u
X3464 VDD a_28966_69121# L_HI_uq40 VDD sg13_lv_pmos ad=1.42837p pd=8.61u as=0.3927p ps=2.99u w=1.155u l=0.13u
X3465 a_32306_69630# D_uq64 VDD VDD sg13_lv_pmos ad=79.8f pd=0.8u as=0.1428p ps=1.52u w=0.42u l=0.13u
X3466 a_9628_33337# Y_uq165 VDD VDD sg13_lv_pmos ad=0.147p pd=1.54u as=0.1563p ps=1.22u w=0.42u l=0.13u
X3467 a_29616_67372# a_30135_67379# a_30875_67729# VSS sg13_lv_nmos ad=0.3473p pd=2.71u as=0.12665p ps=1.145u w=0.74u l=0.13u
X3468 VDD Y_uq97 a_11537_23135# VDD sg13_lv_pmos ad=0.2114p pd=1.54u as=0.2856p ps=2.36u w=0.84u l=0.13u
X3469 a_43814_10301# B_uq15 VSS VSS sg13_lv_nmos ad=0.1045p pd=0.93u as=0.187p ps=1.78u w=0.55u l=0.13u
X3470 VSS a_30369_64391# a_29448_64705# VSS sg13_lv_nmos ad=0.1626p pd=1.415u as=0.2516p ps=2.16u w=0.74u l=0.13u
X3471 VDD a_35458_7625# B_uq11 VDD sg13_lv_pmos ad=0.2114p pd=1.54u as=0.42p ps=2.99u w=1.12u l=0.13u
X3472 VSS reset a_77887_29041# VSS sg13_lv_nmos ad=0.14875p pd=1.16u as=0.187p ps=1.78u w=0.55u l=0.13u
X3473 Y_uq230 X_uq323 VDD VDD sg13_lv_pmos ad=0.3808p pd=2.92u as=0.3808p ps=2.92u w=1.12u l=0.13u
X3474 C_uq50 X_uq387 VSS VSS sg13_lv_nmos ad=0.1406p pd=1.12u as=0.2516p ps=2.16u w=0.74u l=0.13u
X3475 X_uq191 a_12593_20111# VSS VSS sg13_lv_nmos ad=0.2886p pd=2.26u as=0.14875p ps=1.16u w=0.74u l=0.13u
X3476 a_8107_40811# D_uq30 VDD VDD sg13_lv_pmos ad=79.8f pd=0.8u as=0.1428p ps=1.52u w=0.42u l=0.13u
X3477 VDD a_52156_67610# a_52101_67491# VDD sg13_lv_pmos ad=1.19383p pd=7.16u as=93.45f ps=0.865u w=0.42u l=0.13u
X3478 VSS L_HI_uq8 a_78881_28691# VSS sg13_lv_nmos ad=79.8f pd=0.8u as=37.8f ps=0.6u w=0.42u l=0.13u
X3479 VDD B_uq38 a_78074_20693# VDD sg13_lv_pmos ad=0.3808p pd=2.92u as=0.2464p ps=1.56u w=1.12u l=0.13u
X3480 a_42250_9137# X_uq138 VDD VDD sg13_lv_pmos ad=0.2856p pd=2.36u as=0.2618p ps=1.63u w=0.84u l=0.13u
X3481 VSS Y_uq240 a_28868_63586# VSS sg13_lv_nmos ad=79.8f pd=0.8u as=0.1428p ps=1.52u w=0.42u l=0.13u
X3482 a_48245_68064# a_48369_68161# VDD VDD sg13_lv_pmos ad=0.2442p pd=2.06u as=1.42837p ps=8.61u w=0.66u l=0.13u
X3483 a_12160_23135# C_uq21 a_12046_23135# VDD sg13_lv_pmos ad=0.2128p pd=1.5u as=0.2464p ps=1.56u w=1.12u l=0.13u
X3484 VSS a_8075_38617# X_uq305 VSS sg13_lv_nmos ad=0.1426p pd=1.16u as=0.2516p ps=2.16u w=0.74u l=0.13u
X3485 VSS a_80076_28300# a_79155_28614# VSS sg13_lv_nmos ad=0.1626p pd=1.415u as=0.2516p ps=2.16u w=0.74u l=0.13u
X3486 a_10383_32686# a_10347_32660# VDD VDD sg13_lv_pmos ad=0.3864p pd=2.93u as=1.17462p ps=7.44u w=1.12u l=0.13u
X3487 VDD L_HI_uq30 a_33074_68118# VDD sg13_lv_pmos ad=0.36237p pd=2.605u as=79.8f ps=0.8u w=0.42u l=0.13u
X3488 VDD D_uq30 a_10381_39578# VDD sg13_lv_pmos ad=0.2128p pd=1.5u as=0.3808p ps=2.92u w=1.12u l=0.13u
X3489 C_uq47 X_uq372 a_47222_63880# VDD sg13_lv_pmos ad=0.3808p pd=2.92u as=0.1176p ps=1.33u w=1.12u l=0.13u
X3490 C_uq73 X_uq446 VSS VSS sg13_lv_nmos ad=0.1406p pd=1.12u as=0.2516p ps=2.16u w=0.74u l=0.13u
X3491 a_41974_64312# a_42417_64355# a_41714_64782# VSS sg13_lv_nmos ad=79.8f pd=0.8u as=0.1296p ps=1.52u w=0.42u l=0.13u
X3492 a_31996_65314# L_HI_uq16 VDD VDD sg13_lv_pmos ad=79.8f pd=0.8u as=1.41367p ps=8.85u w=0.42u l=0.13u
X3493 VDD a_46632_64705# a_47655_64391# VDD sg13_lv_pmos ad=0.1563p pd=1.22u as=63f ps=0.72u w=0.42u l=0.13u
X3494 a_8075_39007# Q_uq19 VSS VSS sg13_lv_nmos ad=0.1428p pd=1.52u as=79.8f ps=0.8u w=0.42u l=0.13u
X3495 VSS Y_uq228 a_9619_40137# VSS sg13_lv_nmos ad=0.1626p pd=1.415u as=60.89999f ps=0.71u w=0.42u l=0.13u
X3496 VDD a_10347_42044# a_10383_41975# VDD sg13_lv_pmos ad=1.17462p pd=7.44u as=0.3864p ps=2.93u w=1.12u l=0.13u
X3497 a_9619_33563# D_uq17 a_9619_33479# VSS sg13_lv_nmos ad=0.1428p pd=1.52u as=60.89999f ps=0.71u w=0.42u l=0.13u
X3498 a_5845_33450# B_uq77 VDD VDD sg13_lv_pmos ad=0.2464p pd=1.56u as=0.3808p ps=2.92u w=1.12u l=0.13u
X3499 VDD Q_uq55 Y_uq309 VDD sg13_lv_pmos ad=0.3808p pd=2.92u as=0.3808p ps=2.92u w=1.12u l=0.13u
X3500 a_35674_66795# a_35789_66796# VSS VSS sg13_lv_nmos ad=0.1428p pd=1.52u as=0.1426p ps=1.16u w=0.42u l=0.5u
X3501 VDD L_HI_uq4 a_78365_24467# VDD sg13_lv_pmos ad=0.36237p pd=2.605u as=79.8f ps=0.8u w=0.42u l=0.13u
X3502 a_9937_34145# A2_uq9 D_uq17 VDD sg13_lv_pmos ad=0.2128p pd=1.5u as=0.2128p ps=1.5u w=1.12u l=0.15u
X3503 VSS B_uq10 a_36206_10067# VSS sg13_lv_nmos ad=0.187p pd=1.78u as=0.1045p ps=0.93u w=0.55u l=0.13u
X3504 VDD Q_uq19 Y_uq190 VDD sg13_lv_pmos ad=0.3808p pd=2.92u as=0.3808p ps=2.92u w=1.12u l=0.13u
X3505 Y_uq256 Q_uq58 a_27928_64344# VDD sg13_lv_pmos ad=0.3808p pd=2.92u as=0.1176p ps=1.33u w=1.12u l=0.13u
X3506 VDD X_uq66 a_36516_8453# VDD sg13_lv_pmos ad=0.2618p pd=1.63u as=0.2856p ps=2.36u w=0.84u l=0.13u
X3507 Y_uq83 X_uq211 VDD VDD sg13_lv_pmos ad=0.3808p pd=2.92u as=0.3808p ps=2.92u w=1.12u l=0.13u
X3508 a_3880_24147# a_3854_24111# VSS VSS sg13_lv_nmos ad=0.2516p pd=2.16u as=0.1626p ps=1.415u w=0.74u l=0.13u
X3509 a_30982_63550# Q_uq48 VSS VSS sg13_lv_nmos ad=0.1428p pd=1.52u as=79.8f ps=0.8u w=0.42u l=0.13u
X3510 a_40870_66574# Y_uq294 VDD VDD sg13_lv_pmos ad=0.1428p pd=1.52u as=0.1523p ps=1.38u w=0.42u l=0.13u
X3511 VSS a_46402_8375# X_uq135 VSS sg13_lv_nmos ad=0.14875p pd=1.16u as=0.2886p ps=2.26u w=0.74u l=0.13u
X3512 VSS B_uq67 a_77629_19529# VSS sg13_lv_nmos ad=0.2516p pd=2.16u as=0.1406p ps=1.12u w=0.74u l=0.13u
X3513 a_80729_28691# L_HI_uq8 VSS VSS sg13_lv_nmos ad=60.89999f pd=0.71u as=0.1626p ps=1.415u w=0.42u l=0.13u
X3514 a_9307_36105# D_uq23 a_8916_36842# VSS sg13_lv_nmos ad=60.89999f pd=0.71u as=0.1428p ps=1.52u w=0.42u l=0.13u
X3515 a_50006_66606# a_49699_66570# a_49912_66606# VSS sg13_lv_nmos ad=37.8f pd=0.6u as=0.1428p ps=1.52u w=0.42u l=0.13u
X3516 C_uq73 X_uq444 a_50582_69928# VDD sg13_lv_pmos ad=0.3808p pd=2.92u as=0.1176p ps=1.33u w=1.12u l=0.13u
X3517 a_43960_68880# a_43738_68936# VDD VDD sg13_lv_pmos ad=0.1176p pd=1.33u as=0.2618p ps=1.63u w=1.12u l=0.13u
X3518 VSS a_40258_8375# A_uq87 VSS sg13_lv_nmos ad=0.14875p pd=1.16u as=0.2886p ps=2.26u w=0.74u l=0.13u
X3519 VSS L_HI_uq17 a_50870_65094# VSS sg13_lv_nmos ad=79.8f pd=0.8u as=37.8f ps=0.6u w=0.42u l=0.13u
X3520 VDD a_7316_25113# a_7261_25208# VDD sg13_lv_pmos ad=1.17282p pd=7.015u as=93.45f ps=0.865u w=0.42u l=0.13u
X3521 VDD a_9609_34825# D_uq19 VDD sg13_lv_pmos ad=0.36195p pd=1.84u as=0.3808p ps=2.92u w=1.12u l=0.13u
X3522 VDD X_uq436 a_32687_64344# VDD sg13_lv_pmos ad=0.3808p pd=2.92u as=0.2464p ps=1.56u w=1.12u l=0.13u
X3523 a_30480_65412# a_30454_65317# VDD VDD sg13_lv_pmos ad=0.34p pd=2.68u as=0.36237p ps=2.605u w=1u l=0.13u
X3524 VSS Y_uq280 D_uq49 VSS sg13_lv_nmos ad=0.1463p pd=1.15u as=0.1694p ps=1.21u w=0.77u l=0.13u
X3525 a_33850_65283# a_33965_65284# VSS VSS sg13_lv_nmos ad=0.1428p pd=1.52u as=0.1426p ps=1.16u w=0.42u l=0.5u
X3526 a_44896_10685# X_uq137 Y_uq28 VDD sg13_lv_pmos ad=0.1176p pd=1.33u as=0.3808p ps=2.92u w=1.12u l=0.13u
X3527 a_5051_33721# a_5087_34043# VSS VSS sg13_lv_nmos ad=0.1428p pd=1.52u as=0.1426p ps=1.16u w=0.42u l=0.5u
X3528 VDD a_8075_33721# C_uq31 VDD sg13_lv_pmos ad=0.2254p pd=1.53u as=0.4256p ps=3u w=1.12u l=0.13u
X3529 VDD X_uq436 a_28079_68416# VDD sg13_lv_pmos ad=0.3808p pd=2.92u as=0.2464p ps=1.56u w=1.12u l=0.13u
X3530 a_77251_20693# a_77029_20749# VDD VDD sg13_lv_pmos ad=0.1176p pd=1.33u as=0.2618p ps=1.63u w=1.12u l=0.13u
X3531 a_5558_24581# L_HI_uq6 VSS VSS sg13_lv_nmos ad=37.8f pd=0.6u as=79.8f ps=0.8u w=0.42u l=0.13u
X3532 X_uq268 a_77215_28253# VSS VSS sg13_lv_nmos ad=0.2886p pd=2.26u as=0.14875p ps=1.16u w=0.74u l=0.13u
X3533 a_8071_42811# a_8086_41514# a_8071_42477# VDD sg13_lv_pmos ad=0.2048p pd=1.63u as=0.34p ps=2.68u w=1u l=0.13u
X3534 D_uq63 X_uq435 VSS VSS sg13_lv_nmos ad=0.1694p pd=1.21u as=0.2618p ps=2.22u w=0.77u l=0.13u
X3535 a_9583_31905# a_9598_32468# a_9583_31324# VDD sg13_lv_pmos ad=0.34p pd=2.68u as=0.2048p ps=1.63u w=1u l=0.13u
X3536 X_uq185 a_9617_19387# VDD VDD sg13_lv_pmos ad=0.42p pd=2.99u as=0.2114p ps=1.54u w=1.12u l=0.13u
X3537 VSS A_uq88 Y_uq3 VSS sg13_lv_nmos ad=0.2516p pd=2.16u as=0.1406p ps=1.12u w=0.74u l=0.13u
X3538 a_9619_31631# a_9583_31324# a_9583_31769# VSS sg13_lv_nmos ad=37.8f pd=0.6u as=0.1428p ps=1.52u w=0.42u l=0.13u
X3539 a_45250_6863# Y_uq0 VSS VSS sg13_lv_nmos ad=0.187p pd=1.78u as=0.14875p ps=1.16u w=0.55u l=0.13u
X3540 VSS VDD VSS VSS sg13_lv_nmos ad=79.8f pd=0.8u as=0 ps=-0 w=0.42u l=1u
X3541 a_46421_63528# a_46545_63625# VDD VDD sg13_lv_pmos ad=0.2442p pd=2.06u as=1.4745p ps=9.07u w=0.66u l=0.13u
X3542 a_29904_69305# a_30135_68891# a_29590_68848# VSS sg13_lv_nmos ad=0.2373p pd=1.97u as=79.8f ps=0.8u w=0.42u l=0.13u
X3543 B_uq84 Y_uq206 a_6237_37924# VSS sg13_lv_nmos ad=0.2664p pd=1.46u as=0.13875p ps=1.115u w=0.74u l=0.13u
X3544 a_41866_10649# X_uq143 VSS VSS sg13_lv_nmos ad=0.187p pd=1.78u as=0.17255p ps=1.25u w=0.55u l=0.13u
X3545 VSS C_uq23 a_78946_19529# VSS sg13_lv_nmos ad=0.1331p pd=1.12u as=0.1216p ps=1.02u w=0.64u l=0.13u
X3546 VDD Y_uq129 a_9617_25435# VDD sg13_lv_pmos ad=0.2114p pd=1.54u as=0.2856p ps=2.36u w=0.84u l=0.13u
X3547 VDD Y_uq95 a_9713_23135# VDD sg13_lv_pmos ad=0.2114p pd=1.54u as=0.2856p ps=2.36u w=0.84u l=0.13u
X3548 a_36166_65062# Q_uq46 VDD VDD sg13_lv_pmos ad=0.1428p pd=1.52u as=0.1523p ps=1.38u w=0.42u l=0.13u
X3549 VDD C_uq15 a_12533_18135# VDD sg13_lv_pmos ad=0.4032p pd=2.96u as=0.1176p ps=1.33u w=1.12u l=0.13u
X3550 a_36202_8379# X_uq67 VDD VDD sg13_lv_pmos ad=0.2856p pd=2.36u as=0.2618p ps=1.63u w=0.84u l=0.13u
X3551 C_uq43 X_uq373 a_45590_63880# VDD sg13_lv_pmos ad=0.3808p pd=2.92u as=0.1176p ps=1.33u w=1.12u l=0.13u
X3552 VSS Q_uq25 a_7727_40852# VSS sg13_lv_nmos ad=0.14505p pd=1.15u as=0.1406p ps=1.12u w=0.74u l=0.13u
X3553 VSS din[12] a_75295_26017# VSS sg13_lv_nmos ad=0.14875p pd=1.16u as=0.187p ps=1.78u w=0.55u l=0.13u
X3554 a_31544_66570# Y_uq363 VDD VDD sg13_lv_pmos ad=0.2856p pd=2.36u as=0.2114p ps=1.54u w=0.84u l=0.13u
X3555 a_27926_66904# X_uq420 VDD VDD sg13_lv_pmos ad=0.1176p pd=1.33u as=0.4032p ps=2.96u w=1.12u l=0.13u
X3556 VSS VDD VSS VSS sg13_lv_nmos ad=79.8f pd=0.8u as=0 ps=-0 w=0.42u l=1u
X3557 a_43138_7625# A VSS VSS sg13_lv_nmos ad=0.187p pd=1.78u as=0.14875p ps=1.16u w=0.55u l=0.13u
X3558 VSS X_uq260 C_uq25 VSS sg13_lv_nmos ad=0.2516p pd=2.16u as=0.1406p ps=1.12u w=0.74u l=0.13u
X3559 a_80178_28300# a_79286_28224# a_80076_28300# VDD sg13_lv_pmos ad=63f pd=0.72u as=79.8f ps=0.8u w=0.42u l=0.13u
X3560 a_47589_65979# a_46647_65867# a_47387_66217# VDD sg13_lv_pmos ad=93.45f pd=0.865u as=0.2048p ps=1.63u w=0.42u l=0.13u
X3561 VSS X_uq372 C_uq47 VSS sg13_lv_nmos ad=0.2516p pd=2.16u as=0.1406p ps=1.12u w=0.74u l=0.13u
X3562 VDD D_uq36 a_51971_65485# VDD sg13_lv_pmos ad=0.1428p pd=1.52u as=79.8f ps=0.8u w=0.42u l=0.13u
X3563 VSS X_uq112 a_37572_9965# VSS sg13_lv_nmos ad=0.17255p pd=1.25u as=0.187p ps=1.78u w=0.55u l=0.13u
X3564 VDD a_5809_40625# B_uq96 VDD sg13_lv_pmos ad=0.2114p pd=1.54u as=0.42p ps=2.99u w=1.12u l=0.13u
X3565 a_41328_69630# D_uq61 a_41234_69630# VSS sg13_lv_nmos ad=60.89999f pd=0.71u as=0.1428p ps=1.52u w=0.42u l=0.13u
X3566 a_47760_69948# a_47734_69853# VSS VSS sg13_lv_nmos ad=0.2516p pd=2.16u as=0.1626p ps=1.415u w=0.74u l=0.13u
X3567 a_49238_68416# X_uq450 VDD VDD sg13_lv_pmos ad=0.1176p pd=1.33u as=0.4032p ps=2.96u w=1.12u l=0.13u
X3568 B_uq63 a_8561_24647# VSS VSS sg13_lv_nmos ad=0.2886p pd=2.26u as=0.14875p ps=1.16u w=0.74u l=0.13u
X3569 VDD X_uq429 a_37498_68936# VDD sg13_lv_pmos ad=0.2618p pd=1.63u as=0.2856p ps=2.36u w=0.84u l=0.13u
X3570 VSS Y_uq41 a_9617_19387# VSS sg13_lv_nmos ad=0.14875p pd=1.16u as=0.187p ps=1.78u w=0.55u l=0.13u
X3571 a_8075_39007# Q_uq19 VDD VDD sg13_lv_pmos ad=0.1428p pd=1.52u as=0.1523p ps=1.38u w=0.42u l=0.13u
X3572 VDD a_78077_22959# a_78189_23023# VDD sg13_lv_pmos ad=0.2254p pd=1.53u as=0.34p ps=2.68u w=1u l=0.5u
X3573 a_40342_65824# a_40785_65867# a_40725_65903# VDD sg13_lv_pmos ad=79.8f pd=0.8u as=63f ps=0.72u w=0.42u l=0.13u
X3574 Y_uq37 X_uq251 VSS VSS sg13_lv_nmos ad=0.1694p pd=1.21u as=0.2618p ps=2.22u w=0.77u l=0.13u
X3575 VSS C_uq21 Y_uq55 VSS sg13_lv_nmos ad=0.2516p pd=2.16u as=0.1406p ps=1.12u w=0.74u l=0.13u
X3576 a_43672_66904# a_43450_66648# VDD VDD sg13_lv_pmos ad=0.1176p pd=1.33u as=0.2618p ps=1.63u w=1.12u l=0.13u
X3577 VDD a_37787_67729# a_38044_67610# VDD sg13_lv_pmos ad=1.19383p pd=7.16u as=79.8f ps=0.8u w=0.42u l=0.13u
X3578 VSS a_48250_67635# X_uq407 VSS sg13_lv_nmos ad=0.1426p pd=1.16u as=0.2516p ps=2.16u w=0.74u l=0.13u
X3579 Q_uq19 a_8833_38394# VSS VSS sg13_lv_nmos ad=0.2516p pd=2.16u as=0.1406p ps=1.12u w=0.74u l=0.13u
X3580 a_49750_68341# a_50193_68097# a_49490_68118# VSS sg13_lv_nmos ad=79.8f pd=0.8u as=0.1296p ps=1.52u w=0.42u l=0.13u
X3581 VSS Y_uq33 a_8945_17875# VSS sg13_lv_nmos ad=0.14875p pd=1.16u as=0.187p ps=1.78u w=0.55u l=0.13u
X3582 VDD a_51707_64705# a_52374_64344# VDD sg13_lv_pmos ad=0.2128p pd=1.5u as=0.3864p ps=2.93u w=1.12u l=0.13u
X3583 a_4420_33911# Y_uq174 VDD VDD sg13_lv_pmos ad=79.8f pd=0.8u as=1.31615p ps=8.395u w=0.42u l=0.13u
X3584 VSS B_N a_43428_8453# VSS sg13_lv_nmos ad=0.17255p pd=1.25u as=0.187p ps=1.78u w=0.55u l=0.13u
X3585 a_7478_24893# L_HI_uq5 VSS VSS sg13_lv_nmos ad=37.8f pd=0.6u as=79.8f ps=0.8u w=0.42u l=0.13u
X3586 a_12533_25695# C_uq21 Y_uq130 VDD sg13_lv_pmos ad=0.1176p pd=1.33u as=0.3808p ps=2.92u w=1.12u l=0.13u
X3587 a_8498_31662# a_8071_32685# VDD VDD sg13_lv_pmos ad=63f pd=0.72u as=0.1563p ps=1.22u w=0.42u l=0.13u
X3588 a_46070_67806# a_45763_67332# a_45976_67806# VSS sg13_lv_nmos ad=37.8f pd=0.6u as=0.1428p ps=1.52u w=0.42u l=0.13u
X3589 a_50865_64355# clk VSS VSS sg13_lv_nmos ad=0.2516p pd=2.16u as=4.19255p ps=26u w=0.74u l=0.13u
X3590 Y_uq30 X_uq168 a_34338_10685# VDD sg13_lv_pmos ad=0.3808p pd=2.92u as=0.1176p ps=1.33u w=1.12u l=0.13u
X3591 VSS Y_uq97 a_11537_23135# VSS sg13_lv_nmos ad=0.14875p pd=1.16u as=0.187p ps=1.78u w=0.55u l=0.13u
X3592 X_uq184 a_10001_19387# VDD VDD sg13_lv_pmos ad=0.42p pd=2.99u as=0.2114p ps=1.54u w=1.12u l=0.13u
X3593 VSS a_39226_63771# X_uq376 VSS sg13_lv_nmos ad=0.1426p pd=1.16u as=0.2516p ps=2.16u w=0.74u l=0.13u
X3594 VSS Q_uq4 a_7340_25655# VSS sg13_lv_nmos ad=0.14875p pd=1.16u as=0.187p ps=1.78u w=0.55u l=0.13u
X3595 VSS Q_uq48 a_27604_63620# VSS sg13_lv_nmos ad=0.14875p pd=1.16u as=0.187p ps=1.78u w=0.55u l=0.13u
X3596 a_28457_63880# C_uq57 Y_uq240 VDD sg13_lv_pmos ad=0.2128p pd=1.5u as=0.3808p ps=2.92u w=1.12u l=0.13u
X3597 a_5809_43188# a_5811_42044# a_5849_41193# VDD sg13_lv_pmos ad=0.2048p pd=1.63u as=0.34p ps=2.68u w=1u l=0.13u
X3598 VSS X_uq83 a_38238_6937# VSS sg13_lv_nmos ad=0.14875p pd=1.16u as=0.187p ps=1.78u w=0.55u l=0.13u
X3599 a_4333_31825# S_uq0 D_uq15 VDD sg13_lv_pmos ad=0.1176p pd=1.33u as=0.3808p ps=2.92u w=1.12u l=0.13u
X3600 VSS a_39418_68307# D_uq54 VSS sg13_lv_nmos ad=0.1426p pd=1.16u as=0.2516p ps=2.16u w=0.74u l=0.13u
X3601 VSS X_uq454 C_uq71 VSS sg13_lv_nmos ad=0.2516p pd=2.16u as=0.1406p ps=1.12u w=0.74u l=0.13u
X3602 VSS a_37379_66687# a_37379_66687# VSS sg13_lv_nmos ad=1.8643p pd=11.96u as=0.111p ps=1.34u w=0.3u l=0.13u
X3603 VDD Y_uq90 a_10097_23135# VDD sg13_lv_pmos ad=0.2114p pd=1.54u as=0.2856p ps=2.36u w=0.84u l=0.13u
X3604 VSS a_28754_65098# a_28866_65162# VSS sg13_lv_nmos ad=0.1426p pd=1.16u as=0.1428p ps=1.52u w=0.42u l=0.5u
X3605 a_29904_69305# a_29616_68884# a_29842_69305# VSS sg13_lv_nmos ad=0.1428p pd=1.52u as=37.8f ps=0.6u w=0.42u l=0.13u
X3606 VSS din[24] a_75679_19969# VSS sg13_lv_nmos ad=0.14875p pd=1.16u as=0.187p ps=1.78u w=0.55u l=0.13u
X3607 a_28848_69948# a_28822_69853# VDD VDD sg13_lv_pmos ad=0.34p pd=2.68u as=0.36237p ps=2.605u w=1u l=0.13u
X3608 VSS a_43906_7625# X_uq43 VSS sg13_lv_nmos ad=0.14875p pd=1.16u as=0.2886p ps=2.26u w=0.74u l=0.13u
X3609 a_4411_25191# B_uq60 a_4297_25191# VDD sg13_lv_pmos ad=0.2128p pd=1.5u as=0.2464p ps=1.56u w=1.12u l=0.13u
X3610 a_4297_30929# Q_uq11 VDD VDD sg13_lv_pmos ad=0.2856p pd=2.36u as=0.2114p ps=1.54u w=0.84u l=0.13u
X3611 VSS a_46306_9887# B_uq8 VSS sg13_lv_nmos ad=0.14875p pd=1.16u as=0.2886p ps=2.26u w=0.74u l=0.13u
X3612 X_uq22 a_37854_6937# VSS VSS sg13_lv_nmos ad=0.2886p pd=2.26u as=0.14875p ps=1.16u w=0.74u l=0.13u
X3613 a_9632_40617# a_9583_41709# a_9632_40555# VSS sg13_lv_nmos ad=0.1428p pd=1.52u as=37.8f ps=0.6u w=0.42u l=0.13u
X3614 VDD VSS VDD VDD sg13_lv_pmos ad=0.34p pd=2.68u as=0 ps=0 w=1u l=1u
X3615 a_5083_31019# D_uq16 VDD VDD sg13_lv_pmos ad=79.8f pd=0.8u as=0.1428p ps=1.52u w=0.42u l=0.13u
X3616 a_4758_41419# Y_uq238 VSS VSS sg13_lv_nmos ad=37.8f pd=0.6u as=0.1701p ps=1.65u w=0.42u l=0.13u
X3617 VSS X_uq373 C_uq43 VSS sg13_lv_nmos ad=0.2516p pd=2.16u as=0.1406p ps=1.12u w=0.74u l=0.13u
X3618 a_6992_22631# B_uq49 Y_uq92 VDD sg13_lv_pmos ad=0.1176p pd=1.33u as=0.3808p ps=2.92u w=1.12u l=0.13u
X3619 a_40785_65867# clk VSS VSS sg13_lv_nmos ad=0.2516p pd=2.16u as=1.7977p ps=11.53u w=0.74u l=0.13u
X3620 a_38628_10301# B_uq26 a_38534_10301# VDD sg13_lv_pmos ad=0.1596p pd=1.22u as=0.2856p ps=2.36u w=0.84u l=0.13u
X3621 VSS Q_uq29 Y_uq268 VSS sg13_lv_nmos ad=0.2516p pd=2.16u as=0.2516p ps=2.16u w=0.74u l=0.13u
X3622 VSS Y_uq40 a_10001_19387# VSS sg13_lv_nmos ad=0.14875p pd=1.16u as=0.187p ps=1.78u w=0.55u l=0.13u
X3623 a_76939_27789# Y_uq144 a_76837_27789# VDD sg13_lv_pmos ad=0.2128p pd=1.5u as=0.2128p ps=1.5u w=1.12u l=0.13u
X3624 A1_uq9 a_78208_25253# VDD VDD sg13_lv_pmos ad=0.3808p pd=2.92u as=0.3822p ps=1.84u w=1.12u l=0.13u
X3625 VDD VSS VDD VDD sg13_lv_pmos ad=0.19p pd=1.38u as=0 ps=0 w=1u l=1u
X3626 a_44496_68884# a_44470_68848# VDD VDD sg13_lv_pmos ad=0.34p pd=2.68u as=0.36237p ps=2.605u w=1u l=0.13u
X3627 a_6595_33175# Y_uq169 VSS VSS sg13_lv_nmos ad=37.8f pd=0.6u as=79.8f ps=0.8u w=0.42u l=0.13u
X3628 a_9619_37451# D_uq24 VDD VDD sg13_lv_pmos ad=79.8f pd=0.8u as=0.1428p ps=1.52u w=0.42u l=0.13u
X3629 a_47171_67415# L_HI_uq26 VDD VDD sg13_lv_pmos ad=79.8f pd=0.8u as=0.36237p ps=2.605u w=0.42u l=0.13u
X3630 a_48177_69609# clk VDD VDD sg13_lv_pmos ad=0.4088p pd=2.97u as=1.621p ps=10.08u w=1.12u l=0.13u
X3631 a_6893_37596# S a_6893_37482# VDD sg13_lv_pmos ad=0.2128p pd=1.5u as=0.2464p ps=1.56u w=1.12u l=0.13u
X3632 a_29427_64431# a_29579_64315# VDD VDD sg13_lv_pmos ad=0.3864p pd=2.93u as=1.4745p ps=9.07u w=1.12u l=0.13u
X3633 a_75962_24765# C_uq23 a_75860_24765# VDD sg13_lv_pmos ad=0.2464p pd=1.56u as=0.2128p ps=1.5u w=1.12u l=0.13u
X3634 X_uq198 a_12593_20899# VSS VSS sg13_lv_nmos ad=0.2886p pd=2.26u as=0.14875p ps=1.16u w=0.74u l=0.13u
X3635 VDD a_43930_69819# X_uq451 VDD sg13_lv_pmos ad=0.2254p pd=1.53u as=0.4256p ps=3u w=1.12u l=0.13u
X3636 a_79068_26752# clk VDD VDD sg13_lv_pmos ad=0.4088p pd=2.97u as=2.04445p ps=13.405u w=1.12u l=0.13u
X3637 VSS X_uq345 Y_uq246 VSS sg13_lv_nmos ad=0.2516p pd=2.16u as=0.1406p ps=1.12u w=0.74u l=0.13u
X3638 a_9665_34953# D_uq23 VSS VSS sg13_lv_nmos ad=0.1216p pd=1.02u as=0.1371p ps=1.12u w=0.64u l=0.13u
X3639 a_4299_42044# clk VDD VDD sg13_lv_pmos ad=0.4088p pd=2.97u as=1.25632p ps=8.01u w=1.12u l=0.13u
X3640 D_uq47 a_49890_65880# VDD VDD sg13_lv_pmos ad=0.4256p pd=3u as=0.2254p ps=1.53u w=1.12u l=0.13u
X3641 a_30480_65412# a_30454_65317# VSS VSS sg13_lv_nmos ad=0.2516p pd=2.16u as=0.1626p ps=1.415u w=0.74u l=0.13u
X3642 a_4297_39674# X_uq315 VDD VDD sg13_lv_pmos ad=0.2856p pd=2.36u as=0.2198p ps=1.53u w=0.84u l=0.13u
X3643 Y_uq314 Q_uq57 a_28600_67368# VDD sg13_lv_pmos ad=0.3808p pd=2.92u as=0.1176p ps=1.33u w=1.12u l=0.13u
X3644 VDD Q_uq1 a_7724_20395# VDD sg13_lv_pmos ad=0.2114p pd=1.54u as=0.2856p ps=2.36u w=0.84u l=0.13u
X3645 VDD a_7059_23458# a_7316_23601# VDD sg13_lv_pmos ad=1.02937p pd=6.325u as=79.8f ps=0.8u w=0.42u l=0.13u
X3646 dout a_80575_25229# VDD VDD sg13_lv_pmos ad=0.42p pd=2.99u as=0.2114p ps=1.54u w=1.12u l=0.13u
X3647 a_48048_69643# a_48279_69752# a_47734_69853# VSS sg13_lv_nmos ad=0.2373p pd=1.97u as=79.8f ps=0.8u w=0.42u l=0.13u
X3648 a_43750_65062# Y_uq261 VDD VDD sg13_lv_pmos ad=0.1428p pd=1.52u as=0.1523p ps=1.38u w=0.42u l=0.13u
X3649 a_40408_65392# a_40186_65136# VDD VDD sg13_lv_pmos ad=0.1176p pd=1.33u as=0.2618p ps=1.63u w=1.12u l=0.13u
X3650 B_uq68 a_78852_19529# VDD VDD sg13_lv_pmos ad=0.3808p pd=2.92u as=0.1918p ps=1.5u w=1.12u l=0.13u
X3651 X_uq173 a_8561_17875# VSS VSS sg13_lv_nmos ad=0.2886p pd=2.26u as=0.14875p ps=1.16u w=0.74u l=0.13u
X3652 a_36736_10221# X_uq162 Y_uq25 VDD sg13_lv_pmos ad=0.1176p pd=1.33u as=0.3808p ps=2.92u w=1.12u l=0.13u
X3653 a_76357_21741# B1_uq7 a_76459_21741# VDD sg13_lv_pmos ad=0.3808p pd=2.92u as=0.2128p ps=1.5u w=1.12u l=0.13u
X3654 a_8107_31019# a_8082_32645# a_8116_31287# VDD sg13_lv_pmos ad=0.1428p pd=1.52u as=79.8f ps=0.8u w=0.42u l=0.13u
X3655 a_49664_64308# X_uq446 VDD VDD sg13_lv_pmos ad=0.2856p pd=2.36u as=0.2618p ps=1.63u w=0.84u l=0.13u
X3656 VSS X_uq206 Y_uq71 VSS sg13_lv_nmos ad=0.2516p pd=2.16u as=0.2516p ps=2.16u w=0.74u l=0.13u
X3657 q[7] a_32980_63620# VDD VDD sg13_lv_pmos ad=0.42p pd=2.99u as=0.2114p ps=1.54u w=1.12u l=0.13u
X3658 A2 B1_uq7 a_76459_21469# VSS sg13_lv_nmos ad=0.2516p pd=2.16u as=0.1406p ps=1.12u w=0.74u l=0.13u
X3659 VDD X_uq144 a_41508_9149# VDD sg13_lv_pmos ad=0.2226p pd=1.535u as=0.1596p ps=1.22u w=0.84u l=0.13u
X3660 a_32306_69630# a_33111_69752# a_32566_69853# VDD sg13_lv_pmos ad=0.1428p pd=1.52u as=79.8f ps=0.8u w=0.42u l=0.13u
X3661 a_80076_20740# L_HI_uq0 VDD VDD sg13_lv_pmos ad=0.147p pd=1.54u as=0.1563p ps=1.22u w=0.42u l=0.13u
X3662 a_38338_7625# q[12] VDD VDD sg13_lv_pmos ad=0.2856p pd=2.36u as=0.2114p ps=1.54u w=0.84u l=0.13u
X3663 a_6559_33211# a_6574_31914# a_6559_32877# VDD sg13_lv_pmos ad=0.2048p pd=1.63u as=0.34p ps=2.68u w=1u l=0.13u
X3664 a_47806_66294# L_HI_uq13 VSS VSS sg13_lv_nmos ad=37.8f pd=0.6u as=79.8f ps=0.8u w=0.42u l=0.13u
X3665 a_5208_21083# B_uq66 VDD VDD sg13_lv_pmos ad=0.2856p pd=2.36u as=0.2618p ps=1.63u w=0.84u l=0.13u
X3666 VSS C_uq23 B1_uq6 VSS sg13_lv_nmos ad=0.2516p pd=2.16u as=0.1406p ps=1.12u w=0.74u l=0.13u
X3667 VSS Y_uq95 a_9713_23135# VSS sg13_lv_nmos ad=0.14875p pd=1.16u as=0.187p ps=1.78u w=0.55u l=0.13u
X3668 a_37443_64344# Y_uq252 a_37329_64344# VDD sg13_lv_pmos ad=0.2128p pd=1.5u as=0.2464p ps=1.56u w=1.12u l=0.13u
X3669 VSS X_uq424 Y_uq303 VSS sg13_lv_nmos ad=0.2516p pd=2.16u as=0.1406p ps=1.12u w=0.74u l=0.13u
X3670 a_8799_33220# Q_uq14 VSS VSS sg13_lv_nmos ad=0.1045p pd=0.93u as=0.1469p ps=1.155u w=0.55u l=0.13u
X3671 A2_uq2 B1_uq6 a_76651_26005# VSS sg13_lv_nmos ad=0.2516p pd=2.16u as=0.1406p ps=1.12u w=0.74u l=0.13u
X3672 a_50552_63546# Q_uq51 VSS VSS sg13_lv_nmos ad=0.187p pd=1.78u as=0.14875p ps=1.16u w=0.55u l=0.13u
X3673 VSS a_44194_10649# X_uq138 VSS sg13_lv_nmos ad=0.14875p pd=1.16u as=0.2886p ps=2.26u w=0.74u l=0.13u
X3674 VDD a_30460_66098# a_30405_65979# VDD sg13_lv_pmos ad=1.41367p pd=8.85u as=93.45f ps=0.865u w=0.42u l=0.13u
X3675 VDD B_uq65 a_5618_25711# VDD sg13_lv_pmos ad=0.2618p pd=1.63u as=0.2856p ps=2.36u w=0.84u l=0.13u
X3676 VSS X_uq405 C_uq56 VSS sg13_lv_nmos ad=0.2516p pd=2.16u as=0.1406p ps=1.12u w=0.74u l=0.13u
X3677 a_4613_32906# a_4337_32361# a_4758_32587# VSS sg13_lv_nmos ad=0.1428p pd=1.52u as=37.8f ps=0.6u w=0.42u l=0.13u
X3678 a_9583_39451# a_9598_38154# a_9583_39117# VDD sg13_lv_pmos ad=0.2048p pd=1.63u as=0.34p ps=2.68u w=1u l=0.13u
X3679 VDD Y_uq141 a_77618_27789# VDD sg13_lv_pmos ad=0.2128p pd=1.5u as=0.2128p ps=1.5u w=1.12u l=0.13u
X3680 a_6125_41738# a_5847_41975# a_5813_41167# VSS sg13_lv_nmos ad=0.2373p pd=1.97u as=79.8f ps=0.8u w=0.42u l=0.13u
X3681 Y_uq73 X_uq210 VSS VSS sg13_lv_nmos ad=0.2516p pd=2.16u as=0.2516p ps=2.16u w=0.74u l=0.13u
X3682 VSS a_4297_40543# a_4321_40263# VSS sg13_lv_nmos ad=79.8f pd=0.8u as=0.1428p ps=1.52u w=0.42u l=0.5u
X3683 VDD a_10345_30929# X_uq280 VDD sg13_lv_pmos ad=0.2114p pd=1.54u as=0.42p ps=2.99u w=1.12u l=0.13u
X3684 X_uq27 a_35934_6937# VDD VDD sg13_lv_pmos ad=0.42p pd=2.99u as=0.2114p ps=1.54u w=1.12u l=0.13u
X3685 a_39603_68967# a_39755_68851# VSS VSS sg13_lv_nmos ad=0.2516p pd=2.16u as=2.01085p ps=12.81u w=0.74u l=0.13u
X3686 VSS Y_uq189 a_5083_34665# VSS sg13_lv_nmos ad=0.1626p pd=1.415u as=60.89999f ps=0.71u w=0.42u l=0.13u
X3687 a_5398_36318# a_5058_36197# a_5047_36571# VDD sg13_lv_pmos ad=93.45f pd=0.865u as=0.2048p ps=1.63u w=0.42u l=0.13u
X3688 Y_uq23 a_37572_9965# VSS VSS sg13_lv_nmos ad=0.1406p pd=1.12u as=0.17255p ps=1.25u w=0.74u l=0.13u
X3689 VSS a_44098_6863# X_uq6 VSS sg13_lv_nmos ad=0.14875p pd=1.16u as=0.2886p ps=2.26u w=0.74u l=0.13u
X3690 VSS a_51707_64705# a_52374_64344# VSS sg13_lv_nmos ad=0.1406p pd=1.12u as=0.2516p ps=2.16u w=0.74u l=0.13u
X3691 VDD a_31739_65171# a_32406_65392# VDD sg13_lv_pmos ad=0.2128p pd=1.5u as=0.3864p ps=2.93u w=1.12u l=0.13u
X3692 a_43738_68307# a_43853_68308# VDD VDD sg13_lv_pmos ad=0.34p pd=2.68u as=0.2254p ps=1.53u w=1u l=0.5u
X3693 a_80167_24687# a_79910_24544# a_80329_24467# VSS sg13_lv_nmos ad=0.1428p pd=1.52u as=37.8f ps=0.6u w=0.42u l=0.13u
X3694 VDD a_32312_66570# SLN[1] VDD sg13_lv_pmos ad=0.2114p pd=1.54u as=0.42p ps=2.99u w=1.12u l=0.13u
X3695 VDD Y_uq176 a_9937_34145# VDD sg13_lv_pmos ad=0.3808p pd=2.92u as=0.2128p ps=1.5u w=1.12u l=0.15u
X3696 Y_uq98 D_uq5 VSS VSS sg13_lv_nmos ad=0.2618p pd=2.22u as=0.1463p ps=1.15u w=0.77u l=0.13u
X3697 a_5139_24504# a_4297_24154# a_5045_24504# VSS sg13_lv_nmos ad=0.12665p pd=1.145u as=0.1428p ps=1.52u w=0.42u l=0.13u
X3698 VDD X_uq168 a_33636_10661# VDD sg13_lv_pmos ad=0.2226p pd=1.535u as=0.1596p ps=1.22u w=0.84u l=0.13u
X3699 a_10345_43188# a_10347_42044# a_10385_41193# VDD sg13_lv_pmos ad=0.2048p pd=1.63u as=0.34p ps=2.68u w=1u l=0.13u
X3700 a_46102_65824# a_46545_65867# a_46485_65903# VDD sg13_lv_pmos ad=79.8f pd=0.8u as=63f ps=0.72u w=0.42u l=0.13u
X3701 a_33254_10301# B_uq14 VSS VSS sg13_lv_nmos ad=0.1045p pd=0.93u as=0.187p ps=1.78u w=0.55u l=0.13u
X3702 a_37918_69630# L_HI_uq38 VSS VSS sg13_lv_nmos ad=37.8f pd=0.6u as=79.8f ps=0.8u w=0.42u l=0.13u
X3703 VSS a_49580_66781# Q_uq52 VSS sg13_lv_nmos ad=0.1406p pd=1.12u as=0.2516p ps=2.16u w=0.74u l=0.13u
X3704 a_44194_10649# X_uq333 VSS VSS sg13_lv_nmos ad=0.187p pd=1.78u as=0.14875p ps=1.16u w=0.55u l=0.13u
X3705 VSS a_46210_10649# B_uq16 VSS sg13_lv_nmos ad=0.14875p pd=1.16u as=0.2886p ps=2.26u w=0.74u l=0.13u
X3706 a_28944_65860# a_28918_65824# VSS VSS sg13_lv_nmos ad=0.2516p pd=2.16u as=0.1626p ps=1.415u w=0.74u l=0.13u
X3707 VSS a_42946_6863# X_uq9 VSS sg13_lv_nmos ad=0.14875p pd=1.16u as=0.2886p ps=2.26u w=0.74u l=0.13u
X3708 Y_uq257 C_uq42 a_49251_64344# VDD sg13_lv_pmos ad=0.3808p pd=2.92u as=0.2128p ps=1.5u w=1.12u l=0.13u
X3709 a_34246_65062# Q_uq47 VSS VSS sg13_lv_nmos ad=0.1428p pd=1.52u as=79.8f ps=0.8u w=0.42u l=0.13u
X3710 VDD a_5139_24504# a_5806_24143# VDD sg13_lv_pmos ad=0.2128p pd=1.5u as=0.3864p ps=2.93u w=1.12u l=0.13u
X3711 VDD a_31846_66827# L_HI_uq21 VDD sg13_lv_pmos ad=1.19383p pd=7.16u as=0.3927p ps=2.99u w=1.155u l=0.13u
X3712 VDD a_41937_69609# a_42039_69752# VDD sg13_lv_pmos ad=1.6733p pd=10.405u as=0.3864p ps=2.93u w=1.12u l=0.13u
X3713 Y_uq242 Q_uq52 VSS VSS sg13_lv_nmos ad=0.1406p pd=1.12u as=0.2516p ps=2.16u w=0.74u l=0.13u
X3714 VDD a_51057_67379# a_51159_67379# VDD sg13_lv_pmos ad=1.19383p pd=7.16u as=0.3864p ps=2.93u w=1.12u l=0.13u
X3715 B_uq58 C_uq19 VDD VDD sg13_lv_pmos ad=0.3808p pd=2.92u as=0.3808p ps=2.92u w=1.12u l=0.13u
X3716 VSS X_uq399 a_40186_65136# VSS sg13_lv_nmos ad=0.17255p pd=1.25u as=0.187p ps=1.78u w=0.55u l=0.13u
X3717 a_28822_69853# a_29265_69609# a_28562_69630# VSS sg13_lv_nmos ad=79.8f pd=0.8u as=0.1296p ps=1.52u w=0.42u l=0.13u
X3718 VSS C_uq33 Y_uq180 VSS sg13_lv_nmos ad=0.1463p pd=1.15u as=0.2618p ps=2.22u w=0.77u l=0.13u
X3719 a_45250_7625# X_uq97 VSS VSS sg13_lv_nmos ad=0.187p pd=1.78u as=0.14875p ps=1.16u w=0.55u l=0.13u
X3720 a_51201_66764# a_50259_66824# a_51062_66764# VSS sg13_lv_nmos ad=79.8f pd=0.8u as=0.2373p ps=1.97u w=0.42u l=0.13u
X3721 Y_uq66 B_uq50 VSS VSS sg13_lv_nmos ad=0.1406p pd=1.12u as=0.2516p ps=2.16u w=0.74u l=0.13u
X3722 VSS Y_uq90 a_10097_23135# VSS sg13_lv_nmos ad=0.14875p pd=1.16u as=0.187p ps=1.78u w=0.55u l=0.13u
X3723 a_36778_9891# X_uq113 VSS VSS sg13_lv_nmos ad=0.187p pd=1.78u as=0.17255p ps=1.25u w=0.55u l=0.13u
X3724 Y_uq37 C_uq0 a_76110_19181# VDD sg13_lv_pmos ad=0.3808p pd=2.92u as=0.2128p ps=1.5u w=1.12u l=0.13u
X3725 VDD Q_uq44 Y_uq239 VDD sg13_lv_pmos ad=0.3808p pd=2.92u as=0.3808p ps=2.92u w=1.12u l=0.13u
X3726 VDD Y_uq23 a_37854_7661# VDD sg13_lv_pmos ad=0.2114p pd=1.54u as=0.2856p ps=2.36u w=0.84u l=0.13u
X3727 a_40401_68161# a_40401_68161# VSS VSS sg13_lv_nmos ad=0.111p pd=1.34u as=2.08687p ps=13.23u w=0.3u l=0.13u
X3728 a_40546_10649# X_uq339 VSS VSS sg13_lv_nmos ad=0.187p pd=1.78u as=0.14875p ps=1.16u w=0.55u l=0.13u
X3729 a_10587_17845# C VSS VSS sg13_lv_nmos ad=0.1406p pd=1.12u as=0.2886p ps=2.26u w=0.74u l=0.13u
X3730 VSS D_uq7 Y_uq76 VSS sg13_lv_nmos ad=0.1463p pd=1.15u as=0.1694p ps=1.21u w=0.77u l=0.13u
X3731 a_35726_10067# A_uq98 VSS VSS sg13_lv_nmos ad=0.1045p pd=0.93u as=0.1469p ps=1.155u w=0.55u l=0.13u
X3732 a_41475_64344# Y_uq249 a_41361_64344# VDD sg13_lv_pmos ad=0.2128p pd=1.5u as=0.2464p ps=1.56u w=1.12u l=0.13u
X3733 Q_uq59 a_31542_67368# VSS VSS sg13_lv_nmos ad=0.2516p pd=2.16u as=0.1406p ps=1.12u w=0.74u l=0.13u
X3734 VDD a_34330_67635# X_uq434 VDD sg13_lv_pmos ad=0.2254p pd=1.53u as=0.4256p ps=3u w=1.12u l=0.13u
X3735 VSS a_42680_63546# q[18] VSS sg13_lv_nmos ad=0.14875p pd=1.16u as=0.2886p ps=2.26u w=0.74u l=0.13u
X3736 X_uq233 a_12017_24647# VDD VDD sg13_lv_pmos ad=0.42p pd=2.99u as=0.2114p ps=1.54u w=1.12u l=0.13u
X3737 VDD a_4754_25082# X_uq260 VDD sg13_lv_pmos ad=0.2254p pd=1.53u as=0.4256p ps=3u w=1.12u l=0.13u
X3738 VDD Y_uq257 a_49508_65098# VDD sg13_lv_pmos ad=0.1523p pd=1.38u as=0.1428p ps=1.52u w=0.42u l=0.13u
X3739 a_10345_37044# a_10347_35900# a_10742_36214# VSS sg13_lv_nmos ad=0.12665p pd=1.145u as=0.1428p ps=1.52u w=0.42u l=0.13u
X3740 VSS a_30033_68891# a_30135_68891# VSS sg13_lv_nmos ad=2.01085p pd=12.81u as=0.2516p ps=2.16u w=0.74u l=0.13u
X3741 VSS a_40835_69711# a_40835_69711# VSS sg13_lv_nmos ad=2.01085p pd=12.81u as=0.111p ps=1.34u w=0.3u l=0.13u
X3742 VSS a_39200_66574# Y_uq308 VSS sg13_lv_nmos ad=0.17255p pd=1.25u as=0.1406p ps=1.12u w=0.74u l=0.13u
X3743 VDD a_45922_9137# B_uq7 VDD sg13_lv_pmos ad=0.2114p pd=1.54u as=0.42p ps=2.99u w=1.12u l=0.13u
X3744 a_10428_32924# a_10347_32660# a_10349_33537# VSS sg13_lv_nmos ad=0.1296p pd=1.52u as=79.8f ps=0.8u w=0.42u l=0.13u
X3745 VSS a_5809_40625# B_uq96 VSS sg13_lv_nmos ad=0.14875p pd=1.16u as=0.2886p ps=2.26u w=0.74u l=0.13u
X3746 a_33398_65856# X_uq458 VDD VDD sg13_lv_pmos ad=0.1176p pd=1.33u as=0.4032p ps=2.96u w=1.12u l=0.13u
X3747 VSS X_uq251 C1_uq2 VSS sg13_lv_nmos ad=0.2618p pd=2.22u as=0.1694p ps=1.21u w=0.77u l=0.13u
X3748 a_46545_65867# clk VSS VSS sg13_lv_nmos ad=0.2516p pd=2.16u as=1.7977p ps=11.53u w=0.74u l=0.13u
X3749 X_uq206 a_75679_22205# VSS VSS sg13_lv_nmos ad=0.2886p pd=2.26u as=0.14875p ps=1.16u w=0.74u l=0.13u
X3750 VDD a_46306_9887# B_uq8 VDD sg13_lv_pmos ad=0.2114p pd=1.54u as=0.42p ps=2.99u w=1.12u l=0.13u
X3751 Y_uq110 C_uq15 VSS VSS sg13_lv_nmos ad=0.2618p pd=2.22u as=0.1463p ps=1.15u w=0.77u l=0.13u
X3752 C_uq37 D_uq29 a_10751_40159# VSS sg13_lv_nmos ad=0.2516p pd=2.16u as=0.1406p ps=1.12u w=0.74u l=0.13u
X3753 VSS Y_uq346 a_29716_63620# VSS sg13_lv_nmos ad=0.14875p pd=1.16u as=0.187p ps=1.78u w=0.55u l=0.13u
X3754 a_29818_66795# a_29933_66796# VDD VDD sg13_lv_pmos ad=0.34p pd=2.68u as=0.2254p ps=1.53u w=1u l=0.5u
X3755 X_uq266 a_75295_27529# VDD VDD sg13_lv_pmos ad=0.42p pd=2.99u as=0.2114p ps=1.54u w=1.12u l=0.13u
X3756 a_49778_65856# a_49508_65897# VDD VDD sg13_lv_pmos ad=0.34p pd=2.68u as=0.1523p ps=1.38u w=1u l=0.5u
X3757 VDD a_42178_6863# X_uq11 VDD sg13_lv_pmos ad=0.2114p pd=1.54u as=0.42p ps=2.99u w=1.12u l=0.13u
X3758 a_5150_24861# Q_uq5 VSS VSS sg13_lv_nmos ad=0.1428p pd=1.52u as=79.8f ps=0.8u w=0.42u l=0.13u
X3759 VDD a_30598_68086# a_30317_68308# VDD sg13_lv_pmos ad=0.1523p pd=1.38u as=0.34p ps=2.68u w=1u l=0.5u
X3760 Y a_43428_8453# VSS VSS sg13_lv_nmos ad=0.1406p pd=1.12u as=0.17255p ps=1.25u w=0.74u l=0.13u
X3761 B_uq75 B_uq79 VDD VDD sg13_lv_pmos ad=0.2128p pd=1.5u as=0.3808p ps=2.92u w=1.12u l=0.13u
X3762 VSS a_47553_64391# a_46632_64705# VSS sg13_lv_nmos ad=0.1626p pd=1.415u as=0.2516p ps=2.16u w=0.74u l=0.13u
X3763 D_uq26 C_uq39 a_10381_39578# VDD sg13_lv_pmos ad=0.3808p pd=2.92u as=0.2128p ps=1.5u w=1.12u l=0.13u
X3764 a_3739_22167# Y_uq94 a_3625_22167# VDD sg13_lv_pmos ad=0.2128p pd=1.5u as=0.2464p ps=1.56u w=1.12u l=0.13u
X3765 a_76357_24765# C1_uq2 B2_uq7 VDD sg13_lv_pmos ad=0.2128p pd=1.5u as=0.3808p ps=2.92u w=1.12u l=0.13u
X3766 VDD a_6563_39963# X_uq312 VDD sg13_lv_pmos ad=0.2198p pd=1.52u as=0.6048p ps=3.32u w=1.12u l=0.13u
X3767 VDD a_3535_31126# Q_uq11 VDD sg13_lv_pmos ad=0.2128p pd=1.5u as=0.3808p ps=2.92u w=1.12u l=0.13u
X3768 VDD X_uq452 a_42292_68880# VDD sg13_lv_pmos ad=0.2114p pd=1.54u as=0.2856p ps=2.36u w=0.84u l=0.13u
X3769 Y_uq286 X_uq445 VSS VSS sg13_lv_nmos ad=0.1694p pd=1.21u as=0.2618p ps=2.22u w=0.77u l=0.13u
X3770 a_34725_66921# a_33783_66728# a_34523_66683# VDD sg13_lv_pmos ad=93.45f pd=0.865u as=0.2048p ps=1.63u w=0.42u l=0.13u
X3771 a_35416_68880# a_35194_68936# VDD VDD sg13_lv_pmos ad=0.1176p pd=1.33u as=0.2618p ps=1.63u w=1.12u l=0.13u
X3772 a_5051_42266# X_uq324 VDD VDD sg13_lv_pmos ad=0.2856p pd=2.36u as=0.2198p ps=1.53u w=0.84u l=0.13u
X3773 a_5341_24266# a_4399_24154# a_5139_24504# VDD sg13_lv_pmos ad=93.45f pd=0.865u as=0.2048p ps=1.63u w=0.42u l=0.13u
X3774 a_41410_7625# A_uq95 VDD VDD sg13_lv_pmos ad=0.2856p pd=2.36u as=0.2114p ps=1.54u w=0.84u l=0.13u
X3775 VSS a_43253_68064# a_43174_68339# VSS sg13_lv_nmos ad=2.08687p pd=13.23u as=0.27427p ps=2.28u w=0.795u l=0.13u
X3776 a_44860_66098# a_44603_66217# a_45022_66294# VSS sg13_lv_nmos ad=0.1428p pd=1.52u as=37.8f ps=0.6u w=0.42u l=0.13u
X3777 a_33873_64355# clk VDD VDD sg13_lv_pmos ad=0.4088p pd=2.97u as=1.4357p ps=8.83u w=1.12u l=0.13u
X3778 a_28463_68880# Y_uq349 a_28361_68880# VDD sg13_lv_pmos ad=0.2464p pd=1.56u as=0.2128p ps=1.5u w=1.12u l=0.13u
X3779 VSS Y_uq107 a_10001_23923# VSS sg13_lv_nmos ad=0.14875p pd=1.16u as=0.187p ps=1.78u w=0.55u l=0.13u
X3780 VSS a_40930_10649# B_uq21 VSS sg13_lv_nmos ad=0.14875p pd=1.16u as=0.2886p ps=2.26u w=0.74u l=0.13u
X3781 VDD a_7346_22058# B_uq40 VDD sg13_lv_pmos ad=0.2254p pd=1.53u as=0.4256p ps=3u w=1.12u l=0.13u
X3782 a_28656_69630# D_uq65 a_28562_69630# VSS sg13_lv_nmos ad=60.89999f pd=0.71u as=0.1428p ps=1.52u w=0.42u l=0.13u
X3783 C1_uq6 Q_uq7 VSS VSS sg13_lv_nmos ad=0.1694p pd=1.21u as=0.1463p ps=1.15u w=0.77u l=0.13u
X3784 VSS clk a_79286_28224# VSS sg13_lv_nmos ad=2.70687p pd=17.445u as=0.2516p ps=2.16u w=0.74u l=0.13u
X3785 X_uq220 a_7724_20395# VSS VSS sg13_lv_nmos ad=0.2886p pd=2.26u as=0.14875p ps=1.16u w=0.74u l=0.13u
X3786 D_uq26 Y_uq219 a_10729_39672# VSS sg13_lv_nmos ad=0.1406p pd=1.12u as=0.1406p ps=1.12u w=0.74u l=0.13u
X3787 VDD a_44913_68891# a_45015_68891# VDD sg13_lv_pmos ad=1.42837p pd=8.61u as=0.3864p ps=2.93u w=1.12u l=0.13u
X3788 a_12142_21623# A_N VDD VDD sg13_lv_pmos ad=0.2464p pd=1.56u as=0.3808p ps=2.92u w=1.12u l=0.13u
X3789 VSS a_36206_10067# A_uq89 VSS sg13_lv_nmos ad=0.1469p pd=1.155u as=0.2516p ps=2.16u w=0.74u l=0.13u
X3790 a_3535_41421# a_3580_40023# VDD VDD sg13_lv_pmos ad=0.34p pd=2.68u as=0.36237p ps=2.605u w=1u l=0.13u
X3791 VSS VDD VSS VSS sg13_lv_nmos ad=0.1428p pd=1.52u as=0 ps=-0 w=0.42u l=1u
X3792 a_5800_23699# a_6319_23503# a_7059_23458# VSS sg13_lv_nmos ad=0.3473p pd=2.71u as=0.12665p ps=1.145u w=0.74u l=0.13u
X3793 VDD Q_uq27 a_3535_43295# VDD sg13_lv_pmos ad=0.2114p pd=1.54u as=0.2856p ps=2.36u w=0.84u l=0.13u
X3794 a_10345_31516# a_10383_32686# a_10504_31987# VDD sg13_lv_pmos ad=0.2048p pd=1.63u as=93.45f ps=0.865u w=0.42u l=0.13u
X3795 a_79045_20816# a_78787_21131# VDD VDD sg13_lv_pmos ad=93.45f pd=0.865u as=2.04445p ps=13.405u w=0.42u l=0.13u
X3796 VDD a_39683_69711# a_39683_69945# VDD sg13_lv_pmos ad=1.6733p pd=10.405u as=0.2442p ps=2.06u w=0.66u l=0.13u
X3797 a_35954_69630# a_36759_69752# a_36214_69853# VDD sg13_lv_pmos ad=0.1428p pd=1.52u as=79.8f ps=0.8u w=0.42u l=0.13u
X3798 a_49137_65856# X_uq445 VDD VDD sg13_lv_pmos ad=0.2464p pd=1.56u as=0.3808p ps=2.92u w=1.12u l=0.13u
X3799 VDD Y_uq71 a_77042_22205# VDD sg13_lv_pmos ad=0.2128p pd=1.5u as=0.2128p ps=1.5u w=1.12u l=0.13u
X3800 a_44482_8375# A_uq20 VSS VSS sg13_lv_nmos ad=0.187p pd=1.78u as=0.14875p ps=1.16u w=0.55u l=0.13u
X3801 a_6893_37967# Q_uq25 Y_uq206 VDD sg13_lv_pmos ad=0.1176p pd=1.33u as=0.3808p ps=2.92u w=1.12u l=0.13u
X3802 Q_uq35 a_35190_66904# VDD VDD sg13_lv_pmos ad=0.3808p pd=2.92u as=0.2128p ps=1.5u w=1.12u l=0.13u
X3803 VDD Y_uq238 a_4301_41167# VDD sg13_lv_pmos ad=0.1563p pd=1.22u as=0.147p ps=1.54u w=0.42u l=0.13u
X3804 VSS a_45898_9891# Y_uq17 VSS sg13_lv_nmos ad=0.17255p pd=1.25u as=0.1406p ps=1.12u w=0.74u l=0.13u
X3805 VSS A_uq87 a_39494_10301# VSS sg13_lv_nmos ad=0.1469p pd=1.155u as=0.1045p ps=0.93u w=0.55u l=0.13u
X3806 a_5096_35145# a_5047_36237# a_5096_35083# VSS sg13_lv_nmos ad=0.1428p pd=1.52u as=37.8f ps=0.6u w=0.42u l=0.13u
X3807 a_7059_23458# a_6217_23360# a_5800_23699# VDD sg13_lv_pmos ad=0.2048p pd=1.63u as=0.34p ps=2.68u w=1u l=0.13u
X3808 a_39574_67336# a_40017_67379# a_39314_67806# VSS sg13_lv_nmos ad=79.8f pd=0.8u as=0.1296p ps=1.52u w=0.42u l=0.13u
X3809 Y_uq162 B_uq76 VSS VSS sg13_lv_nmos ad=0.1694p pd=1.21u as=0.2618p ps=2.22u w=0.77u l=0.13u
X3810 VDD Y_uq122 a_10481_25435# VDD sg13_lv_pmos ad=0.2114p pd=1.54u as=0.2856p ps=2.36u w=0.84u l=0.13u
X3811 a_5405_40939# Y_uq229 a_5073_40834# VDD sg13_lv_pmos ad=0.2125p pd=1.425u as=0.35p ps=2.7u w=1u l=0.13u
X3812 a_5073_40834# Y_uq229 VSS VSS sg13_lv_nmos ad=0.1216p pd=1.02u as=0.15745p ps=1.175u w=0.64u l=0.13u
X3813 a_30275_64391# L_HI_uq21 VDD VDD sg13_lv_pmos ad=79.8f pd=0.8u as=0.36237p ps=2.605u w=0.42u l=0.13u
X3814 a_5809_36127# Q_uq16 VSS VSS sg13_lv_nmos ad=0.1428p pd=1.52u as=79.8f ps=0.8u w=0.42u l=0.13u
X3815 VSS a_5139_24504# a_5806_24143# VSS sg13_lv_nmos ad=0.1406p pd=1.12u as=0.2516p ps=2.16u w=0.74u l=0.13u
X3816 a_47387_66217# a_46545_65867# a_47293_66217# VSS sg13_lv_nmos ad=0.12665p pd=1.145u as=0.1428p ps=1.52u w=0.42u l=0.13u
X3817 VSS VDD VSS VSS sg13_lv_nmos ad=79.8f pd=0.8u as=0 ps=-0 w=0.42u l=1u
X3818 VDD a_9583_31905# a_10010_32928# VDD sg13_lv_pmos ad=0.1563p pd=1.22u as=63f ps=0.72u w=0.42u l=0.13u
X3819 VDD a_30107_69707# a_30364_69850# VDD sg13_lv_pmos ad=1.6733p pd=10.405u as=79.8f ps=0.8u w=0.42u l=0.13u
X3820 VSS X_uq90 a_34500_9229# VSS sg13_lv_nmos ad=0.17255p pd=1.25u as=0.187p ps=1.78u w=0.55u l=0.13u
X3821 VSS VDD VSS VSS sg13_lv_nmos ad=0.1428p pd=1.52u as=0 ps=-0 w=0.42u l=1u
X3822 VDD VSS VDD VDD sg13_lv_pmos ad=0.34p pd=2.68u as=0 ps=0 w=1u l=1u
X3823 a_9307_42679# Y_uq232 VSS VSS sg13_lv_nmos ad=37.8f pd=0.6u as=79.8f ps=0.8u w=0.42u l=0.13u
X3824 a_45755_69241# a_44913_68891# a_44496_68884# VDD sg13_lv_pmos ad=0.2048p pd=1.63u as=0.34p ps=2.68u w=1u l=0.13u
X3825 VDD a_6574_31914# a_6570_32837# VDD sg13_lv_pmos ad=2.4956p pd=16.32u as=0.3864p ps=2.93u w=1.12u l=0.13u
X3826 VDD L_HI_uq24 a_32978_66606# VDD sg13_lv_pmos ad=0.36237p pd=2.605u as=79.8f ps=0.8u w=0.42u l=0.13u
X3827 a_4297_25692# a_4297_25692# VSS VSS sg13_lv_nmos ad=0.111p pd=1.34u as=2.05957p ps=13.455u w=0.3u l=0.13u
X3828 VSS A_uq75 a_42566_9149# VSS sg13_lv_nmos ad=0.1469p pd=1.155u as=0.1045p ps=0.93u w=0.55u l=0.13u
X3829 VDD a_32938_9891# a_32896_10221# VDD sg13_lv_pmos ad=0.2618p pd=1.63u as=0.1176p ps=1.33u w=1.12u l=0.13u
X3830 VDD X_uq61 a_42948_8453# VDD sg13_lv_pmos ad=0.2618p pd=1.63u as=0.2856p ps=2.36u w=0.84u l=0.13u
X3831 VDD a_42214_63803# L_HI_uq10 VDD sg13_lv_pmos ad=1.4745p pd=9.07u as=0.3927p ps=2.99u w=1.155u l=0.13u
X3832 C_uq45 X_uq376 a_36950_63880# VDD sg13_lv_pmos ad=0.3808p pd=2.92u as=0.1176p ps=1.33u w=1.12u l=0.13u
X3833 VSS a_80675_28967# B_uq70 VSS sg13_lv_nmos ad=0.14875p pd=1.16u as=0.2886p ps=2.26u w=0.74u l=0.13u
X3834 a_39514_69318# a_39256_69318# VSS VSS sg13_lv_nmos ad=0.1428p pd=1.52u as=79.8f ps=0.8u w=0.42u l=0.13u
X3835 a_8086_31722# clk VDD VDD sg13_lv_pmos ad=0.4088p pd=2.97u as=1.4396p ps=9.25u w=1.12u l=0.13u
X3836 a_33536_68844# X_uq432 VSS VSS sg13_lv_nmos ad=0.187p pd=1.78u as=0.17255p ps=1.25u w=0.55u l=0.13u
X3837 VDD a_46018_7625# X_uq39 VDD sg13_lv_pmos ad=0.2114p pd=1.54u as=0.42p ps=2.99u w=1.12u l=0.13u
X3838 VSS L_HI_uq2 a_5608_21557# VSS sg13_lv_nmos ad=0.1626p pd=1.415u as=60.89999f ps=0.71u w=0.42u l=0.13u
X3839 a_8833_38292# a_8835_37148# a_9230_37462# VSS sg13_lv_nmos ad=0.12665p pd=1.145u as=0.1428p ps=1.52u w=0.42u l=0.13u
X3840 X_uq200 a_6572_20395# VDD VDD sg13_lv_pmos ad=0.42p pd=2.99u as=0.2114p ps=1.54u w=1.12u l=0.13u
X3841 VSS a_45922_9137# B_uq7 VSS sg13_lv_nmos ad=0.14875p pd=1.16u as=0.2886p ps=2.26u w=0.74u l=0.13u
X3842 B_uq5 a_34686_8449# VDD VDD sg13_lv_pmos ad=0.42p pd=2.99u as=0.2114p ps=1.54u w=1.12u l=0.13u
X3843 a_35864_64308# Q_uq45 VDD VDD sg13_lv_pmos ad=0.2856p pd=2.36u as=0.2114p ps=1.54u w=0.84u l=0.13u
X3844 a_8071_42647# Y_uq234 VDD VDD sg13_lv_pmos ad=79.8f pd=0.8u as=1.5243p ps=9.795u w=0.42u l=0.13u
X3845 a_79155_28614# a_79286_28224# a_78574_28217# VDD sg13_lv_pmos ad=0.34p pd=2.68u as=0.2048p ps=1.63u w=1u l=0.13u
X3846 VSS a_33941_67706# a_33862_67609# VSS sg13_lv_nmos ad=2.08687p pd=13.23u as=0.27427p ps=2.28u w=0.795u l=0.13u
X3847 Q_uq24 a_10345_43290# VDD VDD sg13_lv_pmos ad=0.3808p pd=2.92u as=0.2128p ps=1.5u w=1.12u l=0.13u
X3848 a_35770_65283# a_35885_65284# VDD VDD sg13_lv_pmos ad=0.34p pd=2.68u as=0.2254p ps=1.53u w=1u l=0.5u
X3849 VSS Q_uq3 C_uq9 VSS sg13_lv_nmos ad=0.1406p pd=1.12u as=0.2516p ps=2.16u w=0.74u l=0.13u
X3850 a_50422_64312# a_50865_64355# a_50805_64391# VDD sg13_lv_pmos ad=79.8f pd=0.8u as=63f ps=0.72u w=0.42u l=0.13u
X3851 a_49912_67368# a_49690_67424# VDD VDD sg13_lv_pmos ad=0.1176p pd=1.33u as=0.2618p ps=1.63u w=1.12u l=0.13u
X3852 a_31294_67806# L_HI_uq25 VSS VSS sg13_lv_nmos ad=37.8f pd=0.6u as=79.8f ps=0.8u w=0.42u l=0.13u
X3853 VSS C_uq16 a_9671_18965# VSS sg13_lv_nmos ad=0.18575p pd=1.26u as=0.187p ps=1.78u w=0.55u l=0.13u
X3854 VDD a_39227_64705# a_39484_64586# VDD sg13_lv_pmos ad=1.4745p pd=9.07u as=79.8f ps=0.8u w=0.42u l=0.13u
X3855 a_50280_66570# a_50411_66876# a_49699_66570# VDD sg13_lv_pmos ad=0.34p pd=2.68u as=0.2048p ps=1.63u w=1u l=0.13u
X3856 VSS X_uq409 C_uq51 VSS sg13_lv_nmos ad=0.2516p pd=2.16u as=0.1406p ps=1.12u w=0.74u l=0.13u
X3857 a_42658_10649# X_uq362 VSS VSS sg13_lv_nmos ad=0.187p pd=1.78u as=0.14875p ps=1.16u w=0.55u l=0.13u
X3858 a_42178_6863# Y_uq18 VDD VDD sg13_lv_pmos ad=0.2856p pd=2.36u as=0.2114p ps=1.54u w=0.84u l=0.13u
X3859 a_48867_68416# Y_uq317 a_48753_68416# VDD sg13_lv_pmos ad=0.2128p pd=1.5u as=0.2464p ps=1.56u w=1.12u l=0.13u
X3860 X_uq172 a_8945_17875# VDD VDD sg13_lv_pmos ad=0.42p pd=2.99u as=0.2114p ps=1.54u w=1.12u l=0.13u
X3861 a_39814_68086# Y_uq322 VSS VSS sg13_lv_nmos ad=0.1428p pd=1.52u as=79.8f ps=0.8u w=0.42u l=0.13u
X3862 VDD Q_uq54 Y_uq291 VDD sg13_lv_pmos ad=0.3808p pd=2.92u as=0.3808p ps=2.92u w=1.12u l=0.13u
X3863 VSS B_uq81 C_uq34 VSS sg13_lv_nmos ad=0.2516p pd=2.16u as=0.1406p ps=1.12u w=0.74u l=0.13u
X3864 a_76741_25229# A2_uq2 VDD VDD sg13_lv_pmos ad=0.2128p pd=1.5u as=0.3808p ps=2.92u w=1.12u l=0.13u
X3865 a_8956_37847# a_8833_38292# a_9307_37975# VSS sg13_lv_nmos ad=0.1428p pd=1.52u as=37.8f ps=0.6u w=0.42u l=0.13u
X3866 VDD a_51608_68844# q[30] VDD sg13_lv_pmos ad=0.2114p pd=1.54u as=0.42p ps=2.99u w=1.12u l=0.13u
X3867 VSS C_uq9 a_77248_23741# VSS sg13_lv_nmos ad=0.1045p pd=0.93u as=0.187p ps=1.78u w=0.55u l=0.13u
X3868 a_29338_64782# a_29579_64315# a_28867_64308# VSS sg13_lv_nmos ad=0.1428p pd=1.52u as=0.12665p ps=1.145u w=0.42u l=0.13u
X3869 VSS Q_uq0 a_6572_20395# VSS sg13_lv_nmos ad=0.14875p pd=1.16u as=0.187p ps=1.78u w=0.55u l=0.13u
X3870 VSS B_uq74 a_7321_33423# VSS sg13_lv_nmos ad=0.15745p pd=1.175u as=0.1216p ps=1.02u w=0.64u l=0.13u
X3871 a_7321_34111# Q_uq14 VDD VDD sg13_lv_pmos ad=0.1428p pd=1.52u as=0.1523p ps=1.38u w=0.42u l=0.13u
X3872 Y_uq260 a_45466_65136# VSS VSS sg13_lv_nmos ad=0.1406p pd=1.12u as=0.17255p ps=1.25u w=0.74u l=0.13u
X3873 VDD Y_uq7 a_32478_6937# VDD sg13_lv_pmos ad=0.2114p pd=1.54u as=0.2856p ps=2.36u w=0.84u l=0.13u
X3874 a_36657_69609# clk VSS VSS sg13_lv_nmos ad=0.2516p pd=2.16u as=1.9335p ps=12.315u w=0.74u l=0.13u
X3875 VSS X_uq454 Y_uq342 VSS sg13_lv_nmos ad=0.2516p pd=2.16u as=0.1406p ps=1.12u w=0.74u l=0.13u
X3876 a_8873_41001# a_8871_41783# a_8833_42996# VSS sg13_lv_nmos ad=0.3473p pd=2.71u as=0.12665p ps=1.145u w=0.74u l=0.13u
X3877 a_51237_68433# a_50295_68240# a_51035_68195# VDD sg13_lv_pmos ad=93.45f pd=0.865u as=0.2048p ps=1.63u w=0.42u l=0.13u
X3878 VDD Q_uq2 a_77444_23741# VDD sg13_lv_pmos ad=0.3822p pd=1.84u as=0.1575p ps=1.315u w=1u l=0.13u
X3879 VSS clk a_10347_32660# VSS sg13_lv_nmos ad=4.4154p pd=28.205u as=0.2516p ps=2.16u w=0.74u l=0.13u
X3880 a_37786_65283# a_37901_65284# VDD VDD sg13_lv_pmos ad=0.34p pd=2.68u as=0.2254p ps=1.53u w=1u l=0.5u
X3881 a_38543_68416# Y_uq338 a_38441_68416# VDD sg13_lv_pmos ad=0.2464p pd=1.56u as=0.2128p ps=1.5u w=1.12u l=0.13u
X3882 Y_uq137 B2_uq9 a_76534_27133# VSS sg13_lv_nmos ad=0.2664p pd=1.46u as=0.13875p ps=1.115u w=0.74u l=0.13u
X3883 VSS q[11] a_35070_10685# VSS sg13_lv_nmos ad=0.14875p pd=1.16u as=0.187p ps=1.78u w=0.55u l=0.13u
X3884 a_6215_38548# a_5809_38522# B_uq87 VSS sg13_lv_nmos ad=0.1406p pd=1.12u as=0.333p ps=2.38u w=0.74u l=0.13u
X3885 a_48070_65062# Q_uq31 VDD VDD sg13_lv_pmos ad=0.1428p pd=1.52u as=0.1523p ps=1.38u w=0.42u l=0.13u
X3886 a_48250_67635# a_48365_67634# VDD VDD sg13_lv_pmos ad=0.34p pd=2.68u as=0.2254p ps=1.53u w=1u l=0.5u
X3887 a_6088_21544# a_5800_21123# a_6026_21544# VSS sg13_lv_nmos ad=0.1428p pd=1.52u as=37.8f ps=0.6u w=0.42u l=0.13u
X3888 VSS VDD VSS VSS sg13_lv_nmos ad=0.1428p pd=1.52u as=0 ps=-0 w=0.42u l=1u
X3889 a_37809_65867# clk VDD VDD sg13_lv_pmos ad=0.4088p pd=2.97u as=1.37835p ps=8.63u w=1.12u l=0.13u
X3890 C_uq63 X_uq427 a_45974_68416# VDD sg13_lv_pmos ad=0.3808p pd=2.92u as=0.1176p ps=1.33u w=1.12u l=0.13u
X3891 a_33009_69609# clk VSS VSS sg13_lv_nmos ad=0.2516p pd=2.16u as=1.9335p ps=12.315u w=0.74u l=0.13u
X3892 VSS X_uq137 Y_uq9 VSS sg13_lv_nmos ad=0.2516p pd=2.16u as=0.1406p ps=1.12u w=0.74u l=0.13u
X3893 a_7321_34574# B_uq80 VDD VDD sg13_lv_pmos ad=0.1596p pd=1.22u as=0.1918p ps=1.5u w=0.84u l=0.13u
X3894 VSS Q_uq26 a_7321_43295# VSS sg13_lv_nmos ad=0.14875p pd=1.16u as=0.187p ps=1.78u w=0.55u l=0.13u
X3895 a_78404_25253# B_uq51 a_78302_25253# VDD sg13_lv_pmos ad=0.1575p pd=1.315u as=0.19p ps=1.38u w=1u l=0.13u
X3896 VSS a_5630_22595# a_5349_22897# VSS sg13_lv_nmos ad=79.8f pd=0.8u as=0.1428p ps=1.52u w=0.42u l=0.5u
X3897 q[6] a_27988_63620# VDD VDD sg13_lv_pmos ad=0.42p pd=2.99u as=0.2114p ps=1.54u w=1.12u l=0.13u
X3898 a_6590_25619# Y_uq133 VSS VSS sg13_lv_nmos ad=0.1428p pd=1.52u as=79.8f ps=0.8u w=0.42u l=0.13u
X3899 VDD a_33851_69707# a_34108_69850# VDD sg13_lv_pmos ad=1.6733p pd=10.405u as=79.8f ps=0.8u w=0.42u l=0.13u
X3900 a_5809_43188# a_5811_42044# a_6206_42358# VSS sg13_lv_nmos ad=0.12665p pd=1.145u as=0.1428p ps=1.52u w=0.42u l=0.13u
X3901 a_42768_67806# D_uq52 a_42674_67806# VSS sg13_lv_nmos ad=60.89999f pd=0.71u as=0.1428p ps=1.52u w=0.42u l=0.13u
X3902 a_8849_38973# Q_uq19 VDD VDD sg13_lv_pmos ad=0.2128p pd=1.5u as=0.3808p ps=2.92u w=1.12u l=0.15u
X3903 a_8071_32685# a_8116_31287# VSS VSS sg13_lv_nmos ad=0.2516p pd=2.16u as=0.1626p ps=1.415u w=0.74u l=0.13u
X3904 a_36994_7625# A_uq2 VDD VDD sg13_lv_pmos ad=0.2856p pd=2.36u as=0.2114p ps=1.54u w=0.84u l=0.13u
X3905 a_4592_25655# B_uq66 C_uq25 VDD sg13_lv_pmos ad=0.1176p pd=1.33u as=0.3808p ps=2.92u w=1.12u l=0.13u
X3906 VSS a_35458_7625# B_uq11 VSS sg13_lv_nmos ad=0.14875p pd=1.16u as=0.2886p ps=2.26u w=0.74u l=0.13u
X3907 a_42274_10649# q[20] VDD VDD sg13_lv_pmos ad=0.2856p pd=2.36u as=0.2114p ps=1.54u w=0.84u l=0.13u
X3908 C1_uq7 C_uq27 a_75726_28253# VDD sg13_lv_pmos ad=0.3808p pd=2.92u as=0.2128p ps=1.5u w=1.12u l=0.13u
X3909 a_30586_63771# a_30701_63772# VSS VSS sg13_lv_nmos ad=0.1428p pd=1.52u as=0.1426p ps=1.16u w=0.42u l=0.5u
X3910 a_42897_65392# X_uq447 VDD VDD sg13_lv_pmos ad=0.2464p pd=1.56u as=0.3808p ps=2.92u w=1.12u l=0.13u
X3911 VDD VSS VDD VDD sg13_lv_pmos ad=0.19p pd=1.38u as=0 ps=0 w=1u l=1u
X3912 a_76645_23253# C1_uq5 Y_uq86 VDD sg13_lv_pmos ad=0.2128p pd=1.5u as=0.3808p ps=2.92u w=1.12u l=0.13u
X3913 a_5047_32685# a_5092_31287# VSS VSS sg13_lv_nmos ad=0.2516p pd=2.16u as=0.1626p ps=1.415u w=0.74u l=0.13u
X3914 C_uq30 C_uq33 VSS VSS sg13_lv_nmos ad=0.1406p pd=1.12u as=0.2516p ps=2.16u w=0.74u l=0.13u
X3915 VDD a_42368_68086# a_42326_68416# VDD sg13_lv_pmos ad=0.2618p pd=1.63u as=0.1176p ps=1.33u w=1.12u l=0.13u
X3916 VDD C_uq36 a_7321_31295# VDD sg13_lv_pmos ad=0.2114p pd=1.54u as=0.2856p ps=2.36u w=0.84u l=0.13u
X3917 a_5062_31722# clk VSS VSS sg13_lv_nmos ad=0.2516p pd=2.16u as=4.1981p ps=26.905u w=0.74u l=0.13u
X3918 a_35088_66281# a_35319_65867# a_34774_65824# VSS sg13_lv_nmos ad=0.2373p pd=1.97u as=79.8f ps=0.8u w=0.42u l=0.13u
X3919 a_5083_34665# D_uq20 a_5083_34571# VSS sg13_lv_nmos ad=60.89999f pd=0.71u as=0.1428p ps=1.52u w=0.42u l=0.13u
X3920 VSS din[14] a_75679_25229# VSS sg13_lv_nmos ad=0.14875p pd=1.16u as=0.187p ps=1.78u w=0.55u l=0.13u
X3921 VSS a_42776_65820# X_uq399 VSS sg13_lv_nmos ad=0.14875p pd=1.16u as=0.2886p ps=2.26u w=0.74u l=0.13u
X3922 VDD a_43259_64705# a_43516_64586# VDD sg13_lv_pmos ad=1.4745p pd=9.07u as=79.8f ps=0.8u w=0.42u l=0.13u
X3923 a_77221_19181# C1 Y_uq45 VDD sg13_lv_pmos ad=0.2128p pd=1.5u as=0.3808p ps=2.92u w=1.12u l=0.13u
X3924 X_uq192 a_12209_20111# VDD VDD sg13_lv_pmos ad=0.42p pd=2.99u as=0.2114p ps=1.54u w=1.12u l=0.13u
X3925 a_6595_31211# D_uq12 VDD VDD sg13_lv_pmos ad=79.8f pd=0.8u as=0.1428p ps=1.52u w=0.42u l=0.13u
X3926 VDD VSS VDD VDD sg13_lv_pmos ad=0.19p pd=1.38u as=0 ps=0 w=1u l=1u
X3927 VDD X_uq152 a_39780_9229# VDD sg13_lv_pmos ad=0.2618p pd=1.63u as=0.2856p ps=2.36u w=0.84u l=0.13u
X3928 a_39610_66795# a_39725_66796# VDD VDD sg13_lv_pmos ad=0.34p pd=2.68u as=0.2254p ps=1.53u w=1u l=0.5u
X3929 X_uq273 a_77503_29041# VDD VDD sg13_lv_pmos ad=0.42p pd=2.99u as=0.2114p ps=1.54u w=1.12u l=0.13u
X3930 a_45826_10649# q[24] VDD VDD sg13_lv_pmos ad=0.2856p pd=2.36u as=0.2114p ps=1.54u w=0.84u l=0.13u
X3931 a_37454_9489# B_uq4 a_37596_9149# VDD sg13_lv_pmos ad=0.2856p pd=2.36u as=0.1596p ps=1.22u w=0.84u l=0.13u
X3932 a_27608_68082# X_uq458 VSS VSS sg13_lv_nmos ad=0.187p pd=1.78u as=0.14875p ps=1.16u w=0.55u l=0.13u
X3933 a_6910_42654# a_6570_42533# a_6559_42907# VDD sg13_lv_pmos ad=93.45f pd=0.865u as=0.2048p ps=1.63u w=0.42u l=0.13u
X3934 VDD X_uq156 a_38820_8453# VDD sg13_lv_pmos ad=0.2618p pd=1.63u as=0.2856p ps=2.36u w=0.84u l=0.13u
X3935 a_6494_22595# Y_uq91 VSS VSS sg13_lv_nmos ad=0.1428p pd=1.52u as=79.8f ps=0.8u w=0.42u l=0.13u
X3936 a_29434_65283# a_29549_65284# VSS VSS sg13_lv_nmos ad=0.1428p pd=1.52u as=0.1426p ps=1.16u w=0.42u l=0.5u
X3937 VSS a_8833_34465# A2_uq9 VSS sg13_lv_nmos ad=0.15745p pd=1.175u as=0.2351p ps=2.16u w=0.74u l=0.13u
X3938 Y_uq247 Q_uq31 VDD VDD sg13_lv_pmos ad=0.3808p pd=2.92u as=0.3808p ps=2.92u w=1.12u l=0.13u
X3939 VSS Y_uq268 a_37972_63620# VSS sg13_lv_nmos ad=0.14875p pd=1.16u as=0.187p ps=1.78u w=0.55u l=0.13u
X3940 C_uq71 X_uq433 VSS VSS sg13_lv_nmos ad=0.1406p pd=1.12u as=0.2516p ps=2.16u w=0.74u l=0.13u
X3941 Y_uq57 D_uq1 VSS VSS sg13_lv_nmos ad=0.2618p pd=2.22u as=0.1463p ps=1.15u w=0.77u l=0.13u
X3942 a_50448_67806# D_uq50 a_50354_67806# VSS sg13_lv_nmos ad=60.89999f pd=0.71u as=0.1428p ps=1.52u w=0.42u l=0.13u
X3943 VSS X_uq82 a_39006_6937# VSS sg13_lv_nmos ad=0.14875p pd=1.16u as=0.187p ps=1.78u w=0.55u l=0.13u
X3944 VSS X_uq137 a_45254_10301# VSS sg13_lv_nmos ad=0.1469p pd=1.155u as=0.1045p ps=0.93u w=0.55u l=0.13u
X3945 a_35864_64308# Q_uq45 VSS VSS sg13_lv_nmos ad=0.187p pd=1.78u as=0.14875p ps=1.16u w=0.55u l=0.13u
X3946 X_uq271 a_76063_26741# VDD VDD sg13_lv_pmos ad=0.42p pd=2.99u as=0.2114p ps=1.54u w=1.12u l=0.13u
X3947 a_9632_38025# a_9583_39117# a_9632_37963# VSS sg13_lv_nmos ad=0.1428p pd=1.52u as=37.8f ps=0.6u w=0.42u l=0.13u
X3948 VDD L_HI_uq36 a_41494_69853# VDD sg13_lv_pmos ad=0.1563p pd=1.22u as=0.147p ps=1.54u w=0.42u l=0.13u
X3949 VDD a_34972_64586# a_34917_64467# VDD sg13_lv_pmos ad=1.4745p pd=9.07u as=93.45f ps=0.865u w=0.42u l=0.13u
X3950 a_6936_21837# B_uq66 VDD VDD sg13_lv_pmos ad=0.2856p pd=2.36u as=0.2618p ps=1.63u w=0.84u l=0.13u
X3951 a_47302_68844# Q_uq42 VDD VDD sg13_lv_pmos ad=0.1428p pd=1.52u as=0.1523p ps=1.38u w=0.42u l=0.13u
X3952 VSS D_uq7 Y_uq113 VSS sg13_lv_nmos ad=0.1463p pd=1.15u as=0.2618p ps=2.22u w=0.77u l=0.13u
X3953 a_6215_37087# Y_uq196 D_uq30 VSS sg13_lv_nmos ad=0.1406p pd=1.12u as=0.2516p ps=2.16u w=0.74u l=0.13u
X3954 VSS din[2] a_77503_29041# VSS sg13_lv_nmos ad=0.14875p pd=1.16u as=0.187p ps=1.78u w=0.55u l=0.13u
X3955 a_44421_67491# a_43479_67379# a_44219_67729# VDD sg13_lv_pmos ad=93.45f pd=0.865u as=0.2048p ps=1.63u w=0.42u l=0.13u
X3956 VDD a_48166_68339# L_HI_uq34 VDD sg13_lv_pmos ad=1.42837p pd=8.61u as=0.3927p ps=2.99u w=1.155u l=0.13u
X3957 a_51142_68844# Q_uq41 VSS VSS sg13_lv_nmos ad=0.1428p pd=1.52u as=79.8f ps=0.8u w=0.42u l=0.13u
X3958 a_29842_69305# L_HI_uq32 VSS VSS sg13_lv_nmos ad=37.8f pd=0.6u as=0.1701p ps=1.65u w=0.42u l=0.13u
X3959 a_9628_40311# a_9598_40746# a_9619_40043# VSS sg13_lv_nmos ad=79.8f pd=0.8u as=0.1296p ps=1.52u w=0.42u l=0.13u
X3960 a_78459_27179# D_uq10 a_78365_27179# VSS sg13_lv_nmos ad=60.89999f pd=0.71u as=0.1428p ps=1.52u w=0.42u l=0.13u
X3961 a_6088_23394# a_5800_23699# a_6026_23394# VSS sg13_lv_nmos ad=0.1428p pd=1.52u as=37.8f ps=0.6u w=0.42u l=0.13u
X3962 VDD a_44603_66217# a_45270_65856# VDD sg13_lv_pmos ad=0.2128p pd=1.5u as=0.3864p ps=2.93u w=1.12u l=0.13u
X3963 VSS Y_uq22 a_37854_6937# VSS sg13_lv_nmos ad=0.14875p pd=1.16u as=0.187p ps=1.78u w=0.55u l=0.13u
X3964 VDD a_4478_21360# L_HI_uq1 VDD sg13_lv_pmos ad=1.37097p pd=8.54u as=0.3927p ps=2.99u w=1.155u l=0.13u
X3965 D_uq50 C_uq58 VSS VSS sg13_lv_nmos ad=0.2618p pd=2.22u as=0.1463p ps=1.15u w=0.77u l=0.13u
X3966 a_30107_69707# a_29265_69609# a_28848_69948# VDD sg13_lv_pmos ad=0.2048p pd=1.63u as=0.34p ps=2.68u w=1u l=0.13u
X3967 VSS clk a_51275_65364# VSS sg13_lv_nmos ad=4.19255p pd=26u as=0.2516p ps=2.16u w=0.74u l=0.13u
X3968 a_10428_41738# D_uq27 VDD VDD sg13_lv_pmos ad=79.8f pd=0.8u as=0.1428p ps=1.52u w=0.42u l=0.13u
X3969 a_9583_42737# Y_uq233 VDD VDD sg13_lv_pmos ad=0.2856p pd=2.36u as=0.2114p ps=1.54u w=0.84u l=0.13u
X3970 a_9619_33563# a_9598_32468# a_9628_33337# VSS sg13_lv_nmos ad=0.1296p pd=1.52u as=79.8f ps=0.8u w=0.42u l=0.13u
X3971 VDD Y_uq75 a_12593_20111# VDD sg13_lv_pmos ad=0.2114p pd=1.54u as=0.2856p ps=2.36u w=0.84u l=0.13u
X3972 VSS a_7059_23458# a_7726_23679# VSS sg13_lv_nmos ad=0.1406p pd=1.12u as=0.2516p ps=2.16u w=0.74u l=0.13u
X3973 a_77219_28967# din[3] VSS VSS sg13_lv_nmos ad=0.187p pd=1.78u as=0.14875p ps=1.16u w=0.55u l=0.13u
X3974 a_45348_10301# B_uq6 a_45254_10301# VDD sg13_lv_pmos ad=0.1596p pd=1.22u as=0.2856p ps=2.36u w=0.84u l=0.13u
X3975 a_10428_35406# a_10385_35049# VDD VDD sg13_lv_pmos ad=63f pd=0.72u as=0.1563p ps=1.22u w=0.42u l=0.13u
X3976 C_uq4 C_uq24 VDD VDD sg13_lv_pmos ad=0.2128p pd=1.5u as=0.2198p ps=1.53u w=1.12u l=0.13u
X3977 a_42960_67372# a_42934_67336# VSS VSS sg13_lv_nmos ad=0.2516p pd=2.16u as=0.1626p ps=1.415u w=0.74u l=0.13u
X3978 a_76939_27517# Y_uq144 VSS VSS sg13_lv_nmos ad=0.1406p pd=1.12u as=0.1406p ps=1.12u w=0.74u l=0.13u
X3979 a_7321_33723# a_7345_33831# VDD VDD sg13_lv_pmos ad=0.34p pd=2.68u as=0.2254p ps=1.53u w=1u l=0.5u
X3980 VSS L_HI_uq30 a_33168_68118# VSS sg13_lv_nmos ad=0.1626p pd=1.415u as=60.89999f ps=0.71u w=0.42u l=0.13u
X3981 VSS Y_uq119 a_11633_25435# VSS sg13_lv_nmos ad=0.14875p pd=1.16u as=0.187p ps=1.78u w=0.55u l=0.13u
X3982 Q_uq54 a_43446_69928# VDD VDD sg13_lv_pmos ad=0.3808p pd=2.92u as=0.2128p ps=1.5u w=1.12u l=0.13u
X3983 a_36440_64308# Q_uq55 VDD VDD sg13_lv_pmos ad=0.2856p pd=2.36u as=0.2114p ps=1.54u w=0.84u l=0.13u
X3984 a_46906_69147# a_47021_69146# VDD VDD sg13_lv_pmos ad=0.34p pd=2.68u as=0.2254p ps=1.53u w=1u l=0.5u
X3985 Y_uq293 Q_uq38 VSS VSS sg13_lv_nmos ad=0.2516p pd=2.16u as=0.2516p ps=2.16u w=0.74u l=0.13u
X3986 VDD a_33170_65098# a_33282_65162# VDD sg13_lv_pmos ad=0.2254p pd=1.53u as=0.34p ps=2.68u w=1u l=0.5u
X3987 a_42000_64348# a_42519_64355# a_43259_64705# VSS sg13_lv_nmos ad=0.3473p pd=2.71u as=0.12665p ps=1.145u w=0.74u l=0.13u
X3988 A_uq97 a_32382_9961# VDD VDD sg13_lv_pmos ad=0.42p pd=2.99u as=0.2114p ps=1.54u w=1.12u l=0.13u
X3989 VDD a_46342_63803# L_HI_uq13 VDD sg13_lv_pmos ad=1.4745p pd=9.07u as=0.3927p ps=2.99u w=1.155u l=0.13u
X3990 VSS a_39032_68082# X_uq432 VSS sg13_lv_nmos ad=0.14875p pd=1.16u as=0.2886p ps=2.26u w=0.74u l=0.13u
X3991 a_8120_31593# a_8071_32685# a_8120_31531# VSS sg13_lv_nmos ad=0.1428p pd=1.52u as=37.8f ps=0.6u w=0.42u l=0.13u
X3992 X_uq411 a_27316_66644# VDD VDD sg13_lv_pmos ad=0.42p pd=2.99u as=0.2114p ps=1.54u w=1.12u l=0.13u
X3993 VSS X_uq323 Y_uq210 VSS sg13_lv_nmos ad=0.2516p pd=2.16u as=0.2516p ps=2.16u w=0.74u l=0.13u
X3994 a_33238_66829# a_33681_66585# a_32978_66606# VSS sg13_lv_nmos ad=79.8f pd=0.8u as=0.1296p ps=1.52u w=0.42u l=0.13u
X3995 a_52101_67491# a_51159_67379# a_51899_67729# VDD sg13_lv_pmos ad=93.45f pd=0.865u as=0.2048p ps=1.63u w=0.42u l=0.13u
X3996 B_uq51 Q_uq3 VSS VSS sg13_lv_nmos ad=0.2516p pd=2.16u as=0.1406p ps=1.12u w=0.74u l=0.13u
X3997 VSS L_HI_uq4 a_78459_24467# VSS sg13_lv_nmos ad=0.1626p pd=1.415u as=60.89999f ps=0.71u w=0.42u l=0.13u
X3998 a_5051_42745# a_5087_43067# VDD VDD sg13_lv_pmos ad=0.34p pd=2.68u as=0.2254p ps=1.53u w=1u l=0.5u
X3999 VDD Y_uq231 a_10349_41167# VDD sg13_lv_pmos ad=0.1563p pd=1.22u as=0.147p ps=1.54u w=0.42u l=0.13u
X4000 a_41410_6863# Y_uq19 VSS VSS sg13_lv_nmos ad=0.187p pd=1.78u as=0.14875p ps=1.16u w=0.55u l=0.13u
X4001 VDD Y_uq190 a_7357_36139# VDD sg13_lv_pmos ad=0.19p pd=1.38u as=0.2125p ps=1.425u w=1u l=0.13u
X4002 a_46264_64782# a_46051_64308# VDD VDD sg13_lv_pmos ad=79.8f pd=0.8u as=1.4745p ps=9.07u w=0.42u l=0.13u
X4003 a_33456_64348# a_33430_64312# VDD VDD sg13_lv_pmos ad=0.34p pd=2.68u as=0.36237p ps=2.605u w=1u l=0.13u
X4004 VSS a_40785_65867# a_40887_65867# VSS sg13_lv_nmos ad=1.8643p pd=11.96u as=0.2516p ps=2.16u w=0.74u l=0.13u
X4005 a_33682_64769# L_HI_uq12 VSS VSS sg13_lv_nmos ad=37.8f pd=0.6u as=0.1701p ps=1.65u w=0.42u l=0.13u
X4006 VSS a_40545_68927# a_39624_69241# VSS sg13_lv_nmos ad=0.1626p pd=1.415u as=0.2516p ps=2.16u w=0.74u l=0.13u
X4007 VSS X_uq150 a_39972_9965# VSS sg13_lv_nmos ad=0.17255p pd=1.25u as=0.187p ps=1.78u w=0.55u l=0.13u
X4008 a_8079_37083# S VSS VSS sg13_lv_nmos ad=0.187p pd=1.78u as=0.18575p ps=1.26u w=0.55u l=0.13u
X4009 X_uq450 a_48148_68880# VDD VDD sg13_lv_pmos ad=0.42p pd=2.99u as=0.2114p ps=1.54u w=1.12u l=0.13u
X4010 VSS a_4297_43188# a_4297_43290# VSS sg13_lv_nmos ad=0.1406p pd=1.12u as=0.2516p ps=2.16u w=0.74u l=0.13u
X4011 VDD a_48177_69609# a_48279_69752# VDD sg13_lv_pmos ad=1.6733p pd=10.405u as=0.3864p ps=2.93u w=1.12u l=0.13u
X4012 a_8873_36297# a_8837_36271# VSS VSS sg13_lv_nmos ad=0.2516p pd=2.16u as=0.1626p ps=1.415u w=0.74u l=0.13u
X4013 a_52065_65252# a_51123_65312# a_51926_65252# VSS sg13_lv_nmos ad=79.8f pd=0.8u as=0.2373p ps=1.97u w=0.42u l=0.13u
X4014 Y_uq280 X_uq387 a_32536_65856# VDD sg13_lv_pmos ad=0.3808p pd=2.92u as=0.1176p ps=1.33u w=1.12u l=0.13u
X4015 VDD din[5] a_76351_29041# VDD sg13_lv_pmos ad=0.2114p pd=1.54u as=0.2856p ps=2.36u w=0.84u l=0.13u
X4016 VDD a_79068_26752# a_79170_26752# VDD sg13_lv_pmos ad=2.04445p pd=13.405u as=0.3864p ps=2.93u w=1.12u l=0.13u
X4017 Y_uq82 B1_uq7 a_75979_22981# VSS sg13_lv_nmos ad=0.2516p pd=2.16u as=0.1406p ps=1.12u w=0.74u l=0.13u
X4018 D_uq29 Y_uq219 VSS VSS sg13_lv_nmos ad=0.2516p pd=2.16u as=0.2516p ps=2.16u w=0.74u l=0.13u
X4019 a_50640_67372# a_50614_67336# VSS VSS sg13_lv_nmos ad=0.2516p pd=2.16u as=0.1626p ps=1.415u w=0.74u l=0.13u
X4020 VSS A_uq391 a_27316_66644# VSS sg13_lv_nmos ad=0.14875p pd=1.16u as=0.187p ps=1.78u w=0.55u l=0.13u
X4021 a_77720_27517# Y_uq141 B1_uq5 VSS sg13_lv_nmos ad=0.1406p pd=1.12u as=0.1406p ps=1.12u w=0.74u l=0.13u
X4022 a_33941_67706# a_34065_67405# VDD VDD sg13_lv_pmos ad=0.2442p pd=2.06u as=1.19383p ps=7.16u w=0.66u l=0.13u
X4023 a_7292_38117# C_uq36 VDD VDD sg13_lv_pmos ad=0.1596p pd=1.22u as=0.36195p ps=1.84u w=0.84u l=0.13u
X4024 a_80329_24467# L_HI_uq4 VSS VSS sg13_lv_nmos ad=37.8f pd=0.6u as=79.8f ps=0.8u w=0.42u l=0.13u
X4025 C_uq28 a_75583_29041# VSS VSS sg13_lv_nmos ad=0.2886p pd=2.26u as=0.14875p ps=1.16u w=0.74u l=0.13u
X4026 a_7261_25208# a_6319_25015# a_7059_24970# VDD sg13_lv_pmos ad=93.45f pd=0.865u as=0.2048p ps=1.63u w=0.42u l=0.13u
X4027 VSS a_42926_10067# A_uq72 VSS sg13_lv_nmos ad=0.1469p pd=1.155u as=0.2516p ps=2.16u w=0.74u l=0.13u
X4028 a_38986_9137# X_uq81 VSS VSS sg13_lv_nmos ad=0.187p pd=1.78u as=0.17255p ps=1.25u w=0.55u l=0.13u
X4029 VDD a_6590_25619# a_6309_25921# VDD sg13_lv_pmos ad=0.1523p pd=1.38u as=0.34p ps=2.68u w=1u l=0.5u
X4030 a_76438_22181# Y_uq72 VDD VDD sg13_lv_pmos ad=0.2716p pd=1.605u as=0.3808p ps=2.92u w=1.12u l=0.13u
X4031 VSS a_7742_22595# a_7461_22897# VSS sg13_lv_nmos ad=79.8f pd=0.8u as=0.1428p ps=1.52u w=0.42u l=0.5u
X4032 VDD X_uq455 a_27802_68936# VDD sg13_lv_pmos ad=0.2618p pd=1.63u as=0.2856p ps=2.36u w=0.84u l=0.13u
X4033 a_44860_66098# L_HI_uq19 VDD VDD sg13_lv_pmos ad=79.8f pd=0.8u as=1.41367p ps=8.85u w=0.42u l=0.13u
X4034 VSS B_uq75 a_8832_34225# VSS sg13_lv_nmos ad=0.15245p pd=1.17u as=0.17462p ps=1.185u w=0.55u l=0.13u
X4035 D_uq44 C_uq55 a_37443_65392# VDD sg13_lv_pmos ad=0.3808p pd=2.92u as=0.2128p ps=1.5u w=1.12u l=0.13u
X4036 a_80593_25947# Q_uq7 VDD VDD sg13_lv_pmos ad=0.1428p pd=1.52u as=0.1523p ps=1.38u w=0.42u l=0.13u
X4037 Y_uq364 Q_uq59 VSS VSS sg13_lv_nmos ad=0.2516p pd=2.16u as=0.2516p ps=2.16u w=0.74u l=0.13u
X4038 a_12149_25695# C_uq20 Y_uq131 VDD sg13_lv_pmos ad=0.1176p pd=1.33u as=0.3808p ps=2.92u w=1.12u l=0.13u
X4039 VDD a_39874_7625# X_uq51 VDD sg13_lv_pmos ad=0.2114p pd=1.54u as=0.42p ps=2.99u w=1.12u l=0.13u
X4040 a_4301_41167# a_4299_42044# a_4380_41738# VSS sg13_lv_nmos ad=79.8f pd=0.8u as=0.1296p ps=1.52u w=0.42u l=0.13u
X4041 VSS X_uq429 C_uq65 VSS sg13_lv_nmos ad=0.2516p pd=2.16u as=0.1406p ps=1.12u w=0.74u l=0.13u
X4042 VDD a_78455_22492# Q_uq3 VDD sg13_lv_pmos ad=0.2128p pd=1.5u as=0.3808p ps=2.92u w=1.12u l=0.13u
X4043 a_76052_28253# C_uq28 C1_uq6 VDD sg13_lv_pmos ad=0.2128p pd=1.5u as=0.3808p ps=2.92u w=1.12u l=0.13u
X4044 X_uq311 a_3539_39543# VSS VSS sg13_lv_nmos ad=0.2516p pd=2.16u as=0.1426p ps=1.16u w=0.74u l=0.13u
X4045 VSS B_uq74 Y_uq162 VSS sg13_lv_nmos ad=0.1463p pd=1.15u as=0.1694p ps=1.21u w=0.77u l=0.13u
X4046 a_34714_65283# a_34829_65284# VDD VDD sg13_lv_pmos ad=0.34p pd=2.68u as=0.2254p ps=1.53u w=1u l=0.5u
X4047 a_31132_67610# a_30875_67729# a_31294_67806# VSS sg13_lv_nmos ad=0.1428p pd=1.52u as=37.8f ps=0.6u w=0.42u l=0.13u
X4048 a_6563_40069# S VSS VSS sg13_lv_nmos ad=0.187p pd=1.78u as=0.18945p ps=1.27u w=0.55u l=0.13u
X4049 a_44098_6863# Y_uq1 VSS VSS sg13_lv_nmos ad=0.187p pd=1.78u as=0.14875p ps=1.16u w=0.55u l=0.13u
X4050 Y_uq68 C_uq16 VSS VSS sg13_lv_nmos ad=0.1406p pd=1.12u as=0.2516p ps=2.16u w=0.74u l=0.13u
X4051 VDD a_48922_69147# X_uq425 VDD sg13_lv_pmos ad=0.2254p pd=1.53u as=0.4256p ps=3u w=1.12u l=0.13u
X4052 VDD A_uq97 a_38622_7661# VDD sg13_lv_pmos ad=0.2114p pd=1.54u as=0.2856p ps=2.36u w=0.84u l=0.13u
X4053 a_38325_64391# a_37968_64348# VDD VDD sg13_lv_pmos ad=63f pd=0.72u as=0.1563p ps=1.22u w=0.42u l=0.13u
X4054 VDD VSS VDD VDD sg13_lv_pmos ad=0.34p pd=2.68u as=0 ps=0 w=1u l=1u
X4055 a_36528_67372# a_37047_67379# a_37787_67729# VSS sg13_lv_nmos ad=0.3473p pd=2.71u as=0.12665p ps=1.145u w=0.74u l=0.13u
X4056 C_uq45 X_uq429 VSS VSS sg13_lv_nmos ad=0.1406p pd=1.12u as=0.2516p ps=2.16u w=0.74u l=0.13u
X4057 a_29080_64782# a_28867_64308# VDD VDD sg13_lv_pmos ad=79.8f pd=0.8u as=1.4745p ps=9.07u w=0.42u l=0.13u
X4058 Y_uq324 C_uq66 VSS VSS sg13_lv_nmos ad=0.2618p pd=2.22u as=0.1463p ps=1.15u w=0.77u l=0.13u
X4059 a_79910_27102# a_79068_26752# a_78651_26745# VDD sg13_lv_pmos ad=0.2048p pd=1.63u as=0.34p ps=2.68u w=1u l=0.13u
X4060 VDD Y_uq76 a_12593_20899# VDD sg13_lv_pmos ad=0.2114p pd=1.54u as=0.2856p ps=2.36u w=0.84u l=0.13u
X4061 Q_uq41 a_51702_68416# VDD VDD sg13_lv_pmos ad=0.3808p pd=2.92u as=0.2128p ps=1.5u w=1.12u l=0.13u
X4062 a_79138_21489# X_uq208 a_79044_21489# VSS sg13_lv_nmos ad=0.1216p pd=1.02u as=0.2176p ps=1.96u w=0.64u l=0.13u
X4063 VSS clk a_39755_68851# VSS sg13_lv_nmos ad=1.9335p pd=12.315u as=0.2516p ps=2.16u w=0.74u l=0.13u
X4064 a_3580_40023# a_3550_40458# a_3962_40398# VDD sg13_lv_pmos ad=79.8f pd=0.8u as=63f ps=0.72u w=0.42u l=0.13u
X4065 a_4337_41193# a_4301_41167# VDD VDD sg13_lv_pmos ad=0.34p pd=2.68u as=0.36237p ps=2.605u w=1u l=0.13u
X4066 a_44698_65283# a_44813_65284# VSS VSS sg13_lv_nmos ad=0.1428p pd=1.52u as=0.1426p ps=1.16u w=0.42u l=0.5u
X4067 Y_uq267 X_uq376 a_38776_65392# VDD sg13_lv_pmos ad=0.3808p pd=2.92u as=0.1176p ps=1.33u w=1.12u l=0.13u
X4068 VSS a_36166_65062# a_35885_65284# VSS sg13_lv_nmos ad=79.8f pd=0.8u as=0.1428p ps=1.52u w=0.42u l=0.5u
X4069 a_3571_39755# D_uq28 VDD VDD sg13_lv_pmos ad=79.8f pd=0.8u as=0.1428p ps=1.52u w=0.42u l=0.13u
X4070 SLN[7] a_30100_63620# VSS VSS sg13_lv_nmos ad=0.2886p pd=2.26u as=0.14875p ps=1.16u w=0.74u l=0.13u
X4071 a_38338_7625# q[12] VSS VSS sg13_lv_nmos ad=0.187p pd=1.78u as=0.14875p ps=1.16u w=0.55u l=0.13u
X4072 a_3580_33241# a_3546_31883# a_3571_33467# VDD sg13_lv_pmos ad=79.8f pd=0.8u as=0.1428p ps=1.52u w=0.42u l=0.13u
X4073 VSS Q_uq32 Y_uq290 VSS sg13_lv_nmos ad=0.2516p pd=2.16u as=0.2516p ps=2.16u w=0.74u l=0.13u
X4074 a_33542_10661# B_uq31 VSS VSS sg13_lv_nmos ad=0.1045p pd=0.93u as=0.187p ps=1.78u w=0.55u l=0.13u
X4075 VSS din[23] a_75295_19969# VSS sg13_lv_nmos ad=0.14875p pd=1.16u as=0.187p ps=1.78u w=0.55u l=0.13u
X4076 VDD Q_uq42 Y_uq331 VDD sg13_lv_pmos ad=0.3808p pd=2.92u as=0.3808p ps=2.92u w=1.12u l=0.13u
X4077 VDD X_uq433 a_36730_64400# VDD sg13_lv_pmos ad=0.2618p pd=1.63u as=0.2856p ps=2.36u w=0.84u l=0.13u
X4078 a_46418_66610# a_46148_66610# VDD VDD sg13_lv_pmos ad=0.34p pd=2.68u as=0.1523p ps=1.38u w=1u l=0.5u
X4079 VDD a_46690_9137# X_uq95 VDD sg13_lv_pmos ad=0.2114p pd=1.54u as=0.42p ps=2.99u w=1.12u l=0.13u
X4080 Y_uq188 Y_uq190 VSS VSS sg13_lv_nmos ad=0.1406p pd=1.12u as=0.2516p ps=2.16u w=0.74u l=0.13u
X4081 VSS Y_uq234 a_8107_40905# VSS sg13_lv_nmos ad=0.1626p pd=1.415u as=60.89999f ps=0.71u w=0.42u l=0.13u
X4082 VSS a_35398_69598# a_35117_69820# VSS sg13_lv_nmos ad=79.8f pd=0.8u as=0.1428p ps=1.52u w=0.42u l=0.5u
X4083 X_uq21 a_38238_6937# VDD VDD sg13_lv_pmos ad=0.42p pd=2.99u as=0.2114p ps=1.54u w=1.12u l=0.13u
X4084 a_5821_37924# Y_uq206 B_uq84 VDD sg13_lv_pmos ad=0.2744p pd=1.61u as=0.2128p ps=1.5u w=1.12u l=0.13u
X4085 a_6893_34850# C_uq33 Y_uq180 VDD sg13_lv_pmos ad=0.2128p pd=1.5u as=0.3808p ps=2.92u w=1.12u l=0.13u
X4086 VSS a_3535_42833# X_uq326 VSS sg13_lv_nmos ad=0.14875p pd=1.16u as=0.2886p ps=2.26u w=0.74u l=0.13u
X4087 VSS VDD VSS VSS sg13_lv_nmos ad=0.1428p pd=1.52u as=0 ps=-0 w=0.42u l=1u
X4088 a_3546_31883# a_3550_32372# VDD VDD sg13_lv_pmos ad=0.3864p pd=2.93u as=1.31615p ps=8.395u w=1.12u l=0.13u
X4089 a_9583_41879# a_9583_42043# a_9619_42007# VSS sg13_lv_nmos ad=0.1428p pd=1.52u as=37.8f ps=0.6u w=0.42u l=0.13u
X4090 a_48369_68161# a_48369_68161# VSS VSS sg13_lv_nmos ad=0.111p pd=1.34u as=2.08687p ps=13.23u w=0.3u l=0.13u
X4091 X_uq188 a_76831_18457# VSS VSS sg13_lv_nmos ad=0.2886p pd=2.26u as=0.14875p ps=1.16u w=0.74u l=0.13u
X4092 VDD X_uq137 a_44964_9149# VDD sg13_lv_pmos ad=0.2226p pd=1.535u as=0.1596p ps=1.22u w=0.84u l=0.13u
X4093 Y_uq263 C_uq44 a_41475_64344# VDD sg13_lv_pmos ad=0.3808p pd=2.92u as=0.2128p ps=1.5u w=1.12u l=0.13u
X4094 a_39408_67806# D_uq54 a_39314_67806# VSS sg13_lv_nmos ad=60.89999f pd=0.71u as=0.1428p ps=1.52u w=0.42u l=0.13u
X4095 Y_uq232 X_uq323 VDD VDD sg13_lv_pmos ad=0.3808p pd=2.92u as=0.3808p ps=2.92u w=1.12u l=0.13u
X4096 a_9628_33337# a_9594_31979# a_9619_33563# VDD sg13_lv_pmos ad=79.8f pd=0.8u as=0.1428p ps=1.52u w=0.42u l=0.13u
X4097 a_36440_64308# Q_uq55 VSS VSS sg13_lv_nmos ad=0.187p pd=1.78u as=0.14875p ps=1.16u w=0.55u l=0.13u
X4098 a_43344_65860# a_43318_65824# VSS VSS sg13_lv_nmos ad=0.2516p pd=2.16u as=0.1626p ps=1.415u w=0.74u l=0.13u
X4099 Y_uq319 C_uq63 VSS VSS sg13_lv_nmos ad=0.2618p pd=2.22u as=0.1463p ps=1.15u w=0.77u l=0.13u
X4100 a_10239_20869# B_uq63 a_10137_20869# VSS sg13_lv_nmos ad=0.1406p pd=1.12u as=0.1406p ps=1.12u w=0.74u l=0.13u
X4101 VDD a_33730_7625# X_uq123 VDD sg13_lv_pmos ad=0.2114p pd=1.54u as=0.42p ps=2.99u w=1.12u l=0.13u
X4102 VDD X_uq319 Y_uq169 VDD sg13_lv_pmos ad=0.3808p pd=2.92u as=0.3808p ps=2.92u w=1.12u l=0.13u
X4103 VDD a_41794_6863# X_uq12 VDD sg13_lv_pmos ad=0.2114p pd=1.54u as=0.42p ps=2.99u w=1.12u l=0.13u
X4104 VDD VSS VDD VDD sg13_lv_pmos ad=0.34p pd=2.68u as=0 ps=0 w=1u l=1u
X4105 VDD a_36070_66574# a_35789_66796# VDD sg13_lv_pmos ad=0.1523p pd=1.38u as=0.34p ps=2.68u w=1u l=0.5u
X4106 VSS X_uq319 Y_uq194 VSS sg13_lv_nmos ad=0.2516p pd=2.16u as=0.2516p ps=2.16u w=0.74u l=0.13u
X4107 a_78702_26277# B_uq68 a_78588_26277# VDD sg13_lv_pmos ad=0.2128p pd=1.5u as=0.2464p ps=1.56u w=1.12u l=0.13u
X4108 a_8086_41514# clk VSS VSS sg13_lv_nmos ad=0.2516p pd=2.16u as=5.69177p ps=37.635u w=0.74u l=0.13u
X4109 VDD a_41602_8375# X_uq62 VDD sg13_lv_pmos ad=0.2114p pd=1.54u as=0.42p ps=2.99u w=1.12u l=0.13u
X4110 VDD L_HI_uq26 a_45976_67806# VDD sg13_lv_pmos ad=1.19383p pd=7.16u as=79.8f ps=0.8u w=0.42u l=0.13u
X4111 a_9619_40137# D_uq26 a_9619_40043# VSS sg13_lv_nmos ad=60.89999f pd=0.71u as=0.1428p ps=1.52u w=0.42u l=0.13u
X4112 D_uq46 C_uq56 VSS VSS sg13_lv_nmos ad=0.2618p pd=2.22u as=0.1463p ps=1.15u w=0.77u l=0.13u
X4113 VSS X_uq137 a_45350_9149# VSS sg13_lv_nmos ad=0.1469p pd=1.155u as=0.1045p ps=0.93u w=0.55u l=0.13u
X4114 a_41714_64782# a_42519_64355# a_41974_64312# VDD sg13_lv_pmos ad=0.1428p pd=1.52u as=79.8f ps=0.8u w=0.42u l=0.13u
X4115 Y_uq228 X_uq323 VDD VDD sg13_lv_pmos ad=0.3808p pd=2.92u as=0.3808p ps=2.92u w=1.12u l=0.13u
X4116 a_42779_69707# a_41937_69609# a_42685_69707# VSS sg13_lv_nmos ad=0.12665p pd=1.145u as=0.1428p ps=1.52u w=0.42u l=0.13u
X4117 C1 C_uq23 VSS VSS sg13_lv_nmos ad=0.2618p pd=2.22u as=0.1463p ps=1.15u w=0.77u l=0.13u
X4118 a_5096_35145# a_5058_36197# a_5092_34839# VSS sg13_lv_nmos ad=0.2373p pd=1.97u as=79.8f ps=0.8u w=0.42u l=0.13u
X4119 VDD a_79910_27102# a_80167_26983# VDD sg13_lv_pmos ad=2.04445p pd=13.405u as=79.8f ps=0.8u w=0.42u l=0.13u
X4120 VDD a_34246_65062# a_33965_65284# VDD sg13_lv_pmos ad=0.1523p pd=1.38u as=0.34p ps=2.68u w=1u l=0.5u
X4121 D_uq41 a_28866_65162# VDD VDD sg13_lv_pmos ad=0.4256p pd=3u as=0.2254p ps=1.53u w=1.12u l=0.13u
X4122 a_29301_65903# a_28944_65860# VDD VDD sg13_lv_pmos ad=63f pd=0.72u as=0.1563p ps=1.22u w=0.42u l=0.13u
X4123 D_uq61 C_uq69 a_42051_68880# VDD sg13_lv_pmos ad=0.3808p pd=2.92u as=0.2128p ps=1.5u w=1.12u l=0.13u
X4124 B_uq29 a_33150_10685# VDD VDD sg13_lv_pmos ad=0.42p pd=2.99u as=0.2114p ps=1.54u w=1.12u l=0.13u
X4125 Y_uq21 a_39972_9965# VSS VSS sg13_lv_nmos ad=0.1406p pd=1.12u as=0.17255p ps=1.25u w=0.74u l=0.13u
X4126 a_76171_27789# Y_uq146 VDD VDD sg13_lv_pmos ad=0.2128p pd=1.5u as=0.3808p ps=2.92u w=1.12u l=0.13u
X4127 VSS Y_uq23 a_37854_7661# VSS sg13_lv_nmos ad=0.14875p pd=1.16u as=0.187p ps=1.78u w=0.55u l=0.13u
X4128 a_41116_67610# L_HI_uq28 VDD VDD sg13_lv_pmos ad=79.8f pd=0.8u as=1.19383p ps=7.16u w=0.42u l=0.13u
X4129 X_uq55 a_33246_7661# VDD VDD sg13_lv_pmos ad=0.42p pd=2.99u as=0.2114p ps=1.54u w=1.12u l=0.13u
X4130 a_29590_67336# a_30033_67379# a_29973_67415# VDD sg13_lv_pmos ad=79.8f pd=0.8u as=63f ps=0.72u w=0.42u l=0.13u
X4131 a_5514_21557# D VDD VDD sg13_lv_pmos ad=79.8f pd=0.8u as=0.1428p ps=1.52u w=0.42u l=0.13u
X4132 a_4557_21457# a_4681_21156# VDD VDD sg13_lv_pmos ad=0.2442p pd=2.06u as=1.37097p ps=8.54u w=0.66u l=0.13u
X4133 VSS a_46402_6863# X VSS sg13_lv_nmos ad=0.14875p pd=1.16u as=0.2886p ps=2.26u w=0.74u l=0.13u
X4134 VDD Q_uq29 Y_uq268 VDD sg13_lv_pmos ad=0.3808p pd=2.92u as=0.3808p ps=2.92u w=1.12u l=0.13u
X4135 VDD a_7321_32575# a_7345_32295# VDD sg13_lv_pmos ad=0.1523p pd=1.38u as=0.34p ps=2.68u w=1u l=0.5u
X4136 VSS L_HI_uq21 a_30626_64769# VSS sg13_lv_nmos ad=0.1701p pd=1.65u as=37.8f ps=0.6u w=0.42u l=0.13u
X4137 VSS a_30107_69707# a_30774_69928# VSS sg13_lv_nmos ad=0.1406p pd=1.12u as=0.2516p ps=2.16u w=0.74u l=0.13u
X4138 a_4771_41001# D_uq33 a_4380_41738# VSS sg13_lv_nmos ad=60.89999f pd=0.71u as=0.1428p ps=1.52u w=0.42u l=0.13u
X4139 a_32216_68082# Q_uq59 VSS VSS sg13_lv_nmos ad=0.187p pd=1.78u as=0.14875p ps=1.16u w=0.55u l=0.13u
X4140 a_44774_10301# B_uq7 VSS VSS sg13_lv_nmos ad=0.1045p pd=0.93u as=0.187p ps=1.78u w=0.55u l=0.13u
X4141 a_5845_32207# Y_uq159 VDD VDD sg13_lv_pmos ad=0.1176p pd=1.33u as=0.4032p ps=2.96u w=1.12u l=0.13u
X4142 Y_uq8 X_uq137 VSS VSS sg13_lv_nmos ad=0.1406p pd=1.12u as=0.2516p ps=2.16u w=0.74u l=0.13u
X4143 X_uq248 a_9233_25435# VSS VSS sg13_lv_nmos ad=0.2886p pd=2.26u as=0.14875p ps=1.16u w=0.74u l=0.13u
X4144 VSS S Y_uq207 VSS sg13_lv_nmos ad=0.2516p pd=2.16u as=0.2516p ps=2.16u w=0.74u l=0.13u
X4145 VDD a_44219_67729# a_44886_67368# VDD sg13_lv_pmos ad=0.2128p pd=1.5u as=0.3864p ps=2.93u w=1.12u l=0.13u
X4146 a_77042_22205# B_uq67 VDD VDD sg13_lv_pmos ad=0.3808p pd=2.92u as=0.2128p ps=1.5u w=1.12u l=0.13u
X4147 B2_uq6 X_uq241 VDD VDD sg13_lv_pmos ad=0.3808p pd=2.92u as=0.3808p ps=2.92u w=1.12u l=0.13u
X4148 VSS L_HI_uq8 a_80333_28678# VSS sg13_lv_nmos ad=0.1701p pd=1.65u as=37.8f ps=0.6u w=0.42u l=0.13u
X4149 a_10385_35049# a_10383_35831# a_10345_37044# VSS sg13_lv_nmos ad=0.3473p pd=2.71u as=0.12665p ps=1.145u w=0.74u l=0.13u
X4150 VDD a_33873_64355# a_33975_64355# VDD sg13_lv_pmos ad=1.4745p pd=9.07u as=0.3864p ps=2.93u w=1.12u l=0.13u
X4151 a_3546_31883# a_3550_32372# VSS VSS sg13_lv_nmos ad=0.2516p pd=2.16u as=5.43125p ps=35.255u w=0.74u l=0.13u
X4152 a_27928_64344# a_27706_64400# VDD VDD sg13_lv_pmos ad=0.1176p pd=1.33u as=0.2618p ps=1.63u w=1.12u l=0.13u
X4153 a_38470_68844# Q_uq55 VSS VSS sg13_lv_nmos ad=0.1428p pd=1.52u as=79.8f ps=0.8u w=0.42u l=0.13u
X4154 a_10345_37457# Y_uq192 VDD VDD sg13_lv_pmos ad=0.2856p pd=2.36u as=0.2114p ps=1.54u w=0.84u l=0.13u
X4155 VSS Y_uq206 a_5079_37303# VSS sg13_lv_nmos ad=0.1406p pd=1.12u as=0.1406p ps=1.12u w=0.74u l=0.15u
X4156 VDD a_29734_68086# a_29453_68308# VDD sg13_lv_pmos ad=0.1523p pd=1.38u as=0.34p ps=2.68u w=1u l=0.5u
X4157 a_42674_67806# a_43479_67379# a_42934_67336# VDD sg13_lv_pmos ad=0.1428p pd=1.52u as=79.8f ps=0.8u w=0.42u l=0.13u
X4158 a_30405_65979# a_29463_65867# a_30203_66217# VDD sg13_lv_pmos ad=93.45f pd=0.865u as=0.2048p ps=1.63u w=0.42u l=0.13u
X4159 VSS X_uq452 a_42292_68880# VSS sg13_lv_nmos ad=0.14875p pd=1.16u as=0.187p ps=1.78u w=0.55u l=0.13u
X4160 VDD X_uq206 Y_uq71 VDD sg13_lv_pmos ad=0.3808p pd=2.92u as=0.3808p ps=2.92u w=1.12u l=0.13u
X4161 a_41410_7625# A_uq95 VSS VSS sg13_lv_nmos ad=0.187p pd=1.78u as=0.14875p ps=1.16u w=0.55u l=0.13u
X4162 VSS a_32024_67332# q[3] VSS sg13_lv_nmos ad=0.14875p pd=1.16u as=0.2886p ps=2.26u w=0.74u l=0.13u
X4163 a_4613_32906# a_4335_33143# a_4301_32335# VSS sg13_lv_nmos ad=0.2373p pd=1.97u as=79.8f ps=0.8u w=0.42u l=0.13u
X4164 a_39600_67372# a_39574_67336# VSS VSS sg13_lv_nmos ad=0.2516p pd=2.16u as=0.1626p ps=1.415u w=0.74u l=0.13u
X4165 a_6936_21837# B_uq66 VSS VSS sg13_lv_nmos ad=0.187p pd=1.78u as=0.17255p ps=1.25u w=0.55u l=0.13u
X4166 a_5845_32930# C_uq30 D_uq16 VDD sg13_lv_pmos ad=0.2128p pd=1.5u as=0.3808p ps=2.92u w=1.12u l=0.13u
X4167 a_76069_27789# C1_uq6 Y_uq144 VDD sg13_lv_pmos ad=0.2128p pd=1.5u as=0.3808p ps=2.92u w=1.12u l=0.13u
X4168 a_80197_26168# a_80312_26169# VDD VDD sg13_lv_pmos ad=0.34p pd=2.68u as=0.2254p ps=1.53u w=1u l=0.5u
X4169 VDD Q_uq58 a_27316_64344# VDD sg13_lv_pmos ad=0.2114p pd=1.54u as=0.2856p ps=2.36u w=0.84u l=0.13u
X4170 VDD a_31907_69711# a_31907_69945# VDD sg13_lv_pmos ad=1.6733p pd=10.405u as=0.2442p ps=2.06u w=0.66u l=0.13u
X4171 VSS a_46690_9137# X_uq95 VSS sg13_lv_nmos ad=0.14875p pd=1.16u as=0.2886p ps=2.26u w=0.74u l=0.13u
X4172 Y_uq73 X_uq210 VDD VDD sg13_lv_pmos ad=0.3808p pd=2.92u as=0.3808p ps=2.92u w=1.12u l=0.13u
X4173 VDD a_37454_9489# X_uq85 VDD sg13_lv_pmos ad=0.2226p pd=1.535u as=0.3976p ps=2.95u w=1.12u l=0.13u
X4174 VDD D_uq11 a_79982_28300# VDD sg13_lv_pmos ad=0.1428p pd=1.52u as=79.8f ps=0.8u w=0.42u l=0.13u
X4175 a_9609_34825# Y_uq219 a_9665_35055# VSS sg13_lv_nmos ad=0.2176p pd=1.96u as=0.1216p ps=1.02u w=0.64u l=0.13u
X4176 a_46808_69594# X_uq450 VSS VSS sg13_lv_nmos ad=0.187p pd=1.78u as=0.14875p ps=1.16u w=0.55u l=0.13u
X4177 a_7357_32934# X_uq284 VDD VDD sg13_lv_pmos ad=0.2125p pd=1.425u as=0.19p ps=1.38u w=1u l=0.13u
X4178 VSS a_41218_8375# X_uq63 VSS sg13_lv_nmos ad=0.14875p pd=1.16u as=0.2886p ps=2.26u w=0.74u l=0.13u
X4179 a_78877_27166# L_HI_uq7 VSS VSS sg13_lv_nmos ad=37.8f pd=0.6u as=0.1701p ps=1.65u w=0.42u l=0.13u
X4180 a_44021_66552# a_44145_66649# VDD VDD sg13_lv_pmos ad=0.2442p pd=2.06u as=1.19383p ps=7.16u w=0.66u l=0.13u
X4181 A_uq76 a_41414_10301# VSS VSS sg13_lv_nmos ad=0.2516p pd=2.16u as=0.1469p ps=1.155u w=0.74u l=0.13u
X4182 VDD Y_uq345 a_30100_63620# VDD sg13_lv_pmos ad=0.2114p pd=1.54u as=0.2856p ps=2.36u w=0.84u l=0.13u
X4183 a_12533_18135# C_uq5 Y_uq41 VDD sg13_lv_pmos ad=0.1176p pd=1.33u as=0.3808p ps=2.92u w=1.12u l=0.13u
X4184 VDD a_45634_7625# X_uq40 VDD sg13_lv_pmos ad=0.2114p pd=1.54u as=0.42p ps=2.99u w=1.12u l=0.13u
X4185 a_46786_8375# Y_uq26 VSS VSS sg13_lv_nmos ad=0.187p pd=1.78u as=0.14875p ps=1.16u w=0.55u l=0.13u
X4186 VSS Q_uq49 Y_uq285 VSS sg13_lv_nmos ad=0.2516p pd=2.16u as=0.1406p ps=1.12u w=0.74u l=0.13u
X4187 a_47110_65062# Q_uq32 VDD VDD sg13_lv_pmos ad=0.1428p pd=1.52u as=0.1523p ps=1.38u w=0.42u l=0.13u
X4188 Q_uq16 a_5047_36954# VDD VDD sg13_lv_pmos ad=0.3808p pd=2.92u as=0.2128p ps=1.5u w=1.12u l=0.13u
X4189 a_9307_37975# Y_uq197 VSS VSS sg13_lv_nmos ad=37.8f pd=0.6u as=79.8f ps=0.8u w=0.42u l=0.13u
X4190 D_uq8 X_uq259 VSS VSS sg13_lv_nmos ad=0.1694p pd=1.21u as=0.2618p ps=2.22u w=0.77u l=0.13u
X4191 VSS A_uq98 Y_uq7 VSS sg13_lv_nmos ad=0.2516p pd=2.16u as=0.1406p ps=1.12u w=0.74u l=0.13u
X4192 VDD a_51899_67729# a_52566_67368# VDD sg13_lv_pmos ad=0.2128p pd=1.5u as=0.3864p ps=2.93u w=1.12u l=0.13u
X4193 X_uq211 a_75295_22205# VSS VSS sg13_lv_nmos ad=0.2886p pd=2.26u as=0.14875p ps=1.16u w=0.74u l=0.13u
X4194 a_76266_25577# B1_uq7 VSS VSS sg13_lv_nmos ad=0.1406p pd=1.12u as=0.2516p ps=2.16u w=0.74u l=0.13u
X4195 a_8992_42462# a_8871_41783# a_8833_42996# VDD sg13_lv_pmos ad=93.45f pd=0.865u as=0.2048p ps=1.63u w=0.42u l=0.13u
X4196 a_44784_69305# a_44496_68884# a_44722_69305# VSS sg13_lv_nmos ad=0.1428p pd=1.52u as=37.8f ps=0.6u w=0.42u l=0.13u
X4197 a_41494_69853# a_41937_69609# a_41234_69630# VSS sg13_lv_nmos ad=79.8f pd=0.8u as=0.1296p ps=1.52u w=0.42u l=0.13u
X4198 Y_uq13 X_uq162 a_37122_9173# VDD sg13_lv_pmos ad=0.3808p pd=2.92u as=0.1176p ps=1.33u w=1.12u l=0.13u
X4199 VSS a_78941_22959# a_79053_23023# VSS sg13_lv_nmos ad=0.1426p pd=1.16u as=0.1428p ps=1.52u w=0.42u l=0.5u
X4200 Y_uq258 C_uq73 a_48771_64344# VDD sg13_lv_pmos ad=0.3808p pd=2.92u as=0.2128p ps=1.5u w=1.12u l=0.13u
X4201 X_uq247 a_9617_25435# VDD VDD sg13_lv_pmos ad=0.42p pd=2.99u as=0.2114p ps=1.54u w=1.12u l=0.13u
X4202 VSS Y_uq210 a_9619_37545# VSS sg13_lv_nmos ad=0.1626p pd=1.415u as=60.89999f ps=0.71u w=0.42u l=0.13u
X4203 a_50354_67806# a_51159_67379# a_50614_67336# VDD sg13_lv_pmos ad=0.1428p pd=1.52u as=79.8f ps=0.8u w=0.42u l=0.13u
X4204 VSS L_HI_uq18 a_51458_66619# VSS sg13_lv_nmos ad=0.1701p pd=1.65u as=37.8f ps=0.6u w=0.42u l=0.13u
X4205 VSS a_5833_35135# a_5809_35317# VSS sg13_lv_nmos ad=0.1426p pd=1.16u as=0.1428p ps=1.52u w=0.42u l=0.5u
X4206 a_78115_22205# B_uq38 Y_uq74 VDD sg13_lv_pmos ad=0.1176p pd=1.33u as=0.3808p ps=2.92u w=1.12u l=0.13u
X4207 VDD Y_uq163 a_8116_31287# VDD sg13_lv_pmos ad=0.1563p pd=1.22u as=0.147p ps=1.54u w=0.42u l=0.13u
X4208 C_uq66 X_uq401 a_36566_66904# VDD sg13_lv_pmos ad=0.3808p pd=2.92u as=0.1176p ps=1.33u w=1.12u l=0.13u
X4209 VSS a_37499_69707# a_38166_69928# VSS sg13_lv_nmos ad=0.1406p pd=1.12u as=0.2516p ps=2.16u w=0.74u l=0.13u
X4210 VSS a_7321_34574# B_uq74 VSS sg13_lv_nmos ad=0.1331p pd=1.12u as=0.2516p ps=2.16u w=0.74u l=0.13u
X4211 VDD din[20] a_75679_22205# VDD sg13_lv_pmos ad=0.2114p pd=1.54u as=0.2856p ps=2.36u w=0.84u l=0.13u
X4212 a_76957_28601# Y_uq155 A2_uq6 VSS sg13_lv_nmos ad=0.1406p pd=1.12u as=0.2516p ps=2.16u w=0.74u l=0.13u
X4213 VDD L_HI_uq29 a_36502_67336# VDD sg13_lv_pmos ad=0.1563p pd=1.22u as=0.147p ps=1.54u w=0.42u l=0.13u
X4214 VSS Y_uq258 a_48644_65098# VSS sg13_lv_nmos ad=79.8f pd=0.8u as=0.1428p ps=1.52u w=0.42u l=0.13u
X4215 a_34338_10685# a_34116_10741# VDD VDD sg13_lv_pmos ad=0.1176p pd=1.33u as=0.2618p ps=1.63u w=1.12u l=0.13u
X4216 VDD a_6585_34382# B_uq79 VDD sg13_lv_pmos ad=0.1918p pd=1.5u as=0.3808p ps=2.92u w=1.12u l=0.13u
X4217 a_33456_64348# a_33430_64312# VSS VSS sg13_lv_nmos ad=0.2516p pd=2.16u as=0.1626p ps=1.415u w=0.74u l=0.13u
X4218 a_10103_25775# B_uq63 a_10009_25775# VDD sg13_lv_pmos ad=0.1596p pd=1.22u as=0.2856p ps=2.36u w=0.84u l=0.13u
X4219 a_6574_31914# clk VSS VSS sg13_lv_nmos ad=0.2516p pd=2.16u as=4.5562p ps=29.965u w=0.74u l=0.13u
X4220 VSS Q_uq42 Y_uq331 VSS sg13_lv_nmos ad=0.2516p pd=2.16u as=0.2516p ps=2.16u w=0.74u l=0.13u
X4221 VDD a_41330_65098# a_41442_65162# VDD sg13_lv_pmos ad=0.2254p pd=1.53u as=0.34p ps=2.68u w=1u l=0.5u
X4222 VSS a_33851_69707# a_34518_69928# VSS sg13_lv_nmos ad=0.1406p pd=1.12u as=0.2516p ps=2.16u w=0.74u l=0.13u
X4223 a_35134_64782# L_HI_uq12 VSS VSS sg13_lv_nmos ad=37.8f pd=0.6u as=79.8f ps=0.8u w=0.42u l=0.13u
X4224 a_51986_65856# a_51716_65897# VSS VSS sg13_lv_nmos ad=0.1428p pd=1.52u as=79.8f ps=0.8u w=0.42u l=0.5u
X4225 a_6026_21544# L_HI_uq2 VSS VSS sg13_lv_nmos ad=37.8f pd=0.6u as=0.1701p ps=1.65u w=0.42u l=0.13u
X4226 VSS X_uq427 C_uq63 VSS sg13_lv_nmos ad=0.2516p pd=2.16u as=0.1406p ps=1.12u w=0.74u l=0.13u
X4227 VDD Y_uq240 a_28868_63586# VDD sg13_lv_pmos ad=0.1523p pd=1.38u as=0.1428p ps=1.52u w=0.42u l=0.13u
X4228 a_78574_20657# a_79134_20780# a_79155_21054# VSS sg13_lv_nmos ad=0.12665p pd=1.145u as=0.3473p ps=2.71u w=0.74u l=0.13u
X4229 a_11957_18599# C_uq1 Y_uq33 VDD sg13_lv_pmos ad=0.1176p pd=1.33u as=0.3808p ps=2.92u w=1.12u l=0.13u
X4230 VSS a_31544_66570# A_uq6 VSS sg13_lv_nmos ad=0.14875p pd=1.16u as=0.2886p ps=2.26u w=0.74u l=0.13u
X4231 a_44326_69598# Q_uq54 VSS VSS sg13_lv_nmos ad=0.1428p pd=1.52u as=79.8f ps=0.8u w=0.42u l=0.13u
X4232 D_uq62 a_39234_69698# VDD VDD sg13_lv_pmos ad=0.4256p pd=3u as=0.2254p ps=1.53u w=1.12u l=0.13u
X4233 VSS a_45418_10649# Y_uq27 VSS sg13_lv_nmos ad=0.17255p pd=1.25u as=0.1406p ps=1.12u w=0.74u l=0.13u
X4234 VSS a_3575_39179# a_3539_39543# VSS sg13_lv_nmos ad=0.1426p pd=1.16u as=0.1428p ps=1.52u w=0.42u l=0.5u
X4235 VSS a_46018_7625# X_uq39 VSS sg13_lv_nmos ad=0.14875p pd=1.16u as=0.2886p ps=2.26u w=0.74u l=0.13u
X4236 VSS C_uq46 Y_uq269 VSS sg13_lv_nmos ad=0.1463p pd=1.15u as=0.2618p ps=2.22u w=0.77u l=0.13u
X4237 a_10010_40686# a_9583_41709# VDD VDD sg13_lv_pmos ad=63f pd=0.72u as=0.1563p ps=1.22u w=0.42u l=0.13u
X4238 a_35217_65867# clk VDD VDD sg13_lv_pmos ad=0.4088p pd=2.97u as=1.37835p ps=8.63u w=1.12u l=0.13u
X4239 a_49664_64308# X_uq446 VSS VSS sg13_lv_nmos ad=0.187p pd=1.78u as=0.17255p ps=1.25u w=0.55u l=0.13u
X4240 VSS a_9583_42043# a_9583_42426# VSS sg13_lv_nmos ad=0.1406p pd=1.12u as=0.2516p ps=2.16u w=0.74u l=0.13u
X4241 VDD reset a_3535_34367# VDD sg13_lv_pmos ad=0.2114p pd=1.54u as=0.2856p ps=2.36u w=0.84u l=0.13u
X4242 D_uq40 a_33282_65162# VSS VSS sg13_lv_nmos ad=0.2516p pd=2.16u as=0.1426p ps=1.16u w=0.74u l=0.13u
X4243 a_30622_66294# L_HI_uq22 VSS VSS sg13_lv_nmos ad=37.8f pd=0.6u as=79.8f ps=0.8u w=0.42u l=0.13u
X4244 a_8873_36297# a_8871_37079# a_8833_38292# VSS sg13_lv_nmos ad=0.3473p pd=2.71u as=0.12665p ps=1.145u w=0.74u l=0.13u
X4245 a_5051_33721# a_5087_34043# VDD VDD sg13_lv_pmos ad=0.34p pd=2.68u as=0.2254p ps=1.53u w=1u l=0.5u
X4246 a_10785_20477# B_uq63 a_10683_20477# VSS sg13_lv_nmos ad=0.1406p pd=1.12u as=0.1406p ps=1.12u w=0.74u l=0.13u
X4247 a_3580_40023# a_3550_40458# a_3571_39755# VSS sg13_lv_nmos ad=79.8f pd=0.8u as=0.1296p ps=1.52u w=0.42u l=0.13u
X4248 VDD Y_uq174 a_4380_32906# VDD sg13_lv_pmos ad=0.36237p pd=2.605u as=79.8f ps=0.8u w=0.42u l=0.13u
X4249 a_30202_68307# a_30317_68308# VDD VDD sg13_lv_pmos ad=0.34p pd=2.68u as=0.2254p ps=1.53u w=1u l=0.5u
X4250 a_5208_21083# B_uq66 VSS VSS sg13_lv_nmos ad=0.187p pd=1.78u as=0.17255p ps=1.25u w=0.55u l=0.13u
X4251 a_36610_7625# q[8] VDD VDD sg13_lv_pmos ad=0.2856p pd=2.36u as=0.2114p ps=1.54u w=0.84u l=0.13u
X4252 a_30982_63550# Q_uq48 VDD VDD sg13_lv_pmos ad=0.1428p pd=1.52u as=0.1523p ps=1.38u w=0.42u l=0.13u
X4253 VSS a_8075_39007# a_8111_38939# VSS sg13_lv_nmos ad=79.8f pd=0.8u as=0.1428p ps=1.52u w=0.42u l=0.5u
X4254 a_3580_33241# a_3546_31883# a_3584_32893# VSS sg13_lv_nmos ad=79.8f pd=0.8u as=0.2373p ps=1.97u w=0.42u l=0.13u
X4255 a_7357_35155# C1_uq8 Y_uq181 VDD sg13_lv_pmos ad=0.2128p pd=1.5u as=0.3808p ps=2.92u w=1.12u l=0.13u
X4256 a_36738_8709# a_36516_8453# VDD VDD sg13_lv_pmos ad=0.1176p pd=1.33u as=0.2618p ps=1.63u w=1.12u l=0.13u
X4257 VSS a_35110_65062# a_34829_65284# VSS sg13_lv_nmos ad=79.8f pd=0.8u as=0.1428p ps=1.52u w=0.42u l=0.5u
X4258 a_44074_8379# X_uq59 VSS VSS sg13_lv_nmos ad=0.187p pd=1.78u as=0.17255p ps=1.25u w=0.55u l=0.13u
X4259 a_6559_33047# Y_uq169 VDD VDD sg13_lv_pmos ad=79.8f pd=0.8u as=2.4956p ps=16.32u w=0.42u l=0.13u
X4260 a_45688_65392# a_45466_65136# VDD VDD sg13_lv_pmos ad=0.1176p pd=1.33u as=0.2618p ps=1.63u w=1.12u l=0.13u
X4261 VDD VSS VDD VDD sg13_lv_pmos ad=0.19p pd=1.38u as=0 ps=0 w=1u l=1u
X4262 VSS C1_uq7 A2_uq6 VSS sg13_lv_nmos ad=0.1406p pd=1.12u as=0.2516p ps=2.16u w=0.74u l=0.13u
X4263 X_uq429 a_37972_68156# VSS VSS sg13_lv_nmos ad=0.2886p pd=2.26u as=0.14875p ps=1.16u w=0.74u l=0.13u
X4264 Y_uq208 B_uq88 VDD VDD sg13_lv_pmos ad=0.2128p pd=1.5u as=0.3808p ps=2.92u w=1.12u l=0.13u
X4265 a_7292_38117# A0 VDD VDD sg13_lv_pmos ad=0.2856p pd=2.36u as=0.1596p ps=1.22u w=0.84u l=0.13u
X4266 VDD X_uq447 a_47092_69668# VDD sg13_lv_pmos ad=0.2114p pd=1.54u as=0.2856p ps=2.36u w=0.84u l=0.13u
X4267 VSS a_51608_68844# q[30] VSS sg13_lv_nmos ad=0.14875p pd=1.16u as=0.2886p ps=2.26u w=0.74u l=0.13u
X4268 VSS Y_uq110 a_11057_24647# VSS sg13_lv_nmos ad=0.14875p pd=1.16u as=0.187p ps=1.78u w=0.55u l=0.13u
X4269 a_10428_33120# a_10347_32660# a_10349_33537# VDD sg13_lv_pmos ad=63f pd=0.72u as=79.8f ps=0.8u w=0.42u l=0.13u
X4270 a_76747_23253# Y_uq82 a_76645_23253# VDD sg13_lv_pmos ad=0.2128p pd=1.5u as=0.2128p ps=1.5u w=1.12u l=0.13u
X4271 a_76268_20229# Y_uq48 VDD VDD sg13_lv_pmos ad=0.2128p pd=1.5u as=0.2128p ps=1.5u w=1.12u l=0.13u
X4272 VDD a_37809_65867# a_37911_65867# VDD sg13_lv_pmos ad=1.41367p pd=8.85u as=0.3864p ps=2.93u w=1.12u l=0.13u
X4273 VSS a_33009_69609# a_33111_69752# VSS sg13_lv_nmos ad=2.01085p pd=12.81u as=0.2516p ps=2.16u w=0.74u l=0.13u
X4274 VDD X_uq251 a_75962_24765# VDD sg13_lv_pmos ad=0.3808p pd=2.92u as=0.2464p ps=1.56u w=1.12u l=0.13u
X4275 VSS Q_uq58 a_27316_64344# VSS sg13_lv_nmos ad=0.14875p pd=1.16u as=0.187p ps=1.78u w=0.55u l=0.13u
X4276 VSS VDD VSS VSS sg13_lv_nmos ad=0.1428p pd=1.52u as=0 ps=-0 w=0.42u l=1u
X4277 C_uq4 a_10727_20907# a_11053_20869# VSS sg13_lv_nmos ad=0.3404p pd=2.4u as=0.1406p ps=1.12u w=0.74u l=0.13u
X4278 VSS a_47674_65283# X_uq372 VSS sg13_lv_nmos ad=0.1426p pd=1.16u as=0.2516p ps=2.16u w=0.74u l=0.13u
X4279 Y_uq70 D_uq1 a_12160_21159# VDD sg13_lv_pmos ad=0.3808p pd=2.92u as=0.2128p ps=1.5u w=1.12u l=0.13u
X4280 a_44388_10301# B_uq8 a_44294_10301# VDD sg13_lv_pmos ad=0.1596p pd=1.22u as=0.2856p ps=2.36u w=0.84u l=0.13u
X4281 VSS Y_uq89 a_12593_21623# VSS sg13_lv_nmos ad=0.14875p pd=1.16u as=0.187p ps=1.78u w=0.55u l=0.13u
X4282 VSS L_HI_uq9 a_46358_64782# VSS sg13_lv_nmos ad=79.8f pd=0.8u as=37.8f ps=0.6u w=0.42u l=0.13u
X4283 D_uq61 X_uq447 VSS VSS sg13_lv_nmos ad=0.1694p pd=1.21u as=0.2618p ps=2.22u w=0.77u l=0.13u
X4284 VDD X_uq239 a_9329_24647# VDD sg13_lv_pmos ad=0.2114p pd=1.54u as=0.2856p ps=2.36u w=0.84u l=0.13u
X4285 a_3571_33467# D_uq18 a_3571_33383# VSS sg13_lv_nmos ad=0.1428p pd=1.52u as=60.89999f ps=0.71u w=0.42u l=0.13u
X4286 Y_uq334 Q_uq54 a_43960_68880# VDD sg13_lv_pmos ad=0.3808p pd=2.92u as=0.1176p ps=1.33u w=1.12u l=0.13u
X4287 Q_uq38 a_38454_67368# VSS VSS sg13_lv_nmos ad=0.2516p pd=2.16u as=0.1406p ps=1.12u w=0.74u l=0.13u
X4288 a_45777_66904# X_uq445 VDD VDD sg13_lv_pmos ad=0.2464p pd=1.56u as=0.3808p ps=2.92u w=1.12u l=0.13u
X4289 Y_uq219 Y_uq229 VSS VSS sg13_lv_nmos ad=0.1406p pd=1.12u as=0.2516p ps=2.16u w=0.74u l=0.13u
X4290 VDD a_46402_8375# X_uq135 VDD sg13_lv_pmos ad=0.2114p pd=1.54u as=0.42p ps=2.99u w=1.12u l=0.13u
X4291 VSS A_uq82 a_38622_6937# VSS sg13_lv_nmos ad=0.14875p pd=1.16u as=0.187p ps=1.78u w=0.55u l=0.13u
X4292 VSS D_uq30 a_9217_34835# VSS sg13_lv_nmos ad=0.2176p pd=1.96u as=81.6f ps=0.895u w=0.64u l=0.13u
X4293 a_43318_65824# a_43761_65867# a_43058_66294# VSS sg13_lv_nmos ad=79.8f pd=0.8u as=0.1296p ps=1.52u w=0.42u l=0.13u
X4294 VDD a_40258_8375# A_uq87 VDD sg13_lv_pmos ad=0.2114p pd=1.54u as=0.42p ps=2.99u w=1.12u l=0.13u
X4295 a_29616_67372# a_29590_67336# VDD VDD sg13_lv_pmos ad=0.34p pd=2.68u as=0.36237p ps=2.605u w=1u l=0.13u
X4296 a_79982_22252# a_79286_22176# a_80076_22252# VSS sg13_lv_nmos ad=0.1296p pd=1.52u as=79.8f ps=0.8u w=0.42u l=0.13u
X4297 a_10078_21061# A_N VDD VDD sg13_lv_pmos ad=0.2856p pd=2.36u as=0.2198p ps=1.53u w=0.84u l=0.13u
X4298 a_6026_23394# L_HI_uq3 VSS VSS sg13_lv_nmos ad=37.8f pd=0.6u as=0.1701p ps=1.65u w=0.42u l=0.13u
X4299 a_30214_66574# Q_uq39 VDD VDD sg13_lv_pmos ad=0.1428p pd=1.52u as=0.1523p ps=1.38u w=0.42u l=0.13u
X4300 C_uq24 a_8561_23923# VSS VSS sg13_lv_nmos ad=0.2886p pd=2.26u as=0.14875p ps=1.16u w=0.74u l=0.13u
X4301 VDD Y_uq25 a_35934_6937# VDD sg13_lv_pmos ad=0.2114p pd=1.54u as=0.2856p ps=2.36u w=0.84u l=0.13u
X4302 a_11093_18135# C_uq5 Y_uq35 VDD sg13_lv_pmos ad=0.1176p pd=1.33u as=0.3808p ps=2.92u w=1.12u l=0.13u
X4303 VSS a_5073_40834# X_uq321 VSS sg13_lv_nmos ad=0.15745p pd=1.175u as=0.2351p ps=2.16u w=0.74u l=0.13u
X4304 VDD VSS VDD VDD sg13_lv_pmos ad=0.34p pd=2.68u as=0 ps=0 w=1u l=1u
X4305 VSS a_46690_9887# X_uq94 VSS sg13_lv_nmos ad=0.14875p pd=1.16u as=0.2886p ps=2.26u w=0.74u l=0.13u
X4306 Y_uq164 X_uq297 VSS VSS sg13_lv_nmos ad=0.2516p pd=2.16u as=0.2516p ps=2.16u w=0.74u l=0.13u
X4307 C_uq29 B_uq70 VDD VDD sg13_lv_pmos ad=0.2128p pd=1.5u as=0.2198p ps=1.53u w=1.12u l=0.13u
X4308 a_6608_31785# a_6559_32877# a_6608_31723# VSS sg13_lv_nmos ad=0.1428p pd=1.52u as=37.8f ps=0.6u w=0.42u l=0.13u
X4309 a_46012_69122# L_HI_uq35 VDD VDD sg13_lv_pmos ad=79.8f pd=0.8u as=1.42837p ps=8.61u w=0.42u l=0.13u
X4310 D_uq47 a_49890_65880# VSS VSS sg13_lv_nmos ad=0.2516p pd=2.16u as=0.1426p ps=1.16u w=0.74u l=0.13u
X4311 a_36994_7625# A_uq2 VSS VSS sg13_lv_nmos ad=0.187p pd=1.78u as=0.14875p ps=1.16u w=0.55u l=0.13u
X4312 VSS A0 a_7705_36806# VSS sg13_lv_nmos ad=0.2516p pd=2.16u as=0.1406p ps=1.12u w=0.74u l=0.13u
X4313 VDD VSS VDD VDD sg13_lv_pmos ad=0.34p pd=2.68u as=0 ps=0 w=1u l=1u
X4314 VSS a_5780_22089# a_5429_21946# VSS sg13_lv_nmos ad=79.8f pd=0.8u as=0.1428p ps=1.52u w=0.42u l=0.13u
X4315 VSS Q_uq1 a_7724_20395# VSS sg13_lv_nmos ad=0.14875p pd=1.16u as=0.187p ps=1.78u w=0.55u l=0.13u
X4316 a_42274_10649# q[20] VSS VSS sg13_lv_nmos ad=0.187p pd=1.78u as=0.14875p ps=1.16u w=0.55u l=0.13u
X4317 a_51201_66764# L_HI_uq18 VDD VDD sg13_lv_pmos ad=0.147p pd=1.54u as=0.1563p ps=1.22u w=0.42u l=0.13u
X4318 D_uq50 C_uq58 a_49443_67368# VDD sg13_lv_pmos ad=0.3808p pd=2.92u as=0.2128p ps=1.5u w=1.12u l=0.13u
X4319 a_8107_40905# D_uq30 a_8107_40811# VSS sg13_lv_nmos ad=60.89999f pd=0.71u as=0.1428p ps=1.52u w=0.42u l=0.13u
X4320 a_8869_39488# Y_uq211 Y_uq212 VDD sg13_lv_pmos ad=0.2128p pd=1.5u as=0.3808p ps=2.92u w=1.12u l=0.13u
X4321 a_5079_37303# X_uq304 VSS VSS sg13_lv_nmos ad=0.2516p pd=2.16u as=0.1406p ps=1.12u w=0.74u l=0.15u
X4322 Q_uq29 a_39894_64344# VDD VDD sg13_lv_pmos ad=0.3808p pd=2.92u as=0.2128p ps=1.5u w=1.12u l=0.13u
X4323 C_uq19 a_9329_24647# VDD VDD sg13_lv_pmos ad=0.42p pd=2.99u as=0.2114p ps=1.54u w=1.12u l=0.13u
X4324 Y_uq109 X_uq236 VSS VSS sg13_lv_nmos ad=0.1406p pd=1.12u as=0.2516p ps=2.16u w=0.74u l=0.13u
X4325 VDD Q_uq35 a_31732_64344# VDD sg13_lv_pmos ad=0.2114p pd=1.54u as=0.2856p ps=2.36u w=0.84u l=0.13u
X4326 VSS VDD VSS VSS sg13_lv_nmos ad=79.8f pd=0.8u as=0 ps=-0 w=0.42u l=1u
X4327 a_80189_22959# a_79919_22959# VSS VSS sg13_lv_nmos ad=0.1428p pd=1.52u as=79.8f ps=0.8u w=0.42u l=0.5u
X4328 a_10990_25695# B_uq58 VDD VDD sg13_lv_pmos ad=0.2464p pd=1.56u as=0.3808p ps=2.92u w=1.12u l=0.13u
X4329 a_30454_65317# a_30897_65073# a_30194_65094# VSS sg13_lv_nmos ad=79.8f pd=0.8u as=0.1296p ps=1.52u w=0.42u l=0.13u
X4330 Q_uq36 a_45270_65856# VDD VDD sg13_lv_pmos ad=0.3808p pd=2.92u as=0.2128p ps=1.5u w=1.12u l=0.13u
X4331 a_49776_68436# a_49750_68341# VSS VSS sg13_lv_nmos ad=0.2516p pd=2.16u as=0.1626p ps=1.415u w=0.74u l=0.13u
X4332 VSS X_uq448 a_45466_65136# VSS sg13_lv_nmos ad=0.17255p pd=1.25u as=0.187p ps=1.78u w=0.55u l=0.13u
X4333 X_uq210 a_75295_22993# VSS VSS sg13_lv_nmos ad=0.2886p pd=2.26u as=0.14875p ps=1.16u w=0.74u l=0.13u
X4334 a_79134_22292# a_79286_22176# VDD VDD sg13_lv_pmos ad=0.3864p pd=2.93u as=1.59725p ps=10.05u w=1.12u l=0.13u
X4335 VSS X_uq251 Y_uq64 VSS sg13_lv_nmos ad=0.2618p pd=2.22u as=0.1694p ps=1.21u w=0.77u l=0.13u
X4336 VSS a_8075_39865# X_uq308 VSS sg13_lv_nmos ad=0.1426p pd=1.16u as=0.2516p ps=2.16u w=0.74u l=0.13u
X4337 VSS VDD VSS VSS sg13_lv_nmos ad=0.1428p pd=1.52u as=0 ps=-0 w=0.42u l=1u
X4338 VDD a_43162_63771# X_uq345 VDD sg13_lv_pmos ad=0.2254p pd=1.53u as=0.4256p ps=3u w=1.12u l=0.13u
X4339 a_36597_70021# a_36240_69948# VDD VDD sg13_lv_pmos ad=63f pd=0.72u as=0.1563p ps=1.22u w=0.42u l=0.13u
X4340 VSS X_uq168 Y_uq30 VSS sg13_lv_nmos ad=0.2516p pd=2.16u as=0.1406p ps=1.12u w=0.74u l=0.13u
X4341 a_77827_26277# C_uq23 A2_uq3 VDD sg13_lv_pmos ad=0.1176p pd=1.33u as=0.3808p ps=2.92u w=1.12u l=0.13u
X4342 a_45826_10649# q[24] VSS VSS sg13_lv_nmos ad=0.187p pd=1.78u as=0.14875p ps=1.16u w=0.55u l=0.13u
X4343 Y_uq63 X_uq202 VSS VSS sg13_lv_nmos ad=0.2516p pd=2.16u as=0.2516p ps=2.16u w=0.74u l=0.13u
X4344 VSS VDD VSS VSS sg13_lv_nmos ad=0.1428p pd=1.52u as=0 ps=-0 w=0.42u l=1u
X4345 a_78002_24065# X_uq215 VSS VSS sg13_lv_nmos ad=78.39999f pd=0.885u as=0.2272p ps=1.99u w=0.64u l=0.13u
X4346 B_uq55 a_9746_24671# VSS VSS sg13_lv_nmos ad=0.2516p pd=2.16u as=0.13395p ps=1.12u w=0.74u l=0.13u
X4347 a_40545_68927# a_39603_68967# a_40406_69160# VSS sg13_lv_nmos ad=79.8f pd=0.8u as=0.2373p ps=1.97u w=0.42u l=0.13u
X4348 VSS a_43036_69850# a_42685_69707# VSS sg13_lv_nmos ad=79.8f pd=0.8u as=0.1428p ps=1.52u w=0.42u l=0.13u
X4349 Y_uq195 B_uq86 VDD VDD sg13_lv_pmos ad=0.2128p pd=1.5u as=0.3808p ps=2.92u w=1.12u l=0.15u
X4350 X_uq64 a_40646_8789# VDD VDD sg13_lv_pmos ad=0.3976p pd=2.95u as=0.2226p ps=1.535u w=1.12u l=0.13u
X4351 VSS VDD VSS VSS sg13_lv_nmos ad=0.1428p pd=1.52u as=0 ps=-0 w=0.42u l=1u
X4352 VSS C_uq68 D_uq60 VSS sg13_lv_nmos ad=0.1463p pd=1.15u as=0.2618p ps=2.22u w=0.77u l=0.13u
X4353 Y_uq152 X_uq268 VSS VSS sg13_lv_nmos ad=0.2516p pd=2.16u as=0.2516p ps=2.16u w=0.74u l=0.13u
X4354 VSS a_9609_34825# D_uq19 VSS sg13_lv_nmos ad=0.1371p pd=1.12u as=0.2516p ps=2.16u w=0.74u l=0.13u
X4355 VSS VDD VSS VSS sg13_lv_nmos ad=79.8f pd=0.8u as=0 ps=-0 w=0.42u l=1u
X4356 a_5809_38522# Q_uq25 VSS VSS sg13_lv_nmos ad=0.187p pd=1.78u as=0.14505p ps=1.15u w=0.55u l=0.13u
X4357 VSS B_uq93 a_5087_39700# VSS sg13_lv_nmos ad=0.14505p pd=1.15u as=0.1406p ps=1.12u w=0.74u l=0.13u
X4358 VSS a_47960_63546# q[22] VSS sg13_lv_nmos ad=0.14875p pd=1.16u as=0.2886p ps=2.26u w=0.74u l=0.13u
X4359 VSS Y_uq165 a_9632_33083# VSS sg13_lv_nmos ad=0.1701p pd=1.65u as=37.8f ps=0.6u w=0.42u l=0.13u
X4360 VSS a_36533_69218# a_36454_69121# VSS sg13_lv_nmos ad=2.01085p pd=12.81u as=0.27427p ps=2.28u w=0.795u l=0.13u
X4361 VSS a_8071_32855# a_8107_32787# VSS sg13_lv_nmos ad=79.8f pd=0.8u as=0.1428p ps=1.52u w=0.42u l=0.13u
X4362 VDD VSS VDD VDD sg13_lv_pmos ad=0.34p pd=2.68u as=0 ps=0 w=1u l=1u
X4363 VDD a_36730_68307# D_uq55 VDD sg13_lv_pmos ad=0.2254p pd=1.53u as=0.4256p ps=3u w=1.12u l=0.13u
X4364 a_10819_41001# D_uq27 a_10428_41738# VSS sg13_lv_nmos ad=60.89999f pd=0.71u as=0.1428p ps=1.52u w=0.42u l=0.13u
X4365 VDD a_42406_65062# a_42125_65284# VDD sg13_lv_pmos ad=0.1523p pd=1.38u as=0.34p ps=2.68u w=1u l=0.5u
X4366 a_42926_10067# X_uq144 VSS VSS sg13_lv_nmos ad=0.1045p pd=0.93u as=0.1469p ps=1.155u w=0.55u l=0.13u
X4367 a_29616_68884# a_30135_68891# a_30875_69241# VSS sg13_lv_nmos ad=0.3473p pd=2.71u as=0.12665p ps=1.145u w=0.74u l=0.13u
X4368 X_uq271 a_76063_26741# VSS VSS sg13_lv_nmos ad=0.2886p pd=2.26u as=0.14875p ps=1.16u w=0.74u l=0.13u
X4369 VDD VSS VDD VDD sg13_lv_pmos ad=0.34p pd=2.68u as=0 ps=0 w=1u l=1u
X4370 VDD din[12] a_75295_26017# VDD sg13_lv_pmos ad=0.2114p pd=1.54u as=0.2856p ps=2.36u w=0.84u l=0.13u
X4371 a_4168_24568# a_3880_24147# a_4106_24568# VSS sg13_lv_nmos ad=0.1428p pd=1.52u as=37.8f ps=0.6u w=0.42u l=0.13u
X4372 a_5849_41193# a_5813_41167# VSS VSS sg13_lv_nmos ad=0.2516p pd=2.16u as=0.1626p ps=1.415u w=0.74u l=0.13u
X4373 VSS a_48341_63528# a_48262_63803# VSS sg13_lv_nmos ad=3.5825p pd=23.78u as=0.27427p ps=2.28u w=0.795u l=0.13u
X4374 D_uq57 a_28770_68186# VDD VDD sg13_lv_pmos ad=0.4256p pd=3u as=0.2254p ps=1.53u w=1.12u l=0.13u
X4375 X_uq17 a_39774_6937# VSS VSS sg13_lv_nmos ad=0.2886p pd=2.26u as=0.14875p ps=1.16u w=0.74u l=0.13u
X4376 VSS a_46018_8375# B_uq1 VSS sg13_lv_nmos ad=0.14875p pd=1.16u as=0.2886p ps=2.26u w=0.74u l=0.13u
X4377 VSS a_37070_11001# X_uq160 VSS sg13_lv_nmos ad=0.1469p pd=1.155u as=0.2516p ps=2.16u w=0.74u l=0.13u
X4378 VSS a_8075_37753# D_uq25 VSS sg13_lv_nmos ad=0.1426p pd=1.16u as=0.2516p ps=2.16u w=0.74u l=0.13u
X4379 D X_uq259 VSS VSS sg13_lv_nmos ad=0.1694p pd=1.21u as=0.2618p ps=2.22u w=0.77u l=0.13u
X4380 VSS din[13] a_75295_25229# VSS sg13_lv_nmos ad=0.14875p pd=1.16u as=0.187p ps=1.78u w=0.55u l=0.13u
X4381 VSS a_28064_67332# Y_uq329 VSS sg13_lv_nmos ad=0.17255p pd=1.25u as=0.1406p ps=1.12u w=0.74u l=0.13u
X4382 VDD B_uq66 a_6992_22631# VDD sg13_lv_pmos ad=0.4032p pd=2.96u as=0.1176p ps=1.33u w=1.12u l=0.13u
X4383 VSS a_32792_68082# X_uq458 VSS sg13_lv_nmos ad=0.14875p pd=1.16u as=0.2886p ps=2.26u w=0.74u l=0.13u
X4384 Q_uq42 a_46422_68880# VDD VDD sg13_lv_pmos ad=0.3808p pd=2.92u as=0.2128p ps=1.5u w=1.12u l=0.13u
X4385 a_5800_21123# a_5774_21087# VDD VDD sg13_lv_pmos ad=0.34p pd=2.68u as=0.36237p ps=2.605u w=1u l=0.13u
X4386 a_47798_68416# X_uq446 VDD VDD sg13_lv_pmos ad=0.1176p pd=1.33u as=0.4032p ps=2.96u w=1.12u l=0.13u
X4387 a_51971_65485# a_51275_65364# a_52065_65252# VSS sg13_lv_nmos ad=0.1296p pd=1.52u as=79.8f ps=0.8u w=0.42u l=0.13u
X4388 VDD VSS VDD VDD sg13_lv_pmos ad=0.34p pd=2.68u as=0 ps=0 w=1u l=1u
X4389 Y_uq14 a_34980_9229# VSS VSS sg13_lv_nmos ad=0.1406p pd=1.12u as=0.17255p ps=1.25u w=0.74u l=0.13u
X4390 a_28419_64344# Y_uq281 a_28305_64344# VDD sg13_lv_pmos ad=0.2128p pd=1.5u as=0.2464p ps=1.56u w=1.12u l=0.13u
X4391 C_uq13 B_uq66 VSS VSS sg13_lv_nmos ad=0.1406p pd=1.12u as=0.2516p ps=2.16u w=0.74u l=0.13u
X4392 a_47126_66904# X_uq448 VDD VDD sg13_lv_pmos ad=0.1176p pd=1.33u as=0.4032p ps=2.96u w=1.12u l=0.13u
X4393 a_75630_19181# B_uq32 a_75516_19181# VDD sg13_lv_pmos ad=0.2128p pd=1.5u as=0.2464p ps=1.56u w=1.12u l=0.13u
X4394 VDD a_10345_31414# Q_uq10 VDD sg13_lv_pmos ad=0.2128p pd=1.5u as=0.3808p ps=2.92u w=1.12u l=0.13u
X4395 a_78881_22643# a_78574_22169# a_78787_22643# VSS sg13_lv_nmos ad=37.8f pd=0.6u as=0.1428p ps=1.52u w=0.42u l=0.13u
X4396 VSS B_uq22 a_40334_9489# VSS sg13_lv_nmos ad=0.187p pd=1.78u as=0.1045p ps=0.93u w=0.55u l=0.13u
X4397 a_78651_26745# a_78625_26709# VSS VSS sg13_lv_nmos ad=0.2516p pd=2.16u as=0.1626p ps=1.415u w=0.74u l=0.13u
X4398 a_10669_22381# B_uq63 a_10567_22381# VSS sg13_lv_nmos ad=0.1406p pd=1.12u as=0.1406p ps=1.12u w=0.74u l=0.13u
X4399 Y_uq310 Q_uq56 VDD VDD sg13_lv_pmos ad=0.3808p pd=2.92u as=0.3808p ps=2.92u w=1.12u l=0.13u
X4400 X_uq78 a_42566_9149# VDD VDD sg13_lv_pmos ad=0.3976p pd=2.95u as=0.2226p ps=1.535u w=1.12u l=0.13u
X4401 B_uq85 Y_uq207 a_8425_36573# VDD sg13_lv_pmos ad=0.2128p pd=1.5u as=0.2128p ps=1.5u w=1.12u l=0.15u
X4402 Y_uq19 A_uq87 a_41154_10221# VDD sg13_lv_pmos ad=0.3808p pd=2.92u as=0.1176p ps=1.33u w=1.12u l=0.13u
X4403 a_30203_66217# a_29361_65867# a_30109_66217# VSS sg13_lv_nmos ad=0.12665p pd=1.145u as=0.1428p ps=1.52u w=0.42u l=0.13u
X4404 VSS Y_uq13 a_35166_6937# VSS sg13_lv_nmos ad=0.14875p pd=1.16u as=0.187p ps=1.78u w=0.55u l=0.13u
X4405 VDD L_HI_uq35 a_44470_68848# VDD sg13_lv_pmos ad=0.1563p pd=1.22u as=0.147p ps=1.54u w=0.42u l=0.13u
X4406 VSS a_5051_42745# X_uq324 VSS sg13_lv_nmos ad=0.1426p pd=1.16u as=0.2516p ps=2.16u w=0.74u l=0.13u
X4407 VSS C_uq15 Y_uq65 VSS sg13_lv_nmos ad=0.1463p pd=1.15u as=0.1694p ps=1.21u w=0.77u l=0.13u
X4408 a_43714_6863# X_uq78 VSS VSS sg13_lv_nmos ad=0.187p pd=1.78u as=0.14875p ps=1.16u w=0.55u l=0.13u
X4409 C_uq13 B_uq50 a_4302_23679# VDD sg13_lv_pmos ad=0.3808p pd=2.92u as=0.1176p ps=1.33u w=1.12u l=0.13u
X4410 X_uq157 a_35838_10685# VDD VDD sg13_lv_pmos ad=0.42p pd=2.99u as=0.2114p ps=1.54u w=1.12u l=0.13u
X4411 VSS B_uq96 a_4297_39287# VSS sg13_lv_nmos ad=0.17255p pd=1.25u as=0.187p ps=1.78u w=0.55u l=0.13u
X4412 a_42406_65062# Q_uq30 VDD VDD sg13_lv_pmos ad=0.1428p pd=1.52u as=0.1523p ps=1.38u w=0.42u l=0.13u
X4413 VDD B_uq43 a_78039_23756# VDD sg13_lv_pmos ad=0.2891p pd=1.695u as=0.1596p ps=1.22u w=0.84u l=0.13u
X4414 VSS a_35722_8379# Y_uq6 VSS sg13_lv_nmos ad=0.17255p pd=1.25u as=0.1406p ps=1.12u w=0.74u l=0.13u
X4415 VDD D_uq34 a_47459_64391# VDD sg13_lv_pmos ad=0.1428p pd=1.52u as=79.8f ps=0.8u w=0.42u l=0.13u
X4416 A_uq0 a_45268_66644# VDD VDD sg13_lv_pmos ad=0.42p pd=2.99u as=0.2114p ps=1.54u w=1.12u l=0.13u
X4417 X_uq19 a_39006_6937# VDD VDD sg13_lv_pmos ad=0.42p pd=2.99u as=0.2114p ps=1.54u w=1.12u l=0.13u
X4418 VSS VDD VSS VSS sg13_lv_nmos ad=0.1428p pd=1.52u as=0 ps=-0 w=0.42u l=1u
X4419 VSS X_uq162 Y_uq24 VSS sg13_lv_nmos ad=0.2516p pd=2.16u as=0.1406p ps=1.12u w=0.74u l=0.13u
X4420 X_uq450 a_48148_68880# VSS VSS sg13_lv_nmos ad=0.2886p pd=2.26u as=0.14875p ps=1.16u w=0.74u l=0.13u
X4421 Q_uq29 a_39894_64344# VSS VSS sg13_lv_nmos ad=0.2516p pd=2.16u as=0.1406p ps=1.12u w=0.74u l=0.13u
X4422 VDD L_HI_uq21 a_29080_64782# VDD sg13_lv_pmos ad=1.4745p pd=9.07u as=79.8f ps=0.8u w=0.42u l=0.13u
X4423 VSS C_uq20 Y_uq32 VSS sg13_lv_nmos ad=0.2516p pd=2.16u as=0.1406p ps=1.12u w=0.74u l=0.13u
X4424 VSS Q_uq35 a_31732_64344# VSS sg13_lv_nmos ad=0.14875p pd=1.16u as=0.187p ps=1.78u w=0.55u l=0.13u
X4425 a_7346_24410# a_7461_24409# VSS VSS sg13_lv_nmos ad=0.1428p pd=1.52u as=0.1426p ps=1.16u w=0.42u l=0.5u
X4426 a_33430_64312# a_33873_64355# a_33170_64782# VSS sg13_lv_nmos ad=79.8f pd=0.8u as=0.1296p ps=1.52u w=0.42u l=0.13u
X4427 VSS Y_uq76 a_12593_20899# VSS sg13_lv_nmos ad=0.14875p pd=1.16u as=0.187p ps=1.78u w=0.55u l=0.13u
X4428 a_44024_63546# Y_uq292 VDD VDD sg13_lv_pmos ad=0.2856p pd=2.36u as=0.2114p ps=1.54u w=0.84u l=0.13u
X4429 VDD X_uq305 a_7337_37793# VDD sg13_lv_pmos ad=0.3808p pd=2.92u as=0.2128p ps=1.5u w=1.12u l=0.15u
X4430 X_uq193 a_10193_20111# VDD VDD sg13_lv_pmos ad=0.42p pd=2.99u as=0.2114p ps=1.54u w=1.12u l=0.13u
X4431 VSS B_uq25 a_39374_9489# VSS sg13_lv_nmos ad=0.187p pd=1.78u as=0.1045p ps=0.93u w=0.55u l=0.13u
X4432 VDD a_38662_66574# a_38381_66796# VDD sg13_lv_pmos ad=0.1523p pd=1.38u as=0.34p ps=2.68u w=1u l=0.5u
X4433 VDD X_uq251 a_77029_20749# VDD sg13_lv_pmos ad=0.2618p pd=1.63u as=0.2856p ps=2.36u w=0.84u l=0.13u
X4434 a_8832_34225# X_uq286 VSS VSS sg13_lv_nmos ad=0.17462p pd=1.185u as=0.374p ps=2.46u w=0.55u l=0.13u
X4435 VDD a_36316_66098# a_36261_65979# VDD sg13_lv_pmos ad=1.41367p pd=8.85u as=93.45f ps=0.865u w=0.42u l=0.13u
X4436 a_5833_35135# a_5809_34855# VDD VDD sg13_lv_pmos ad=0.34p pd=2.68u as=0.1523p ps=1.38u w=1u l=0.5u
X4437 a_43810_10649# q[22] VDD VDD sg13_lv_pmos ad=0.2856p pd=2.36u as=0.2114p ps=1.54u w=0.84u l=0.13u
X4438 a_41414_10301# B_uq20 VSS VSS sg13_lv_nmos ad=0.1045p pd=0.93u as=0.187p ps=1.78u w=0.55u l=0.13u
X4439 a_76549_28253# B1_uq7 a_76651_28253# VDD sg13_lv_pmos ad=0.3808p pd=2.92u as=0.2128p ps=1.5u w=1.12u l=0.13u
X4440 a_80076_28300# a_79134_28340# a_79937_28533# VSS sg13_lv_nmos ad=79.8f pd=0.8u as=0.2373p ps=1.97u w=0.42u l=0.13u
X4441 a_33360_68436# a_33334_68341# VDD VDD sg13_lv_pmos ad=0.34p pd=2.68u as=0.36237p ps=2.605u w=1u l=0.13u
X4442 VDD a_31132_69122# a_31077_69003# VDD sg13_lv_pmos ad=1.42837p pd=8.61u as=93.45f ps=0.865u w=0.42u l=0.13u
X4443 VDD a_78577_21411# a_78296_21633# VDD sg13_lv_pmos ad=0.1523p pd=1.38u as=0.34p ps=2.68u w=1u l=0.5u
X4444 VSS a_4299_33212# a_4335_33143# VSS sg13_lv_nmos ad=5.0377p pd=32.285u as=0.2516p ps=2.16u w=0.74u l=0.13u
X4445 a_9619_37545# D_uq24 a_9619_37451# VSS sg13_lv_nmos ad=60.89999f pd=0.71u as=0.1428p ps=1.52u w=0.42u l=0.13u
X4446 a_36730_68307# a_36845_68308# VSS VSS sg13_lv_nmos ad=0.1428p pd=1.52u as=0.1426p ps=1.16u w=0.42u l=0.5u
X4447 VSS Y_uq288 a_45268_66644# VSS sg13_lv_nmos ad=0.14875p pd=1.16u as=0.187p ps=1.78u w=0.55u l=0.13u
X4448 X_uq244 a_10481_25435# VDD VDD sg13_lv_pmos ad=0.42p pd=2.99u as=0.2114p ps=1.54u w=1.12u l=0.13u
X4449 a_10819_36727# Y_uq186 VSS VSS sg13_lv_nmos ad=37.8f pd=0.6u as=79.8f ps=0.8u w=0.42u l=0.13u
X4450 VSS a_39874_7625# X_uq51 VSS sg13_lv_nmos ad=0.14875p pd=1.16u as=0.2886p ps=2.26u w=0.74u l=0.13u
X4451 VDD a_79619_21407# B_uq67 VDD sg13_lv_pmos ad=0.2114p pd=1.54u as=0.42p ps=2.99u w=1.12u l=0.13u
X4452 VDD X_uq346 a_37758_10685# VDD sg13_lv_pmos ad=0.2114p pd=1.54u as=0.2856p ps=2.36u w=0.84u l=0.13u
X4453 a_78651_24785# a_78625_24690# VDD VDD sg13_lv_pmos ad=0.34p pd=2.68u as=0.36237p ps=2.605u w=1u l=0.13u
X4454 a_36950_63880# X_uq429 VDD VDD sg13_lv_pmos ad=0.1176p pd=1.33u as=0.4032p ps=2.96u w=1.12u l=0.13u
X4455 VDD Q_uq30 Y_uq250 VDD sg13_lv_pmos ad=0.3808p pd=2.92u as=0.3808p ps=2.92u w=1.12u l=0.13u
X4456 Y_uq142 C1_uq4 VSS VSS sg13_lv_nmos ad=0.1406p pd=1.12u as=0.2516p ps=2.16u w=0.74u l=0.13u
X4457 X_uq346 a_38740_63620# VDD VDD sg13_lv_pmos ad=0.42p pd=2.99u as=0.2114p ps=1.54u w=1.12u l=0.13u
X4458 VSS A_uq97 a_38622_7661# VSS sg13_lv_nmos ad=0.14875p pd=1.16u as=0.187p ps=1.78u w=0.55u l=0.13u
X4459 A2_uq3 C_uq23 VSS VSS sg13_lv_nmos ad=0.1406p pd=1.12u as=0.2516p ps=2.16u w=0.74u l=0.13u
X4460 a_4297_43188# a_4299_42044# a_4694_42358# VSS sg13_lv_nmos ad=0.12665p pd=1.145u as=0.1428p ps=1.52u w=0.42u l=0.13u
X4461 X_uq93 a_34014_7661# VDD VDD sg13_lv_pmos ad=0.42p pd=2.99u as=0.2114p ps=1.54u w=1.12u l=0.13u
X4462 a_8071_32855# a_8071_33019# a_8107_32983# VSS sg13_lv_nmos ad=0.1428p pd=1.52u as=37.8f ps=0.6u w=0.42u l=0.13u
X4463 VDD a_42010_65283# X_uq375 VDD sg13_lv_pmos ad=0.2254p pd=1.53u as=0.4256p ps=3u w=1.12u l=0.13u
X4464 VSS VDD VSS VSS sg13_lv_nmos ad=0.1428p pd=1.52u as=0 ps=-0 w=0.42u l=1u
X4465 VSS Q_uq51 Y_uq356 VSS sg13_lv_nmos ad=0.2516p pd=2.16u as=0.2516p ps=2.16u w=0.74u l=0.13u
X4466 C_uq57 X_uq406 a_27926_66904# VDD sg13_lv_pmos ad=0.3808p pd=2.92u as=0.1176p ps=1.33u w=1.12u l=0.13u
X4467 X_uq35 a_32862_6937# VDD VDD sg13_lv_pmos ad=0.42p pd=2.99u as=0.2114p ps=1.54u w=1.12u l=0.13u
X4468 a_4297_30929# Q_uq11 VSS VSS sg13_lv_nmos ad=0.187p pd=1.78u as=0.14875p ps=1.16u w=0.55u l=0.13u
X4469 VDD din[6] a_75967_29041# VDD sg13_lv_pmos ad=0.2114p pd=1.54u as=0.2856p ps=2.36u w=0.84u l=0.13u
X4470 a_44868_10301# B_uq7 a_44774_10301# VDD sg13_lv_pmos ad=0.1596p pd=1.22u as=0.2856p ps=2.36u w=0.84u l=0.13u
X4471 VDD C_uq16 a_11628_24647# VDD sg13_lv_pmos ad=0.3808p pd=2.92u as=0.2464p ps=1.56u w=1.12u l=0.13u
X4472 VSS Q_uq19 a_9247_38875# VSS sg13_lv_nmos ad=0.1406p pd=1.12u as=0.2516p ps=2.16u w=0.74u l=0.15u
X4473 a_46545_63625# a_46545_63625# VSS VSS sg13_lv_nmos ad=0.111p pd=1.34u as=3.5825p ps=23.78u w=0.3u l=0.13u
X4474 a_76477_27517# Y_uq146 Y_uq144 VSS sg13_lv_nmos ad=0.1406p pd=1.12u as=0.2516p ps=2.16u w=0.74u l=0.13u
X4475 a_44130_9173# a_43908_9229# VDD VDD sg13_lv_pmos ad=0.1176p pd=1.33u as=0.2618p ps=1.63u w=1.12u l=0.13u
X4476 VDD B_uq55 a_12533_24647# VDD sg13_lv_pmos ad=0.4032p pd=2.96u as=0.1176p ps=1.33u w=1.12u l=0.13u
X4477 a_30626_64769# a_29448_64705# a_30230_64624# VSS sg13_lv_nmos ad=37.8f pd=0.6u as=0.1428p ps=1.52u w=0.42u l=0.13u
X4478 D_uq5 B_uq63 VDD VDD sg13_lv_pmos ad=0.2128p pd=1.5u as=0.2198p ps=1.53u w=1.12u l=0.13u
X4479 a_40006_66574# Q_uq34 VDD VDD sg13_lv_pmos ad=0.1428p pd=1.52u as=0.1523p ps=1.38u w=0.42u l=0.13u
X4480 a_3535_42833# A_uq347 VDD VDD sg13_lv_pmos ad=0.2856p pd=2.36u as=0.2114p ps=1.54u w=0.84u l=0.13u
X4481 a_43162_63771# a_43277_63772# VSS VSS sg13_lv_nmos ad=0.1428p pd=1.52u as=0.1426p ps=1.16u w=0.42u l=0.5u
X4482 a_36206_10067# B_uq10 a_36348_10301# VDD sg13_lv_pmos ad=0.2856p pd=2.36u as=0.1596p ps=1.22u w=0.84u l=0.13u
X4483 a_50865_64355# clk VDD VDD sg13_lv_pmos ad=0.4088p pd=2.97u as=1.4357p ps=8.83u w=1.12u l=0.13u
X4484 a_7705_33028# B_uq76 VSS VSS sg13_lv_nmos ad=81.6f pd=0.895u as=0.2176p ps=1.96u w=0.64u l=0.13u
X4485 VSS C_uq22 Y_uq119 VSS sg13_lv_nmos ad=0.1463p pd=1.15u as=0.1694p ps=1.21u w=0.77u l=0.13u
X4486 D_uq31 Y_uq219 VSS VSS sg13_lv_nmos ad=0.1694p pd=1.21u as=0.2618p ps=2.22u w=0.77u l=0.13u
X4487 a_80333_28678# a_79155_28614# a_79937_28533# VSS sg13_lv_nmos ad=37.8f pd=0.6u as=0.1428p ps=1.52u w=0.42u l=0.13u
X4488 a_7357_35155# B_uq79 a_7357_35257# VDD sg13_lv_pmos ad=0.3808p pd=2.92u as=0.2128p ps=1.5u w=1.12u l=0.13u
X4489 X_uq433 a_34804_68880# VDD VDD sg13_lv_pmos ad=0.42p pd=2.99u as=0.2114p ps=1.54u w=1.12u l=0.13u
X4490 a_44482_7625# X_uq145 VDD VDD sg13_lv_pmos ad=0.2856p pd=2.36u as=0.2114p ps=1.54u w=0.84u l=0.13u
X4491 a_37910_66904# X_uq429 VDD VDD sg13_lv_pmos ad=0.1176p pd=1.33u as=0.4032p ps=2.96u w=1.12u l=0.13u
X4492 VSS a_33730_7625# X_uq123 VSS sg13_lv_nmos ad=0.14875p pd=1.16u as=0.2886p ps=2.26u w=0.74u l=0.13u
X4493 VDD B_uq33 a_10372_19391# VDD sg13_lv_pmos ad=0.2198p pd=1.53u as=0.2856p ps=2.36u w=0.84u l=0.13u
X4494 VSS L_HI_uq17 a_52322_65107# VSS sg13_lv_nmos ad=0.1701p pd=1.65u as=37.8f ps=0.6u w=0.42u l=0.13u
X4495 VDD a_38651_66217# a_39318_65856# VDD sg13_lv_pmos ad=0.2128p pd=1.5u as=0.3864p ps=2.93u w=1.12u l=0.13u
X4496 B1 Y_uq73 a_76438_22597# VSS sg13_lv_nmos ad=0.2664p pd=1.46u as=0.13875p ps=1.115u w=0.74u l=0.13u
X4497 Y_uq36 C_uq1 VSS VSS sg13_lv_nmos ad=0.1406p pd=1.12u as=0.2516p ps=2.16u w=0.74u l=0.13u
X4498 VSS a_50168_69594# A_uq20 VSS sg13_lv_nmos ad=0.14875p pd=1.16u as=0.2886p ps=2.26u w=0.74u l=0.13u
X4499 VSS D_uq5 Y_uq97 VSS sg13_lv_nmos ad=0.1463p pd=1.15u as=0.2618p ps=2.22u w=0.77u l=0.13u
X4500 VSS din[15] a_75295_24505# VSS sg13_lv_nmos ad=0.14875p pd=1.16u as=0.187p ps=1.78u w=0.55u l=0.13u
X4501 a_37934_9489# A_uq88 VSS VSS sg13_lv_nmos ad=0.1045p pd=0.93u as=0.1469p ps=1.155u w=0.55u l=0.13u
X4502 VDD S a_6893_40355# VDD sg13_lv_pmos ad=0.253p pd=1.53u as=0.3325p ps=1.665u w=1u l=0.13u
X4503 VSS A0 a_7320_39999# VSS sg13_lv_nmos ad=0.374p pd=2.46u as=0.17462p ps=1.185u w=0.55u l=0.13u
X4504 C_uq21 C_uq16 VDD VDD sg13_lv_pmos ad=0.3808p pd=2.92u as=0.2128p ps=1.5u w=1.12u l=0.13u
X4505 VSS a_80593_25947# a_80312_26169# VSS sg13_lv_nmos ad=79.8f pd=0.8u as=0.1428p ps=1.52u w=0.42u l=0.5u
X4506 VDD a_37838_8555# X_uq70 VDD sg13_lv_pmos ad=0.2226p pd=1.535u as=0.3976p ps=2.95u w=1.12u l=0.13u
X4507 a_3571_33383# Y_uq172 VSS VSS sg13_lv_nmos ad=60.89999f pd=0.71u as=0.1626p ps=1.415u w=0.42u l=0.13u
X4508 VSS C1_uq6 Y_uq144 VSS sg13_lv_nmos ad=0.1406p pd=1.12u as=0.2516p ps=2.16u w=0.74u l=0.13u
X4509 B_uq29 a_33150_10685# VSS VSS sg13_lv_nmos ad=0.2886p pd=2.26u as=0.14875p ps=1.16u w=0.74u l=0.13u
X4510 VDD L_HI_uq5 a_5514_24893# VDD sg13_lv_pmos ad=0.36237p pd=2.605u as=79.8f ps=0.8u w=0.42u l=0.13u
X4511 a_78757_23984# a_78872_23983# VSS VSS sg13_lv_nmos ad=0.1428p pd=1.52u as=0.1426p ps=1.16u w=0.42u l=0.5u
X4512 Y_uq98 D_uq5 a_12256_24183# VDD sg13_lv_pmos ad=0.3808p pd=2.92u as=0.2128p ps=1.5u w=1.12u l=0.13u
X4513 X_uq55 a_33246_7661# VSS VSS sg13_lv_nmos ad=0.2886p pd=2.26u as=0.14875p ps=1.16u w=0.74u l=0.13u
X4514 X_uq341 a_41236_63620# VDD VDD sg13_lv_pmos ad=0.42p pd=2.99u as=0.2114p ps=1.54u w=1.12u l=0.13u
X4515 VSS a_10345_30929# X_uq280 VSS sg13_lv_nmos ad=0.14875p pd=1.16u as=0.2886p ps=2.26u w=0.74u l=0.13u
X4516 VDD a_45250_6863# X_uq3 VDD sg13_lv_pmos ad=0.2114p pd=1.54u as=0.42p ps=2.99u w=1.12u l=0.13u
X4517 Y_uq238 X_uq323 VSS VSS sg13_lv_nmos ad=0.2516p pd=2.16u as=0.2516p ps=2.16u w=0.74u l=0.13u
X4518 a_34065_67405# a_34065_67405# VSS VSS sg13_lv_nmos ad=0.111p pd=1.34u as=2.08687p ps=13.23u w=0.3u l=0.13u
X4519 D_uq18 D_uq12 VSS VSS sg13_lv_nmos ad=0.1406p pd=1.12u as=0.2516p ps=2.16u w=0.74u l=0.13u
X4520 a_30309_69945# a_29367_69752# a_30107_69707# VDD sg13_lv_pmos ad=93.45f pd=0.865u as=0.2048p ps=1.63u w=0.42u l=0.13u
X4521 a_51458_66619# a_50280_66570# a_51062_66764# VSS sg13_lv_nmos ad=37.8f pd=0.6u as=0.1428p ps=1.52u w=0.42u l=0.13u
X4522 Y_uq110 B_uq58 VSS VSS sg13_lv_nmos ad=0.1694p pd=1.21u as=0.2618p ps=2.22u w=0.77u l=0.13u
X4523 VSS X_uq401 C_uq66 VSS sg13_lv_nmos ad=0.2516p pd=2.16u as=0.1406p ps=1.12u w=0.74u l=0.13u
X4524 a_6894_22167# Q_uq0 Y_uq93 VDD sg13_lv_pmos ad=0.1176p pd=1.33u as=0.3808p ps=2.92u w=1.12u l=0.13u
X4525 a_3886_41502# a_3546_41381# a_3535_41755# VDD sg13_lv_pmos ad=93.45f pd=0.865u as=0.2048p ps=1.63u w=0.42u l=0.13u
X4526 Y_uq364 Q_uq59 VDD VDD sg13_lv_pmos ad=0.3808p pd=2.92u as=0.3808p ps=2.92u w=1.12u l=0.13u
X4527 a_47265_67415# a_46323_67455# a_47171_67415# VDD sg13_lv_pmos ad=79.8f pd=0.8u as=0.1428p ps=1.52u w=0.42u l=0.13u
X4528 a_42368_68086# X_uq449 VSS VSS sg13_lv_nmos ad=0.187p pd=1.78u as=0.17255p ps=1.25u w=0.55u l=0.13u
X4529 VSS C_uq39 D_uq23 VSS sg13_lv_nmos ad=0.2516p pd=2.16u as=0.2516p ps=2.16u w=0.74u l=0.13u
X4530 VDD a_44134_68086# a_43853_68308# VDD sg13_lv_pmos ad=0.1523p pd=1.38u as=0.34p ps=2.68u w=1u l=0.5u
X4531 VSS L_HI_uq16 a_30288_65094# VSS sg13_lv_nmos ad=0.1626p pd=1.415u as=60.89999f ps=0.71u w=0.42u l=0.13u
X4532 VDD a_36778_9891# a_36736_10221# VDD sg13_lv_pmos ad=0.2618p pd=1.63u as=0.1176p ps=1.33u w=1.12u l=0.13u
X4533 VDD B_uq83 B_uq85 VDD sg13_lv_pmos ad=0.3808p pd=2.92u as=0.2128p ps=1.5u w=1.12u l=0.15u
X4534 VSS Y_uq260 D_uq42 VSS sg13_lv_nmos ad=0.1463p pd=1.15u as=0.1694p ps=1.21u w=0.77u l=0.13u
X4535 C_uq63 X_uq448 VSS VSS sg13_lv_nmos ad=0.1406p pd=1.12u as=0.2516p ps=2.16u w=0.74u l=0.13u
X4536 VDD VSS VDD VDD sg13_lv_pmos ad=0.19p pd=1.38u as=0 ps=0 w=1u l=1u
X4537 a_43930_69819# a_44045_69820# VDD VDD sg13_lv_pmos ad=0.34p pd=2.68u as=0.2254p ps=1.53u w=1u l=0.5u
X4538 VSS VDD VSS VSS sg13_lv_nmos ad=0.1428p pd=1.52u as=0 ps=-0 w=0.42u l=1u
X4539 a_47474_69630# a_48279_69752# a_47734_69853# VDD sg13_lv_pmos ad=0.1428p pd=1.52u as=79.8f ps=0.8u w=0.42u l=0.13u
X4540 a_7321_32575# Y_uq162 VSS VSS sg13_lv_nmos ad=0.1428p pd=1.52u as=79.8f ps=0.8u w=0.42u l=0.13u
X4541 B_uq73 a_8832_34225# a_8869_33953# VDD sg13_lv_pmos ad=0.3808p pd=2.92u as=0.2128p ps=1.5u w=1.12u l=0.13u
X4542 VDD Q_uq26 a_7321_43295# VDD sg13_lv_pmos ad=0.2114p pd=1.54u as=0.2856p ps=2.36u w=0.84u l=0.13u
X4543 VSS B_uq65 a_5618_25711# VSS sg13_lv_nmos ad=0.17255p pd=1.25u as=0.187p ps=1.78u w=0.55u l=0.13u
X4544 VSS D_uq24 D_uq27 VSS sg13_lv_nmos ad=0.1463p pd=1.15u as=0.1694p ps=1.21u w=0.77u l=0.13u
X4545 a_38414_9489# B_uq3 a_38556_9149# VDD sg13_lv_pmos ad=0.2856p pd=2.36u as=0.1596p ps=1.22u w=0.84u l=0.13u
X4546 VSS B_uq11 a_34766_10067# VSS sg13_lv_nmos ad=0.187p pd=1.78u as=0.1045p ps=0.93u w=0.55u l=0.13u
X4547 a_41884_66098# a_41627_66217# a_42046_66294# VSS sg13_lv_nmos ad=0.1428p pd=1.52u as=37.8f ps=0.6u w=0.42u l=0.13u
X4548 VDD X_uq297 Y_uq167 VDD sg13_lv_pmos ad=0.3808p pd=2.92u as=0.3808p ps=2.92u w=1.12u l=0.13u
X4549 VDD VSS VDD VDD sg13_lv_pmos ad=0.19p pd=1.38u as=0 ps=0 w=1u l=1u
X4550 VSS a_39874_8375# X_uq65 VSS sg13_lv_nmos ad=0.14875p pd=1.16u as=0.2886p ps=2.26u w=0.74u l=0.13u
X4551 D_uq1 a_10660_21679# a_10862_21993# VSS sg13_lv_nmos ad=0.333p pd=2.38u as=0.1406p ps=1.12u w=0.74u l=0.13u
X4552 a_3854_24111# a_4297_24154# a_3594_24581# VSS sg13_lv_nmos ad=79.8f pd=0.8u as=0.1296p ps=1.52u w=0.42u l=0.13u
X4553 a_44482_8375# A_uq20 VDD VDD sg13_lv_pmos ad=0.2856p pd=2.36u as=0.2114p ps=1.54u w=0.84u l=0.13u
X4554 Y_uq110 C_uq15 a_10624_24183# VDD sg13_lv_pmos ad=0.3808p pd=2.92u as=0.2128p ps=1.5u w=1.12u l=0.13u
X4555 VDD a_30369_64391# a_29448_64705# VDD sg13_lv_pmos ad=0.36237p pd=2.605u as=0.34p ps=2.68u w=1u l=0.13u
X4556 VSS C_uq37 D_uq21 VSS sg13_lv_nmos ad=0.2516p pd=2.16u as=0.1406p ps=1.12u w=0.74u l=0.13u
X4557 a_7321_37166# B_uq83 VDD VDD sg13_lv_pmos ad=0.1596p pd=1.22u as=0.1918p ps=1.5u w=0.84u l=0.13u
X4558 a_39814_68086# Y_uq322 VDD VDD sg13_lv_pmos ad=0.1428p pd=1.52u as=0.1523p ps=1.38u w=0.42u l=0.13u
X4559 a_40002_9173# a_39780_9229# VDD VDD sg13_lv_pmos ad=0.1176p pd=1.33u as=0.2618p ps=1.63u w=1.12u l=0.13u
X4560 a_6098_22898# a_6213_22897# VSS VSS sg13_lv_nmos ad=0.1428p pd=1.52u as=0.1426p ps=1.16u w=0.42u l=0.5u
X4561 Y_uq324 C_uq66 a_36387_68416# VDD sg13_lv_pmos ad=0.3808p pd=2.92u as=0.2128p ps=1.5u w=1.12u l=0.13u
X4562 a_40952_63546# Q_uq30 VDD VDD sg13_lv_pmos ad=0.2856p pd=2.36u as=0.2114p ps=1.54u w=0.84u l=0.13u
X4563 VSS a_45634_7625# X_uq40 VSS sg13_lv_nmos ad=0.14875p pd=1.16u as=0.2886p ps=2.26u w=0.74u l=0.13u
X4564 a_40451_68927# L_HI_uq37 VDD VDD sg13_lv_pmos ad=79.8f pd=0.8u as=0.36237p ps=2.605u w=0.42u l=0.13u
X4565 a_41026_7625# Y_uq30 VDD VDD sg13_lv_pmos ad=0.2856p pd=2.36u as=0.2114p ps=1.54u w=0.84u l=0.13u
X4566 X_uq221 a_75679_23717# VSS VSS sg13_lv_nmos ad=0.2886p pd=2.26u as=0.14875p ps=1.16u w=0.74u l=0.13u
X4567 a_7357_39594# Y_uq219 VDD VDD sg13_lv_pmos ad=0.2464p pd=1.56u as=0.3808p ps=2.92u w=1.12u l=0.13u
X4568 Y_uq326 a_36826_66648# VSS VSS sg13_lv_nmos ad=0.1406p pd=1.12u as=0.17255p ps=1.25u w=0.74u l=0.13u
X4569 VDD a_47644_66098# a_47589_65979# VDD sg13_lv_pmos ad=1.41367p pd=8.85u as=93.45f ps=0.865u w=0.42u l=0.13u
X4570 Y_uq269 Y_uq253 VSS VSS sg13_lv_nmos ad=0.1694p pd=1.21u as=0.1463p ps=1.15u w=0.77u l=0.13u
X4571 VSS a_9583_39287# a_9619_39219# VSS sg13_lv_nmos ad=79.8f pd=0.8u as=0.1428p ps=1.52u w=0.42u l=0.13u
X4572 Q_uq4 a_7726_25191# VSS VSS sg13_lv_nmos ad=0.2516p pd=2.16u as=0.1406p ps=1.12u w=0.74u l=0.13u
X4573 a_38044_67610# a_37787_67729# a_38206_67806# VSS sg13_lv_nmos ad=0.1428p pd=1.52u as=37.8f ps=0.6u w=0.42u l=0.13u
X4574 Y_uq332 X_uq427 a_47032_68416# VDD sg13_lv_pmos ad=0.3808p pd=2.92u as=0.1176p ps=1.33u w=1.12u l=0.13u
X4575 VSS a_7321_34111# a_7345_33831# VSS sg13_lv_nmos ad=79.8f pd=0.8u as=0.1428p ps=1.52u w=0.42u l=0.5u
X4576 VSS a_6563_38009# Y_uq206 VSS sg13_lv_nmos ad=0.17255p pd=1.25u as=0.1406p ps=1.12u w=0.74u l=0.13u
X4577 VSS a_43516_64586# a_43165_64705# VSS sg13_lv_nmos ad=79.8f pd=0.8u as=0.1428p ps=1.52u w=0.42u l=0.13u
X4578 VDD a_4420_42743# a_4456_42654# VDD sg13_lv_pmos ad=1.31615p pd=8.395u as=93.45f ps=0.865u w=0.42u l=0.13u
X4579 a_29170_66281# L_HI_uq22 VSS VSS sg13_lv_nmos ad=37.8f pd=0.6u as=0.1701p ps=1.65u w=0.42u l=0.13u
X4580 C_uq1 C_uq24 a_10785_20477# VSS sg13_lv_nmos ad=0.2516p pd=2.16u as=0.1406p ps=1.12u w=0.74u l=0.13u
X4581 VDD SLN[9] a_34686_10685# VDD sg13_lv_pmos ad=0.2114p pd=1.54u as=0.2856p ps=2.36u w=0.84u l=0.13u
X4582 a_4297_34766# B_uq78 VDD VDD sg13_lv_pmos ad=0.1596p pd=1.22u as=0.1918p ps=1.5u w=0.84u l=0.13u
X4583 VSS a_78179_25943# X_uq251 VSS sg13_lv_nmos ad=0.14875p pd=1.16u as=0.2886p ps=2.26u w=0.74u l=0.13u
X4584 VDD a_8079_37083# B_uq83 VDD sg13_lv_pmos ad=0.2128p pd=1.5u as=0.3808p ps=2.92u w=1.12u l=0.13u
X4585 a_47986_69643# L_HI_uq34 VSS VSS sg13_lv_nmos ad=37.8f pd=0.6u as=0.1701p ps=1.65u w=0.42u l=0.13u
X4586 VSS Y_uq214 a_9217_39590# VSS sg13_lv_nmos ad=0.2516p pd=2.16u as=0.1406p ps=1.12u w=0.74u l=0.13u
X4587 a_5774_25116# a_6217_24872# a_6157_25284# VDD sg13_lv_pmos ad=79.8f pd=0.8u as=63f ps=0.72u w=0.42u l=0.13u
X4588 a_6641_39472# X_uq314 a_6585_39650# VSS sg13_lv_nmos ad=0.1216p pd=1.02u as=0.2176p ps=1.96u w=0.64u l=0.13u
X4589 a_6559_42573# a_6604_41175# VDD VDD sg13_lv_pmos ad=0.34p pd=2.68u as=0.36237p ps=2.605u w=1u l=0.13u
X4590 a_40368_65860# a_40887_65867# a_41627_66217# VSS sg13_lv_nmos ad=0.3473p pd=2.71u as=0.12665p ps=1.145u w=0.74u l=0.13u
X4591 a_79153_23681# Y_uq85 VDD VDD sg13_lv_pmos ad=0.1428p pd=1.52u as=0.1523p ps=1.38u w=0.42u l=0.13u
X4592 VSS VDD VSS VSS sg13_lv_nmos ad=0.1428p pd=1.52u as=0 ps=-0 w=0.42u l=1u
X4593 VSS a_6559_33211# a_6559_33594# VSS sg13_lv_nmos ad=0.1406p pd=1.12u as=0.2516p ps=2.16u w=0.74u l=0.13u
X4594 a_28822_69853# a_29265_69609# a_29205_70021# VDD sg13_lv_pmos ad=79.8f pd=0.8u as=63f ps=0.72u w=0.42u l=0.13u
X4595 a_5092_31287# a_5062_31722# a_5083_31019# VSS sg13_lv_nmos ad=79.8f pd=0.8u as=0.1296p ps=1.52u w=0.42u l=0.13u
X4596 X_uq352 a_35668_63620# VDD VDD sg13_lv_pmos ad=0.42p pd=2.99u as=0.2114p ps=1.54u w=1.12u l=0.13u
X4597 a_46358_64782# a_46051_64308# a_46264_64782# VSS sg13_lv_nmos ad=37.8f pd=0.6u as=0.1428p ps=1.52u w=0.42u l=0.13u
X4598 VDD a_43942_66827# L_HI_uq19 VDD sg13_lv_pmos ad=1.19383p pd=7.16u as=0.3927p ps=2.99u w=1.155u l=0.13u
X4599 Y_uq319 C_uq63 a_45603_68416# VDD sg13_lv_pmos ad=0.3808p pd=2.92u as=0.2128p ps=1.5u w=1.12u l=0.13u
X4600 a_50168_63546# Y_uq291 VDD VDD sg13_lv_pmos ad=0.2856p pd=2.36u as=0.2114p ps=1.54u w=0.84u l=0.13u
X4601 C_uq20 a_10343_18965# a_10669_18965# VSS sg13_lv_nmos ad=0.3404p pd=2.4u as=0.1406p ps=1.12u w=0.74u l=0.13u
X4602 VSS VDD VSS VSS sg13_lv_nmos ad=0.1428p pd=1.52u as=0 ps=-0 w=0.42u l=1u
X4603 VDD a_35217_65867# a_35319_65867# VDD sg13_lv_pmos ad=1.41367p pd=8.85u as=0.3864p ps=2.93u w=1.12u l=0.13u
X4604 VDD X_uq199 a_8561_19387# VDD sg13_lv_pmos ad=0.2114p pd=1.54u as=0.2856p ps=2.36u w=0.84u l=0.13u
X4605 X_uq183 a_10865_19387# VSS VSS sg13_lv_nmos ad=0.2886p pd=2.26u as=0.14875p ps=1.16u w=0.74u l=0.13u
X4606 a_8115_37109# a_8079_37083# B_uq83 VSS sg13_lv_nmos ad=0.1406p pd=1.12u as=0.3404p ps=2.4u w=0.74u l=0.13u
X4607 a_5139_24504# a_4297_24154# a_3880_24147# VDD sg13_lv_pmos ad=0.2048p pd=1.63u as=0.34p ps=2.68u w=1u l=0.13u
X4608 VDD Y_uq236 a_6595_40907# VDD sg13_lv_pmos ad=0.36237p pd=2.605u as=79.8f ps=0.8u w=0.42u l=0.13u
X4609 A1 Q_uq6 a_76268_20229# VDD sg13_lv_pmos ad=0.3808p pd=2.92u as=0.2128p ps=1.5u w=1.12u l=0.13u
X4610 VDD VSS VDD VDD sg13_lv_pmos ad=0.19p pd=1.38u as=0 ps=0 w=1u l=1u
X4611 VDD a_3535_41755# a_3535_42138# VDD sg13_lv_pmos ad=0.2128p pd=1.5u as=0.3864p ps=2.93u w=1.12u l=0.13u
X4612 VDD a_48728_65820# q[27] VDD sg13_lv_pmos ad=0.2114p pd=1.54u as=0.42p ps=2.99u w=1.12u l=0.13u
X4613 A_uq30 a_34132_63620# VDD VDD sg13_lv_pmos ad=0.42p pd=2.99u as=0.2114p ps=1.54u w=1.12u l=0.13u
X4614 VDD a_39418_68307# D_uq54 VDD sg13_lv_pmos ad=0.2254p pd=1.53u as=0.4256p ps=3u w=1.12u l=0.13u
X4615 a_77245_19957# A1 C_uq9 VSS sg13_lv_nmos ad=0.1406p pd=1.12u as=0.2516p ps=2.16u w=0.74u l=0.13u
X4616 a_8071_42647# a_8071_42811# a_8107_42775# VSS sg13_lv_nmos ad=0.1428p pd=1.52u as=37.8f ps=0.6u w=0.42u l=0.13u
X4617 a_8075_38617# a_8111_38939# VDD VDD sg13_lv_pmos ad=0.34p pd=2.68u as=0.2254p ps=1.53u w=1u l=0.5u
X4618 VDD C_uq33 a_6585_34382# VDD sg13_lv_pmos ad=0.2856p pd=2.36u as=0.1596p ps=1.22u w=0.84u l=0.13u
X4619 a_42660_9149# B_uq17 a_42566_9149# VDD sg13_lv_pmos ad=0.1596p pd=1.22u as=0.2856p ps=2.36u w=0.84u l=0.13u
X4620 VDD X_uq220 a_8561_23135# VDD sg13_lv_pmos ad=0.2114p pd=1.54u as=0.2856p ps=2.36u w=0.84u l=0.13u
X4621 a_37392_65860# a_37366_65824# VSS VSS sg13_lv_nmos ad=0.2516p pd=2.16u as=0.1626p ps=1.415u w=0.74u l=0.13u
X4622 a_47302_68844# Q_uq42 VSS VSS sg13_lv_nmos ad=0.1428p pd=1.52u as=79.8f ps=0.8u w=0.42u l=0.13u
X4623 VSS a_49276_69850# a_48925_69707# VSS sg13_lv_nmos ad=79.8f pd=0.8u as=0.1428p ps=1.52u w=0.42u l=0.13u
X4624 a_45250_6863# Y_uq0 VDD VDD sg13_lv_pmos ad=0.2856p pd=2.36u as=0.2114p ps=1.54u w=0.84u l=0.13u
X4625 VDD a_79910_24544# a_80167_24687# VDD sg13_lv_pmos ad=1.59725p pd=10.05u as=79.8f ps=0.8u w=0.42u l=0.13u
X4626 VDD a_3550_40458# a_3546_41381# VDD sg13_lv_pmos ad=1.31615p pd=8.395u as=0.3864p ps=2.93u w=1.12u l=0.13u
X4627 VSS a_5523_21946# a_6190_22167# VSS sg13_lv_nmos ad=0.1406p pd=1.12u as=0.2516p ps=2.16u w=0.74u l=0.13u
X4628 a_52088_69594# Y_uq352 VSS VSS sg13_lv_nmos ad=0.187p pd=1.78u as=0.14875p ps=1.16u w=0.55u l=0.13u
X4629 VDD Q_uq10 a_8833_31967# VDD sg13_lv_pmos ad=0.2114p pd=1.54u as=0.2856p ps=2.36u w=0.84u l=0.13u
X4630 VSS a_5051_33721# X_uq294 VSS sg13_lv_nmos ad=0.1426p pd=1.16u as=0.2516p ps=2.16u w=0.74u l=0.13u
X4631 VSS a_4297_36991# a_4321_36711# VSS sg13_lv_nmos ad=79.8f pd=0.8u as=0.1428p ps=1.52u w=0.42u l=0.5u
X4632 Y_uq281 a_28186_65912# VSS VSS sg13_lv_nmos ad=0.1406p pd=1.12u as=0.17255p ps=1.25u w=0.74u l=0.13u
X4633 a_30369_64391# a_29427_64431# a_30275_64391# VDD sg13_lv_pmos ad=79.8f pd=0.8u as=0.1428p ps=1.52u w=0.42u l=0.13u
X4634 VSS X_uq148 a_40932_9965# VSS sg13_lv_nmos ad=0.17255p pd=1.25u as=0.187p ps=1.78u w=0.55u l=0.13u
X4635 a_42357_64391# a_42000_64348# VDD VDD sg13_lv_pmos ad=63f pd=0.72u as=0.1563p ps=1.22u w=0.42u l=0.13u
X4636 a_39070_66294# L_HI_uq20 VSS VSS sg13_lv_nmos ad=37.8f pd=0.6u as=79.8f ps=0.8u w=0.42u l=0.13u
X4637 a_8837_40975# a_8835_41852# a_8916_41358# VDD sg13_lv_pmos ad=79.8f pd=0.8u as=63f ps=0.72u w=0.42u l=0.13u
X4638 a_47864_66570# Y_uq331 VSS VSS sg13_lv_nmos ad=0.187p pd=1.78u as=0.14875p ps=1.16u w=0.55u l=0.13u
X4639 a_30364_69850# a_30107_69707# a_30526_69630# VSS sg13_lv_nmos ad=0.1428p pd=1.52u as=37.8f ps=0.6u w=0.42u l=0.13u
X4640 a_36610_7625# q[8] VSS VSS sg13_lv_nmos ad=0.187p pd=1.78u as=0.14875p ps=1.16u w=0.55u l=0.13u
X4641 Q_uq37 a_41526_67368# VSS VSS sg13_lv_nmos ad=0.2516p pd=2.16u as=0.1406p ps=1.12u w=0.74u l=0.13u
X4642 VDD din[19] a_75295_22205# VDD sg13_lv_pmos ad=0.2114p pd=1.54u as=0.2856p ps=2.36u w=0.84u l=0.13u
X4643 VSS X_uq433 a_36730_64400# VSS sg13_lv_nmos ad=0.17255p pd=1.25u as=0.187p ps=1.78u w=0.55u l=0.13u
X4644 a_11263_21623# C_uq16 VDD VDD sg13_lv_pmos ad=0.2128p pd=1.5u as=0.3808p ps=2.92u w=1.12u l=0.13u
X4645 VDD a_6559_42907# a_6559_42743# VDD sg13_lv_pmos ad=2.4956p pd=16.32u as=79.8f ps=0.8u w=0.42u l=0.13u
X4646 a_42806_68880# X_uq449 VDD VDD sg13_lv_pmos ad=0.1176p pd=1.33u as=0.4032p ps=2.96u w=1.12u l=0.13u
X4647 VSS X_uq431 Y_uq360 VSS sg13_lv_nmos ad=0.2618p pd=2.22u as=0.1694p ps=1.21u w=0.77u l=0.13u
X4648 VDD X_uq399 a_40762_64400# VDD sg13_lv_pmos ad=0.2618p pd=1.63u as=0.2856p ps=2.36u w=0.84u l=0.13u
X4649 VDD a_45755_69241# a_46012_69122# VDD sg13_lv_pmos ad=1.42837p pd=8.61u as=79.8f ps=0.8u w=0.42u l=0.13u
X4650 a_29830_65062# Q_uq58 VDD VDD sg13_lv_pmos ad=0.1428p pd=1.52u as=0.1523p ps=1.38u w=0.42u l=0.13u
X4651 VDD a_43522_9137# X_uq77 VDD sg13_lv_pmos ad=0.2114p pd=1.54u as=0.42p ps=2.99u w=1.12u l=0.13u
X4652 a_77138_26741# B1_uq6 VDD VDD sg13_lv_pmos ad=0.3808p pd=2.92u as=0.2128p ps=1.5u w=1.12u l=0.13u
X4653 a_5047_36571# a_5062_35274# a_5047_36237# VDD sg13_lv_pmos ad=0.2048p pd=1.63u as=0.34p ps=2.68u w=1u l=0.13u
X4654 VSS C_uq15 Y_uq41 VSS sg13_lv_nmos ad=0.2516p pd=2.16u as=0.1406p ps=1.12u w=0.74u l=0.13u
X4655 VSS a_28280_69594# X_uq455 VSS sg13_lv_nmos ad=0.14875p pd=1.16u as=0.2886p ps=2.26u w=0.74u l=0.13u
X4656 VSS Y_uq205 Y_uq203 VSS sg13_lv_nmos ad=0.2516p pd=2.16u as=0.1406p ps=1.12u w=0.74u l=0.13u
X4657 VDD Y_uq33 a_8945_17875# VDD sg13_lv_pmos ad=0.2114p pd=1.54u as=0.2856p ps=2.36u w=0.84u l=0.13u
X4658 a_79134_20780# a_79286_20664# VSS VSS sg13_lv_nmos ad=0.2516p pd=2.16u as=2.61888p ps=17.445u w=0.74u l=0.13u
X4659 VDD X_uq319 a_4297_35327# VDD sg13_lv_pmos ad=0.2114p pd=1.54u as=0.2856p ps=2.36u w=0.84u l=0.13u
X4660 VSS a_32696_66570# X_uq436 VSS sg13_lv_nmos ad=0.14875p pd=1.16u as=0.2886p ps=2.26u w=0.74u l=0.13u
X4661 a_7059_21480# a_6217_21130# a_6965_21480# VSS sg13_lv_nmos ad=0.12665p pd=1.145u as=0.1428p ps=1.52u w=0.42u l=0.13u
X4662 a_77053_22981# Y_uq80 Y_uq86 VSS sg13_lv_nmos ad=0.1406p pd=1.12u as=0.2516p ps=2.16u w=0.74u l=0.13u
X4663 a_5405_40939# X_uq326 VDD VDD sg13_lv_pmos ad=0.34p pd=2.68u as=0.19p ps=1.38u w=1u l=0.13u
X4664 VSS C_uq19 Y_uq109 VSS sg13_lv_nmos ad=0.1406p pd=1.12u as=0.1406p ps=1.12u w=0.74u l=0.13u
X4665 VDD X_uq293 a_3535_34847# VDD sg13_lv_pmos ad=0.2114p pd=1.54u as=0.2856p ps=2.36u w=0.84u l=0.13u
X4666 a_10468_36599# Y_uq186 VDD VDD sg13_lv_pmos ad=79.8f pd=0.8u as=1.17462p ps=7.44u w=0.42u l=0.13u
X4667 a_7316_21361# L_HI_uq2 VDD VDD sg13_lv_pmos ad=79.8f pd=0.8u as=1.37097p ps=8.54u w=0.42u l=0.13u
X4668 a_44792_69594# X_uq450 VSS VSS sg13_lv_nmos ad=0.187p pd=1.78u as=0.14875p ps=1.16u w=0.55u l=0.13u
X4669 a_30706_65107# L_HI_uq16 VSS VSS sg13_lv_nmos ad=37.8f pd=0.6u as=0.1701p ps=1.65u w=0.42u l=0.13u
X4670 VSS a_30033_67379# a_30135_67379# VSS sg13_lv_nmos ad=2.08687p pd=13.23u as=0.2516p ps=2.16u w=0.74u l=0.13u
X4671 VDD Y_uq234 a_8116_41079# VDD sg13_lv_pmos ad=0.1563p pd=1.22u as=0.147p ps=1.54u w=0.42u l=0.13u
X4672 a_38266_66795# a_38381_66796# VDD VDD sg13_lv_pmos ad=0.34p pd=2.68u as=0.2254p ps=1.53u w=1u l=0.5u
X4673 VDD a_8799_33220# X_uq284 VDD sg13_lv_pmos ad=0.2226p pd=1.535u as=0.3976p ps=2.95u w=1.12u l=0.13u
X4674 VSS Q_uq12 a_5809_33991# VSS sg13_lv_nmos ad=79.8f pd=0.8u as=0.1428p ps=1.52u w=0.42u l=0.13u
X4675 a_45094_65062# Q_uq36 VDD VDD sg13_lv_pmos ad=0.1428p pd=1.52u as=0.1523p ps=1.38u w=0.42u l=0.13u
X4676 VDD Y_uq235 a_5381_39104# VDD sg13_lv_pmos ad=0.2128p pd=1.5u as=0.2128p ps=1.5u w=1.12u l=0.13u
X4677 a_78181_21632# a_78296_21633# VDD VDD sg13_lv_pmos ad=0.34p pd=2.68u as=0.2254p ps=1.53u w=1u l=0.5u
X4678 a_29338_64782# a_29080_64782# VSS VSS sg13_lv_nmos ad=0.1428p pd=1.52u as=79.8f ps=0.8u w=0.42u l=0.13u
X4679 Y_uq34 D_uq7 VSS VSS sg13_lv_nmos ad=0.1694p pd=1.21u as=0.1463p ps=1.15u w=0.77u l=0.13u
X4680 a_40451_68927# a_39755_68851# a_40545_68927# VSS sg13_lv_nmos ad=0.1296p pd=1.52u as=79.8f ps=0.8u w=0.42u l=0.13u
X4681 Y_uq89 D_uq5 VSS VSS sg13_lv_nmos ad=0.2618p pd=2.22u as=0.1463p ps=1.15u w=0.77u l=0.13u
X4682 a_7357_40451# Q_uq25 a_7320_39999# VDD sg13_lv_pmos ad=0.1225p pd=1.245u as=0.34p ps=2.68u w=1u l=0.13u
X4683 X_uq198 a_12593_20899# VDD VDD sg13_lv_pmos ad=0.42p pd=2.99u as=0.2114p ps=1.54u w=1.12u l=0.13u
X4684 a_6559_42907# a_6574_41610# a_6595_42675# VSS sg13_lv_nmos ad=0.12665p pd=1.145u as=0.1428p ps=1.52u w=0.42u l=0.13u
X4685 Q_uq24 a_10345_43290# VSS VSS sg13_lv_nmos ad=0.2516p pd=2.16u as=0.1406p ps=1.12u w=0.74u l=0.13u
X4686 VSS a_40870_66574# a_40589_66796# VSS sg13_lv_nmos ad=79.8f pd=0.8u as=0.1428p ps=1.52u w=0.42u l=0.5u
X4687 a_43317_67415# a_42960_67372# VDD VDD sg13_lv_pmos ad=63f pd=0.72u as=0.1563p ps=1.22u w=0.42u l=0.13u
X4688 VDD X_uq83 a_38238_6937# VDD sg13_lv_pmos ad=0.2114p pd=1.54u as=0.2856p ps=2.36u w=0.84u l=0.13u
X4689 B a_37374_8449# VSS VSS sg13_lv_nmos ad=0.2886p pd=2.26u as=0.14875p ps=1.16u w=0.74u l=0.13u
X4690 VSS a_52156_67610# a_51805_67729# VSS sg13_lv_nmos ad=79.8f pd=0.8u as=0.1428p ps=1.52u w=0.42u l=0.13u
X4691 VDD Y_uq263 a_41060_65098# VDD sg13_lv_pmos ad=0.1523p pd=1.38u as=0.1428p ps=1.52u w=0.42u l=0.13u
X4692 q[12] a_36532_65132# VSS VSS sg13_lv_nmos ad=0.2886p pd=2.26u as=0.14875p ps=1.16u w=0.74u l=0.13u
X4693 VSS a_39683_69711# a_39683_69711# VSS sg13_lv_nmos ad=2.01085p pd=12.81u as=0.111p ps=1.34u w=0.3u l=0.13u
X4694 a_79045_28691# a_78787_28691# VSS VSS sg13_lv_nmos ad=0.1428p pd=1.52u as=79.8f ps=0.8u w=0.42u l=0.13u
X4695 a_75612_28253# Q_uq8 VDD VDD sg13_lv_pmos ad=0.2464p pd=1.56u as=0.3808p ps=2.92u w=1.12u l=0.13u
X4696 S a_9583_39834# VDD VDD sg13_lv_pmos ad=0.3808p pd=2.92u as=0.2128p ps=1.5u w=1.12u l=0.13u
X4697 a_29138_63586# a_28868_63586# VSS VSS sg13_lv_nmos ad=0.1428p pd=1.52u as=79.8f ps=0.8u w=0.42u l=0.5u
X4698 VSS a_38074_69147# X_uq430 VSS sg13_lv_nmos ad=0.1426p pd=1.16u as=0.2516p ps=2.16u w=0.74u l=0.13u
X4699 VSS a_7321_41297# A0 VSS sg13_lv_nmos ad=0.14875p pd=1.16u as=0.2886p ps=2.26u w=0.74u l=0.13u
X4700 a_37499_69707# a_36657_69609# a_36240_69948# VDD sg13_lv_pmos ad=0.2048p pd=1.63u as=0.34p ps=2.68u w=1u l=0.13u
X4701 a_6604_41175# a_6574_41610# a_6986_41550# VDD sg13_lv_pmos ad=79.8f pd=0.8u as=63f ps=0.72u w=0.42u l=0.13u
X4702 VSS a_3550_40458# a_3546_41381# VSS sg13_lv_nmos ad=5.43125p pd=35.255u as=0.2516p ps=2.16u w=0.74u l=0.13u
X4703 a_27608_68082# X_uq458 VDD VDD sg13_lv_pmos ad=0.2856p pd=2.36u as=0.2114p ps=1.54u w=0.84u l=0.13u
X4704 a_32592_69948# a_33111_69752# a_33851_69707# VSS sg13_lv_nmos ad=0.3473p pd=2.71u as=0.12665p ps=1.145u w=0.74u l=0.13u
X4705 a_49699_66570# a_50259_66824# a_50280_66570# VSS sg13_lv_nmos ad=0.12665p pd=1.145u as=0.3473p ps=2.71u w=0.74u l=0.13u
X4706 VSS a_45634_8375# B_uq2 VSS sg13_lv_nmos ad=0.14875p pd=1.16u as=0.2886p ps=2.26u w=0.74u l=0.13u
X4707 a_39418_68307# a_39533_68308# VSS VSS sg13_lv_nmos ad=0.1428p pd=1.52u as=0.1426p ps=1.16u w=0.42u l=0.5u
X4708 VDD a_78961_25470# L_HI_uq4 VDD sg13_lv_pmos ad=1.59725p pd=10.05u as=0.3927p ps=2.99u w=1.155u l=0.13u
X4709 a_6563_39963# A0_uq0 a_6599_40095# VSS sg13_lv_nmos ad=0.1628p pd=1.18u as=0.3367p ps=1.65u w=0.74u l=0.13u
X4710 a_4681_21848# clk VDD VDD sg13_lv_pmos ad=0.4088p pd=2.97u as=1.37097p ps=8.54u w=1.12u l=0.13u
X4711 VDD X_uq256 a_8561_23923# VDD sg13_lv_pmos ad=0.2114p pd=1.54u as=0.2856p ps=2.36u w=0.84u l=0.13u
X4712 a_50448_64348# a_50422_64312# VDD VDD sg13_lv_pmos ad=0.34p pd=2.68u as=0.36237p ps=2.605u w=1u l=0.13u
X4713 Y_uq266 X_uq435 VSS VSS sg13_lv_nmos ad=0.1694p pd=1.21u as=0.2618p ps=2.22u w=0.77u l=0.13u
X4714 a_48922_69147# a_49037_69146# VSS VSS sg13_lv_nmos ad=0.1428p pd=1.52u as=0.1426p ps=1.16u w=0.42u l=0.5u
X4715 A_uq57 a_33748_63620# VSS VSS sg13_lv_nmos ad=0.2886p pd=2.26u as=0.14875p ps=1.16u w=0.74u l=0.13u
X4716 a_50674_64769# L_HI_uq33 VSS VSS sg13_lv_nmos ad=37.8f pd=0.6u as=0.1701p ps=1.65u w=0.42u l=0.13u
X4717 a_80076_28300# L_HI_uq8 VDD VDD sg13_lv_pmos ad=0.147p pd=1.54u as=0.1563p ps=1.22u w=0.42u l=0.13u
X4718 VSS a_44938_10649# Y_uq28 VSS sg13_lv_nmos ad=0.17255p pd=1.25u as=0.1406p ps=1.12u w=0.74u l=0.13u
X4719 VDD a_50280_66570# a_51303_66997# VDD sg13_lv_pmos ad=0.1563p pd=1.22u as=63f ps=0.72u w=0.42u l=0.13u
X4720 Y_uq122 B_uq58 VSS VSS sg13_lv_nmos ad=0.1694p pd=1.21u as=0.2618p ps=2.22u w=0.77u l=0.13u
X4721 VDD a_7059_23458# a_7726_23679# VDD sg13_lv_pmos ad=0.2128p pd=1.5u as=0.3864p ps=2.93u w=1.12u l=0.13u
X4722 a_33851_69707# a_33009_69609# a_32592_69948# VDD sg13_lv_pmos ad=0.2048p pd=1.63u as=0.34p ps=2.68u w=1u l=0.13u
X4723 VSS a_5809_39675# B_uq91 VSS sg13_lv_nmos ad=0.148p pd=1.14u as=0.4033p ps=2.57u w=0.74u l=0.13u
X4724 VSS X_uq328 a_32382_8449# VSS sg13_lv_nmos ad=0.14875p pd=1.16u as=0.187p ps=1.78u w=0.55u l=0.13u
X4725 B_uq51 Y_uq137 a_76741_25577# VSS sg13_lv_nmos ad=0.2516p pd=2.16u as=0.1406p ps=1.12u w=0.74u l=0.13u
X4726 VDD X_uq449 a_42970_66648# VDD sg13_lv_pmos ad=0.2618p pd=1.63u as=0.2856p ps=2.36u w=0.84u l=0.13u
X4727 a_44482_6863# A_uq71 VSS VSS sg13_lv_nmos ad=0.187p pd=1.78u as=0.14875p ps=1.16u w=0.55u l=0.13u
X4728 VSS D_uq30 D_uq31 VSS sg13_lv_nmos ad=0.1463p pd=1.15u as=0.1694p ps=1.21u w=0.77u l=0.13u
X4729 a_51034_65094# a_50776_65094# VSS VSS sg13_lv_nmos ad=0.1428p pd=1.52u as=79.8f ps=0.8u w=0.42u l=0.13u
X4730 a_7357_31713# D_uq13 a_7357_31611# VDD sg13_lv_pmos ad=0.2128p pd=1.5u as=0.2128p ps=1.5u w=1.12u l=0.13u
X4731 a_33264_66924# a_33238_66829# VDD VDD sg13_lv_pmos ad=0.34p pd=2.68u as=0.36237p ps=2.605u w=1u l=0.13u
X4732 D_uq2 a_80301_23023# VSS VSS sg13_lv_nmos ad=0.2516p pd=2.16u as=0.1426p ps=1.16u w=0.74u l=0.13u
X4733 VSS X_uq220 a_8561_23135# VSS sg13_lv_nmos ad=0.14875p pd=1.16u as=0.187p ps=1.78u w=0.55u l=0.13u
X4734 VDD X_uq300 D_uq22 VDD sg13_lv_pmos ad=0.3808p pd=2.92u as=0.3808p ps=2.92u w=1.12u l=0.13u
X4735 VDD din[18] a_75295_22993# VDD sg13_lv_pmos ad=0.2114p pd=1.54u as=0.2856p ps=2.36u w=0.84u l=0.13u
X4736 Q_uq47 a_35382_64344# VDD VDD sg13_lv_pmos ad=0.3808p pd=2.92u as=0.2128p ps=1.5u w=1.12u l=0.13u
X4737 VSS A_uq89 a_34782_6937# VSS sg13_lv_nmos ad=0.14875p pd=1.16u as=0.187p ps=1.78u w=0.55u l=0.13u
X4738 VDD a_6098_22898# D_uq6 VDD sg13_lv_pmos ad=0.2254p pd=1.53u as=0.4256p ps=3u w=1.12u l=0.13u
X4739 VSS C_uq33 Y_uq159 VSS sg13_lv_nmos ad=0.2516p pd=2.16u as=0.2516p ps=2.16u w=0.74u l=0.13u
X4740 B_uq6 a_45150_8449# VSS VSS sg13_lv_nmos ad=0.2886p pd=2.26u as=0.14875p ps=1.16u w=0.74u l=0.13u
X4741 VDD B_uq63 a_10660_21679# VDD sg13_lv_pmos ad=0.2198p pd=1.53u as=0.2856p ps=2.36u w=0.84u l=0.13u
X4742 VSS Y_uq164 a_10819_31823# VSS sg13_lv_nmos ad=79.8f pd=0.8u as=37.8f ps=0.6u w=0.42u l=0.13u
X4743 a_44145_66649# a_44145_66649# VSS VSS sg13_lv_nmos ad=0.111p pd=1.34u as=1.8643p ps=11.96u w=0.3u l=0.13u
X4744 VDD a_38908_66098# a_38853_65979# VDD sg13_lv_pmos ad=1.41367p pd=8.85u as=93.45f ps=0.865u w=0.42u l=0.13u
X4745 VSS L_HI_uq22 a_28752_66294# VSS sg13_lv_nmos ad=0.1626p pd=1.415u as=60.89999f ps=0.71u w=0.42u l=0.13u
X4746 Q_uq14 a_8071_33402# VDD VDD sg13_lv_pmos ad=0.3808p pd=2.92u as=0.2128p ps=1.5u w=1.12u l=0.13u
X4747 VDD a_5051_41401# D_uq33 VDD sg13_lv_pmos ad=0.2254p pd=1.53u as=0.4256p ps=3u w=1.12u l=0.13u
X4748 VDD a_52376_68844# q[31] VDD sg13_lv_pmos ad=0.2114p pd=1.54u as=0.42p ps=2.99u w=1.12u l=0.13u
X4749 a_29330_69318# a_30135_68891# a_29590_68848# VDD sg13_lv_pmos ad=0.1428p pd=1.52u as=79.8f ps=0.8u w=0.42u l=0.13u
X4750 VDD a_5115_23462# a_5115_23696# VDD sg13_lv_pmos ad=1.02937p pd=6.325u as=0.2442p ps=2.06u w=0.66u l=0.13u
X4751 Y_uq19 a_40932_9965# VSS VSS sg13_lv_nmos ad=0.1406p pd=1.12u as=0.17255p ps=1.25u w=0.74u l=0.13u
X4752 VSS Y_uq289 Y_uq261 VSS sg13_lv_nmos ad=0.1463p pd=1.15u as=0.1694p ps=1.21u w=0.77u l=0.13u
X4753 a_4299_42044# clk VSS VSS sg13_lv_nmos ad=0.2516p pd=2.16u as=4.1981p ps=26.905u w=0.74u l=0.13u
X4754 a_79044_21489# X_uq208 VDD VDD sg13_lv_pmos ad=0.1596p pd=1.22u as=0.2856p ps=2.36u w=0.84u l=0.13u
X4755 a_76861_19529# Y_uq44 Y_uq47 VSS sg13_lv_nmos ad=0.1406p pd=1.12u as=0.2516p ps=2.16u w=0.74u l=0.13u
X4756 a_5869_40067# A0 a_5809_39675# VDD sg13_lv_pmos ad=0.3325p pd=1.665u as=0.2225p ps=1.445u w=1u l=0.13u
X4757 VDD a_5833_35135# a_5809_35317# VDD sg13_lv_pmos ad=0.2254p pd=1.53u as=0.34p ps=2.68u w=1u l=0.5u
X4758 VSS B_uq92 a_5087_37951# VSS sg13_lv_nmos ad=0.2516p pd=2.16u as=0.1406p ps=1.12u w=0.74u l=0.13u
X4759 a_5809_36127# Q_uq16 VDD VDD sg13_lv_pmos ad=0.1428p pd=1.52u as=0.1523p ps=1.38u w=0.42u l=0.13u
X4760 a_46306_9887# q[27] VDD VDD sg13_lv_pmos ad=0.2856p pd=2.36u as=0.2114p ps=1.54u w=0.84u l=0.13u
X4761 VDD B_uq89 B_uq87 VDD sg13_lv_pmos ad=0.2198p pd=1.53u as=0.2128p ps=1.5u w=1.12u l=0.13u
X4762 VDD a_41627_66217# a_42294_65856# VDD sg13_lv_pmos ad=0.2128p pd=1.5u as=0.3864p ps=2.93u w=1.12u l=0.13u
X4763 VSS C_uq15 Y_uq90 VSS sg13_lv_nmos ad=0.2516p pd=2.16u as=0.1406p ps=1.12u w=0.74u l=0.13u
X4764 X_uq240 a_8945_24647# VDD VDD sg13_lv_pmos ad=0.42p pd=2.99u as=0.2114p ps=1.54u w=1.12u l=0.13u
X4765 B_uq66 a_3788_24931# VSS VSS sg13_lv_nmos ad=0.2886p pd=2.26u as=0.14875p ps=1.16u w=0.74u l=0.13u
X4766 VDD a_31619_63663# a_31619_63897# VDD sg13_lv_pmos ad=1.4745p pd=9.07u as=0.2442p ps=2.06u w=0.66u l=0.13u
X4767 Y_uq57 D_uq1 a_11680_21159# VDD sg13_lv_pmos ad=0.3808p pd=2.92u as=0.2128p ps=1.5u w=1.12u l=0.13u
X4768 VSS a_43522_9137# X_uq77 VSS sg13_lv_nmos ad=0.14875p pd=1.16u as=0.2886p ps=2.26u w=0.74u l=0.13u
X4769 a_43908_10301# B_uq15 a_43814_10301# VDD sg13_lv_pmos ad=0.1596p pd=1.22u as=0.2856p ps=2.36u w=0.84u l=0.13u
X4770 Y_uq70 A_N VSS VSS sg13_lv_nmos ad=0.1694p pd=1.21u as=0.2618p ps=2.22u w=0.77u l=0.13u
X4771 VDD a_49778_65098# a_49890_65162# VDD sg13_lv_pmos ad=0.2254p pd=1.53u as=0.34p ps=2.68u w=1u l=0.5u
X4772 Q_uq42 a_46422_68880# VSS VSS sg13_lv_nmos ad=0.2516p pd=2.16u as=0.1406p ps=1.12u w=0.74u l=0.13u
X4773 VDD Y_uq119 a_11633_25435# VDD sg13_lv_pmos ad=0.2114p pd=1.54u as=0.2856p ps=2.36u w=0.84u l=0.13u
X4774 VSS Y_uq285 Y_uq272 VSS sg13_lv_nmos ad=0.1463p pd=1.15u as=0.1694p ps=1.21u w=0.77u l=0.13u
X4775 Y_uq62 X_uq197 VDD VDD sg13_lv_pmos ad=0.3808p pd=2.92u as=0.3808p ps=2.92u w=1.12u l=0.13u
X4776 VSS C_uq24 a_10343_22419# VSS sg13_lv_nmos ad=0.18575p pd=1.26u as=0.187p ps=1.78u w=0.55u l=0.13u
X4777 VSS X_uq451 C_uq69 VSS sg13_lv_nmos ad=0.2516p pd=2.16u as=0.1406p ps=1.12u w=0.74u l=0.13u
X4778 X_uq311 a_3539_39543# VDD VDD sg13_lv_pmos ad=0.4256p pd=3u as=0.2254p ps=1.53u w=1.12u l=0.13u
X4779 VSS VDD VSS VSS sg13_lv_nmos ad=79.8f pd=0.8u as=0 ps=-0 w=0.42u l=1u
X4780 Y_uq366 Q_uq60 VSS VSS sg13_lv_nmos ad=0.2516p pd=2.16u as=0.2516p ps=2.16u w=0.74u l=0.13u
X4781 a_9583_41879# Y_uq228 VDD VDD sg13_lv_pmos ad=79.8f pd=0.8u as=1.17462p ps=7.44u w=0.42u l=0.13u
X4782 a_50256_64782# D_uq37 a_50162_64782# VSS sg13_lv_nmos ad=60.89999f pd=0.71u as=0.1428p ps=1.52u w=0.42u l=0.13u
X4783 Y_uq263 X_uq447 VSS VSS sg13_lv_nmos ad=0.1694p pd=1.21u as=0.2618p ps=2.22u w=0.77u l=0.13u
X4784 VSS a_7059_21480# a_7726_21119# VSS sg13_lv_nmos ad=0.1406p pd=1.12u as=0.2516p ps=2.16u w=0.74u l=0.13u
X4785 VSS a_8832_34225# B_uq73 VSS sg13_lv_nmos ad=0.3108p pd=2.32u as=0.1628p ps=1.18u w=0.74u l=0.13u
X4786 SLN[9] a_32596_63620# VDD VDD sg13_lv_pmos ad=0.42p pd=2.99u as=0.2114p ps=1.54u w=1.12u l=0.13u
X4787 VSS VDD VSS VSS sg13_lv_nmos ad=79.8f pd=0.8u as=0 ps=-0 w=0.42u l=1u
X4788 a_35246_10067# B_uq30 a_35388_10301# VDD sg13_lv_pmos ad=0.2856p pd=2.36u as=0.1596p ps=1.22u w=0.84u l=0.13u
X4789 VSS X_uq84 a_37470_6937# VSS sg13_lv_nmos ad=0.14875p pd=1.16u as=0.187p ps=1.78u w=0.55u l=0.13u
X4790 Y_uq317 X_uq407 a_48376_66904# VDD sg13_lv_pmos ad=0.3808p pd=2.92u as=0.1176p ps=1.33u w=1.12u l=0.13u
X4791 a_10385_35049# a_10349_35023# VSS VSS sg13_lv_nmos ad=0.2516p pd=2.16u as=0.1626p ps=1.415u w=0.74u l=0.13u
X4792 VDD Y_uq169 a_6604_31479# VDD sg13_lv_pmos ad=0.1563p pd=1.22u as=0.147p ps=1.54u w=0.42u l=0.13u
X4793 D_uq3 C_uq13 VSS VSS sg13_lv_nmos ad=0.2618p pd=2.22u as=0.1463p ps=1.15u w=0.77u l=0.13u
X4794 a_42016_10221# X_uq144 Y_uq18 VDD sg13_lv_pmos ad=0.1176p pd=1.33u as=0.3808p ps=2.92u w=1.12u l=0.13u
X4795 VDD a_37756_69850# a_37701_69945# VDD sg13_lv_pmos ad=1.6733p pd=10.405u as=93.45f ps=0.865u w=0.42u l=0.13u
X4796 VDD a_46545_65867# a_46647_65867# VDD sg13_lv_pmos ad=1.41367p pd=8.85u as=0.3864p ps=2.93u w=1.12u l=0.13u
X4797 a_6098_22898# a_6213_22897# VDD VDD sg13_lv_pmos ad=0.34p pd=2.68u as=0.2254p ps=1.53u w=1u l=0.5u
X4798 X_uq24 a_37086_6937# VSS VSS sg13_lv_nmos ad=0.2886p pd=2.26u as=0.14875p ps=1.16u w=0.74u l=0.13u
X4799 a_7705_35257# B_uq81 VSS VSS sg13_lv_nmos ad=0.1406p pd=1.12u as=0.1406p ps=1.12u w=0.74u l=0.13u
X4800 Y_uq306 a_42970_66648# VSS VSS sg13_lv_nmos ad=0.1406p pd=1.12u as=0.17255p ps=1.25u w=0.74u l=0.13u
X4801 VDD Q_uq48 Y_uq347 VDD sg13_lv_pmos ad=0.3808p pd=2.92u as=0.3808p ps=2.92u w=1.12u l=0.13u
X4802 X_uq157 a_35838_10685# VSS VSS sg13_lv_nmos ad=0.2886p pd=2.26u as=0.14875p ps=1.16u w=0.74u l=0.13u
X4803 VSS VDD VSS VSS sg13_lv_nmos ad=79.8f pd=0.8u as=0 ps=-0 w=0.42u l=1u
X4804 VDD A_uq391 a_27316_66644# VDD sg13_lv_pmos ad=0.2114p pd=1.54u as=0.2856p ps=2.36u w=0.84u l=0.13u
X4805 a_9619_31795# a_9583_31769# VSS VSS sg13_lv_nmos ad=0.1428p pd=1.52u as=79.8f ps=0.8u w=0.42u l=0.13u
X4806 a_8116_41079# a_8086_41514# a_8107_40811# VSS sg13_lv_nmos ad=79.8f pd=0.8u as=0.1296p ps=1.52u w=0.42u l=0.13u
X4807 VSS Y_uq37 Y_uq47 VSS sg13_lv_nmos ad=0.1406p pd=1.12u as=0.2516p ps=2.16u w=0.74u l=0.13u
X4808 a_34223_65856# Y_uq277 a_34121_65856# VDD sg13_lv_pmos ad=0.2464p pd=1.56u as=0.2128p ps=1.5u w=1.12u l=0.13u
X4809 a_48728_65820# Q_uq41 VSS VSS sg13_lv_nmos ad=0.187p pd=1.78u as=0.14875p ps=1.16u w=0.55u l=0.13u
X4810 VDD a_38414_9489# X_uq83 VDD sg13_lv_pmos ad=0.2226p pd=1.535u as=0.3976p ps=2.95u w=1.12u l=0.13u
X4811 VSS a_38530_8375# B_uq3 VSS sg13_lv_nmos ad=0.14875p pd=1.16u as=0.2886p ps=2.26u w=0.74u l=0.13u
X4812 Y_uq141 X_uq276 VDD VDD sg13_lv_pmos ad=0.3808p pd=2.92u as=0.3808p ps=2.92u w=1.12u l=0.13u
X4813 VSS a_34766_10067# A_uq92 VSS sg13_lv_nmos ad=0.1469p pd=1.155u as=0.2516p ps=2.16u w=0.74u l=0.13u
X4814 VSS VDD VSS VSS sg13_lv_nmos ad=0.1428p pd=1.52u as=0 ps=-0 w=0.42u l=1u
X4815 a_43354_65283# a_43469_65284# VSS VSS sg13_lv_nmos ad=0.1428p pd=1.52u as=0.1426p ps=1.16u w=0.42u l=0.5u
X4816 a_7321_35905# C1_uq8 VSS VSS sg13_lv_nmos ad=0.1216p pd=1.02u as=0.15745p ps=1.175u w=0.64u l=0.13u
X4817 Y_uq306 X_uq397 a_43192_66904# VDD sg13_lv_pmos ad=0.3808p pd=2.92u as=0.1176p ps=1.33u w=1.12u l=0.13u
X4818 D_uq34 C_uq43 VSS VSS sg13_lv_nmos ad=0.2618p pd=2.22u as=0.1463p ps=1.15u w=0.77u l=0.13u
X4819 VDD Q_uq44 a_36532_65132# VDD sg13_lv_pmos ad=0.2114p pd=1.54u as=0.2856p ps=2.36u w=0.84u l=0.13u
X4820 a_76837_27789# B1_uq5 a_76939_27789# VDD sg13_lv_pmos ad=0.3808p pd=2.92u as=0.2128p ps=1.5u w=1.12u l=0.13u
X4821 a_52568_69594# Y_uq351 VSS VSS sg13_lv_nmos ad=0.187p pd=1.78u as=0.14875p ps=1.16u w=0.55u l=0.13u
X4822 VDD X_uq148 a_40932_9965# VDD sg13_lv_pmos ad=0.2618p pd=1.63u as=0.2856p ps=2.36u w=0.84u l=0.13u
X4823 a_43810_10649# q[22] VSS VSS sg13_lv_nmos ad=0.187p pd=1.78u as=0.14875p ps=1.16u w=0.55u l=0.13u
X4824 X_uq179 a_75679_18457# VDD VDD sg13_lv_pmos ad=0.42p pd=2.99u as=0.2114p ps=1.54u w=1.12u l=0.13u
X4825 a_41026_6863# X_uq64 VSS VSS sg13_lv_nmos ad=0.187p pd=1.78u as=0.14875p ps=1.16u w=0.55u l=0.13u
X4826 a_7478_23381# L_HI_uq3 VSS VSS sg13_lv_nmos ad=37.8f pd=0.6u as=79.8f ps=0.8u w=0.42u l=0.13u
X4827 VDD B_uq84 D_uq30 VDD sg13_lv_pmos ad=0.3808p pd=2.92u as=0.2128p ps=1.5u w=1.12u l=0.13u
X4828 a_42926_10067# B_uq9 a_43068_10301# VDD sg13_lv_pmos ad=0.2856p pd=2.36u as=0.1596p ps=1.22u w=0.84u l=0.13u
X4829 VDD a_10852_23191# D_uq5 VDD sg13_lv_pmos ad=0.3808p pd=2.92u as=0.2128p ps=1.5u w=1.12u l=0.13u
X4830 a_76534_26717# B2_uq9 Y_uq137 VDD sg13_lv_pmos ad=0.2744p pd=1.61u as=0.2128p ps=1.5u w=1.12u l=0.13u
X4831 a_3880_24147# a_3854_24111# VDD VDD sg13_lv_pmos ad=0.34p pd=2.68u as=0.36237p ps=2.605u w=1u l=0.13u
X4832 Y_uq152 X_uq268 VDD VDD sg13_lv_pmos ad=0.3808p pd=2.92u as=0.3808p ps=2.92u w=1.12u l=0.13u
X4833 a_80167_26983# a_79910_27102# a_80329_27179# VSS sg13_lv_nmos ad=0.1428p pd=1.52u as=37.8f ps=0.6u w=0.42u l=0.13u
X4834 a_7357_39708# D_uq30 a_7357_39594# VDD sg13_lv_pmos ad=0.2128p pd=1.5u as=0.2464p ps=1.56u w=1.12u l=0.13u
X4835 VDD Y_uq310 a_33748_63620# VDD sg13_lv_pmos ad=0.2114p pd=1.54u as=0.2856p ps=2.36u w=0.84u l=0.13u
X4836 a_28748_64631# a_28867_64308# VDD VDD sg13_lv_pmos ad=0.3864p pd=2.93u as=0.2128p ps=1.5u w=1.12u l=0.13u
X4837 a_80112_26864# a_79170_26752# a_79910_27102# VDD sg13_lv_pmos ad=93.45f pd=0.865u as=0.2048p ps=1.63u w=0.42u l=0.13u
X4838 Q_uq47 a_35382_64344# VSS VSS sg13_lv_nmos ad=0.2516p pd=2.16u as=0.1406p ps=1.12u w=0.74u l=0.13u
X4839 VSS X_uq346 a_37758_10685# VSS sg13_lv_nmos ad=0.14875p pd=1.16u as=0.187p ps=1.78u w=0.55u l=0.13u
X4840 L_HI_uq3 a_5314_23633# VDD VDD sg13_lv_pmos ad=0.3927p pd=2.99u as=1.02937p ps=6.325u w=1.155u l=0.13u
X4841 VSS a_47265_67415# a_46344_67729# VSS sg13_lv_nmos ad=0.1626p pd=1.415u as=0.2516p ps=2.16u w=0.74u l=0.13u
X4842 Y_uq119 C_uq21 VSS VSS sg13_lv_nmos ad=0.2618p pd=2.22u as=0.1463p ps=1.15u w=0.77u l=0.13u
X4843 a_76154_20693# C_uq23 a_76052_20693# VDD sg13_lv_pmos ad=0.2464p pd=1.56u as=0.2128p ps=1.5u w=1.12u l=0.13u
X4844 VDD a_44024_63546# X_uq339 VDD sg13_lv_pmos ad=0.2114p pd=1.54u as=0.42p ps=2.99u w=1.12u l=0.13u
X4845 VDD a_46418_66610# a_46530_66674# VDD sg13_lv_pmos ad=0.2254p pd=1.53u as=0.34p ps=2.68u w=1u l=0.5u
X4846 VDD B_uq67 a_76555_19181# VDD sg13_lv_pmos ad=0.3808p pd=2.92u as=0.2128p ps=1.5u w=1.12u l=0.13u
X4847 a_77698_21489# X_uq201 a_77604_21489# VSS sg13_lv_nmos ad=0.1216p pd=1.02u as=0.2176p ps=1.96u w=0.64u l=0.13u
X4848 Y_uq95 C_uq8 VSS VSS sg13_lv_nmos ad=0.1406p pd=1.12u as=0.2516p ps=2.16u w=0.74u l=0.13u
X4849 VSS D_uq7 Y_uq49 VSS sg13_lv_nmos ad=0.1463p pd=1.15u as=0.1694p ps=1.21u w=0.77u l=0.13u
X4850 VDD a_36059_66217# a_36726_65856# VDD sg13_lv_pmos ad=0.2128p pd=1.5u as=0.3864p ps=2.93u w=1.12u l=0.13u
X4851 VSS VDD VSS VSS sg13_lv_nmos ad=0.1428p pd=1.52u as=0 ps=-0 w=0.42u l=1u
X4852 q[29] a_44884_66644# VDD VDD sg13_lv_pmos ad=0.42p pd=2.99u as=0.2114p ps=1.54u w=1.12u l=0.13u
X4853 X_uq177 a_9233_18599# VSS VSS sg13_lv_nmos ad=0.2886p pd=2.26u as=0.14875p ps=1.16u w=0.74u l=0.13u
X4854 VSS din[26] a_75679_18457# VSS sg13_lv_nmos ad=0.14875p pd=1.16u as=0.187p ps=1.78u w=0.55u l=0.13u
X4855 X_uq93 a_34014_7661# VSS VSS sg13_lv_nmos ad=0.2886p pd=2.26u as=0.14875p ps=1.16u w=0.74u l=0.13u
X4856 X_uq29 a_35166_6937# VDD VDD sg13_lv_pmos ad=0.42p pd=2.99u as=0.2114p ps=1.54u w=1.12u l=0.13u
X4857 Y A_uq75 a_43650_8709# VDD sg13_lv_pmos ad=0.3808p pd=2.92u as=0.1176p ps=1.33u w=1.12u l=0.13u
X4858 a_45176_63546# Y_uq290 VDD VDD sg13_lv_pmos ad=0.2856p pd=2.36u as=0.2114p ps=1.54u w=0.84u l=0.13u
X4859 VSS VDD VSS VSS sg13_lv_nmos ad=79.8f pd=0.8u as=0 ps=-0 w=0.42u l=1u
X4860 VSS Y_uq342 D_uq63 VSS sg13_lv_nmos ad=0.1463p pd=1.15u as=0.1694p ps=1.21u w=0.77u l=0.13u
X4861 VDD X_uq319 a_5047_40319# VDD sg13_lv_pmos ad=0.2114p pd=1.54u as=0.2856p ps=2.36u w=0.84u l=0.13u
X4862 a_36528_69643# a_36240_69948# a_36466_69643# VSS sg13_lv_nmos ad=0.1428p pd=1.52u as=37.8f ps=0.6u w=0.42u l=0.13u
X4863 a_5083_36535# Y_uq189 VSS VSS sg13_lv_nmos ad=37.8f pd=0.6u as=79.8f ps=0.8u w=0.42u l=0.13u
X4864 VDD Y_uq232 a_8916_41546# VDD sg13_lv_pmos ad=0.36237p pd=2.605u as=79.8f ps=0.8u w=0.42u l=0.13u
X4865 VDD a_3539_38143# a_3575_38075# VDD sg13_lv_pmos ad=0.1523p pd=1.38u as=0.34p ps=2.68u w=1u l=0.5u
X4866 VSS B_uq5 a_35534_9489# VSS sg13_lv_nmos ad=0.187p pd=1.78u as=0.1045p ps=0.93u w=0.55u l=0.13u
X4867 a_79982_22252# L_HI VDD VDD sg13_lv_pmos ad=79.8f pd=0.8u as=0.36237p ps=2.605u w=0.42u l=0.13u
X4868 a_10010_38094# a_9583_39117# VDD VDD sg13_lv_pmos ad=63f pd=0.72u as=0.1563p ps=1.22u w=0.42u l=0.13u
X4869 A2_uq1 a_77248_23741# VDD VDD sg13_lv_pmos ad=0.3808p pd=2.92u as=0.3822p ps=1.84u w=1.12u l=0.13u
X4870 Y_uq133 C_uq18 VSS VSS sg13_lv_nmos ad=0.2618p pd=2.22u as=0.1463p ps=1.15u w=0.77u l=0.13u
X4871 a_41602_8375# X_uq164 VSS VSS sg13_lv_nmos ad=0.187p pd=1.78u as=0.14875p ps=1.16u w=0.55u l=0.13u
X4872 VDD a_47387_66217# a_48054_65856# VDD sg13_lv_pmos ad=0.2128p pd=1.5u as=0.3864p ps=2.93u w=1.12u l=0.13u
X4873 VDD a_7346_24410# X_uq237 VDD sg13_lv_pmos ad=0.2254p pd=1.53u as=0.4256p ps=3u w=1.12u l=0.13u
X4874 VSS Y_uq174 a_4771_32169# VSS sg13_lv_nmos ad=0.1626p pd=1.415u as=60.89999f ps=0.71u w=0.42u l=0.13u
X4875 Q_uq25 a_8071_43194# VDD VDD sg13_lv_pmos ad=0.3808p pd=2.92u as=0.2128p ps=1.5u w=1.12u l=0.13u
X4876 a_48728_63546# Y_uq358 VDD VDD sg13_lv_pmos ad=0.2856p pd=2.36u as=0.2114p ps=1.54u w=0.84u l=0.13u
X4877 VDD q[17] a_38910_10685# VDD sg13_lv_pmos ad=0.2114p pd=1.54u as=0.2856p ps=2.36u w=0.84u l=0.13u
X4878 VSS a_7321_37166# C1_uq8 VSS sg13_lv_nmos ad=0.1331p pd=1.12u as=0.2516p ps=2.16u w=0.74u l=0.13u
X4879 a_46786_7625# Y_uq27 VDD VDD sg13_lv_pmos ad=0.2856p pd=2.36u as=0.2114p ps=1.54u w=0.84u l=0.13u
X4880 VSS C1_uq4 Y_uq52 VSS sg13_lv_nmos ad=0.2516p pd=2.16u as=0.1406p ps=1.12u w=0.74u l=0.13u
X4881 a_79040_25567# a_79164_25266# VDD VDD sg13_lv_pmos ad=0.2442p pd=2.06u as=1.59725p ps=10.05u w=0.66u l=0.13u
X4882 a_6215_39807# a_5833_39781# VSS VSS sg13_lv_nmos ad=0.3367p pd=1.65u as=0.148p ps=1.14u w=0.74u l=0.13u
X4883 a_32880_69643# a_32592_69948# a_32818_69643# VSS sg13_lv_nmos ad=0.1428p pd=1.52u as=37.8f ps=0.6u w=0.42u l=0.13u
X4884 a_43186_67793# L_HI_uq27 VSS VSS sg13_lv_nmos ad=37.8f pd=0.6u as=0.1701p ps=1.65u w=0.42u l=0.13u
X4885 VDD X_uq168 a_33348_10301# VDD sg13_lv_pmos ad=0.2226p pd=1.535u as=0.1596p ps=1.22u w=0.84u l=0.13u
X4886 VDD a_30107_69707# a_30774_69928# VDD sg13_lv_pmos ad=0.2128p pd=1.5u as=0.3864p ps=2.93u w=1.12u l=0.13u
X4887 a_78651_24785# a_78625_24690# VSS VSS sg13_lv_nmos ad=0.2516p pd=2.16u as=0.1626p ps=1.415u w=0.74u l=0.13u
X4888 X_uq433 a_34804_68880# VSS VSS sg13_lv_nmos ad=0.2886p pd=2.26u as=0.14875p ps=1.16u w=0.74u l=0.13u
X4889 a_44482_7625# X_uq145 VSS VSS sg13_lv_nmos ad=0.187p pd=1.78u as=0.14875p ps=1.16u w=0.55u l=0.13u
X4890 VSS a_41866_10649# Y_uq29 VSS sg13_lv_nmos ad=0.17255p pd=1.25u as=0.1406p ps=1.12u w=0.74u l=0.13u
X4891 a_8075_34111# Y_uq178 VSS VSS sg13_lv_nmos ad=0.1428p pd=1.52u as=79.8f ps=0.8u w=0.42u l=0.13u
X4892 a_35093_63528# a_35217_63625# VDD VDD sg13_lv_pmos ad=0.2442p pd=2.06u as=1.4745p ps=9.07u w=0.66u l=0.13u
X4893 a_28754_65098# a_28484_65098# VSS VSS sg13_lv_nmos ad=0.1428p pd=1.52u as=79.8f ps=0.8u w=0.42u l=0.5u
X4894 a_40368_65860# a_40342_65824# VSS VSS sg13_lv_nmos ad=0.2516p pd=2.16u as=0.1626p ps=1.415u w=0.74u l=0.13u
X4895 VSS a_30598_68086# a_30317_68308# VSS sg13_lv_nmos ad=79.8f pd=0.8u as=0.1428p ps=1.52u w=0.42u l=0.5u
X4896 a_6025_20655# X_uq259 VDD VDD sg13_lv_pmos ad=0.2464p pd=1.56u as=0.3808p ps=2.92u w=1.12u l=0.13u
X4897 VSS a_8835_41852# a_8871_41783# VSS sg13_lv_nmos ad=4.17695p pd=26.495u as=0.2516p ps=2.16u w=0.74u l=0.13u
X4898 VDD a_51292_68338# a_51237_68433# VDD sg13_lv_pmos ad=1.42837p pd=8.61u as=93.45f ps=0.865u w=0.42u l=0.13u
X4899 a_76555_19181# B2 a_76453_19181# VDD sg13_lv_pmos ad=0.2128p pd=1.5u as=0.2128p ps=1.5u w=1.12u l=0.13u
X4900 q[15] a_38356_63620# VDD VDD sg13_lv_pmos ad=0.42p pd=2.99u as=0.2114p ps=1.54u w=1.12u l=0.13u
X4901 VSS X_uq449 a_42970_66648# VSS sg13_lv_nmos ad=0.17255p pd=1.25u as=0.187p ps=1.78u w=0.55u l=0.13u
X4902 a_47367_67415# a_46475_67339# a_47265_67415# VDD sg13_lv_pmos ad=63f pd=0.72u as=79.8f ps=0.8u w=0.42u l=0.13u
X4903 VDD a_4152_22595# a_4110_22631# VDD sg13_lv_pmos ad=0.2618p pd=1.63u as=0.1176p ps=1.33u w=1.12u l=0.13u
X4904 a_3688_24581# D_uq8 a_3594_24581# VSS sg13_lv_nmos ad=60.89999f pd=0.71u as=0.1428p ps=1.52u w=0.42u l=0.13u
X4905 VDD a_33850_65283# X_uq379 VDD sg13_lv_pmos ad=0.2254p pd=1.53u as=0.4256p ps=3u w=1.12u l=0.13u
X4906 a_50444_65269# a_50563_65058# VDD VDD sg13_lv_pmos ad=0.3864p pd=2.93u as=0.2128p ps=1.5u w=1.12u l=0.13u
X4907 Y_uq211 Y_uq208 VSS VSS sg13_lv_nmos ad=0.1406p pd=1.12u as=0.2516p ps=2.16u w=0.74u l=0.13u
X4908 C_uq36 a_7321_33423# VDD VDD sg13_lv_pmos ad=0.3808p pd=2.92u as=0.3808p ps=2.92u w=1.12u l=0.13u
X4909 a_42046_66294# L_HI_uq14 VSS VSS sg13_lv_nmos ad=37.8f pd=0.6u as=79.8f ps=0.8u w=0.42u l=0.13u
X4910 VSS a_8833_42996# a_8833_43098# VSS sg13_lv_nmos ad=0.1406p pd=1.12u as=0.2516p ps=2.16u w=0.74u l=0.13u
X4911 a_29973_68927# a_29616_68884# VDD VDD sg13_lv_pmos ad=63f pd=0.72u as=0.1563p ps=1.22u w=0.42u l=0.13u
X4912 A_uq71 a_43334_10301# VDD VDD sg13_lv_pmos ad=0.3976p pd=2.95u as=0.2226p ps=1.535u w=1.12u l=0.13u
X4913 VDD a_50086_69121# L_HI_uq31 VDD sg13_lv_pmos ad=1.42837p pd=8.61u as=0.3927p ps=2.99u w=1.155u l=0.13u
X4914 a_36261_65979# a_35319_65867# a_36059_66217# VDD sg13_lv_pmos ad=93.45f pd=0.865u as=0.2048p ps=1.63u w=0.42u l=0.13u
X4915 VDD a_48646_67332# a_48365_67634# VDD sg13_lv_pmos ad=0.1523p pd=1.38u as=0.34p ps=2.68u w=1u l=0.5u
X4916 a_8833_34465# D_uq25 VSS VSS sg13_lv_nmos ad=0.1216p pd=1.02u as=0.15745p ps=1.175u w=0.64u l=0.13u
X4917 VSS a_43330_6863# X_uq8 VSS sg13_lv_nmos ad=0.14875p pd=1.16u as=0.2886p ps=2.26u w=0.74u l=0.13u
X4918 a_50736_64769# a_50448_64348# a_50674_64769# VSS sg13_lv_nmos ad=0.1428p pd=1.52u as=37.8f ps=0.6u w=0.42u l=0.13u
X4919 VDD X_uq399 a_43450_66648# VDD sg13_lv_pmos ad=0.2618p pd=1.63u as=0.2856p ps=2.36u w=0.84u l=0.13u
X4920 VSS VDD VSS VSS sg13_lv_nmos ad=79.8f pd=0.8u as=0 ps=-0 w=0.42u l=1u
X4921 a_5932_42743# Y_uq237 VDD VDD sg13_lv_pmos ad=79.8f pd=0.8u as=1.86053p ps=12.055u w=0.42u l=0.13u
X4922 a_47474_69630# D_uq60 VDD VDD sg13_lv_pmos ad=79.8f pd=0.8u as=0.1428p ps=1.52u w=0.42u l=0.13u
X4923 a_9609_34825# D_uq23 VDD VDD sg13_lv_pmos ad=0.1596p pd=1.22u as=0.36195p ps=1.84u w=0.84u l=0.13u
X4924 a_6604_31479# a_6574_31914# a_6595_31211# VSS sg13_lv_nmos ad=79.8f pd=0.8u as=0.1296p ps=1.52u w=0.42u l=0.13u
X4925 a_32216_68082# Q_uq59 VDD VDD sg13_lv_pmos ad=0.2856p pd=2.36u as=0.2114p ps=1.54u w=0.84u l=0.13u
X4926 a_9632_37963# Y_uq210 VSS VSS sg13_lv_nmos ad=37.8f pd=0.6u as=0.1701p ps=1.65u w=0.42u l=0.13u
X4927 VSS VDD VSS VSS sg13_lv_nmos ad=0.1428p pd=1.52u as=0 ps=-0 w=0.42u l=1u
X4928 VDD a_8833_42996# a_8956_42551# VDD sg13_lv_pmos ad=1.5243p pd=9.795u as=79.8f ps=0.8u w=0.42u l=0.13u
X4929 X_uq178 a_8849_18599# VDD VDD sg13_lv_pmos ad=0.42p pd=2.99u as=0.2114p ps=1.54u w=1.12u l=0.13u
X4930 Y_uq338 a_37498_68936# VSS VSS sg13_lv_nmos ad=0.1406p pd=1.12u as=0.17255p ps=1.25u w=0.74u l=0.13u
X4931 Q_uq19 a_8833_38394# VDD VDD sg13_lv_pmos ad=0.3808p pd=2.92u as=0.2128p ps=1.5u w=1.12u l=0.13u
X4932 VSS a_3539_37753# X_uq304 VSS sg13_lv_nmos ad=0.1426p pd=1.16u as=0.2516p ps=2.16u w=0.74u l=0.13u
X4933 VDD a_41218_8375# X_uq63 VDD sg13_lv_pmos ad=0.2114p pd=1.54u as=0.42p ps=2.99u w=1.12u l=0.13u
X4934 a_7346_24410# a_7461_24409# VDD VDD sg13_lv_pmos ad=0.34p pd=2.68u as=0.2254p ps=1.53u w=1u l=0.5u
X4935 a_79701_29255# a_79502_29318# VSS VSS sg13_lv_nmos ad=0.27427p pd=2.28u as=2.70687p ps=17.445u w=0.795u l=0.13u
X4936 VDD a_35110_67609# L_HI_uq30 VDD sg13_lv_pmos ad=1.19383p pd=7.16u as=0.3927p ps=2.99u w=1.155u l=0.13u
X4937 a_9619_37451# a_9594_39077# a_9628_37719# VDD sg13_lv_pmos ad=0.1428p pd=1.52u as=79.8f ps=0.8u w=0.42u l=0.13u
X4938 VDD a_3575_39179# a_3539_39543# VDD sg13_lv_pmos ad=0.2254p pd=1.53u as=0.34p ps=2.68u w=1u l=0.5u
X4939 a_37126_68086# Y_uq324 VSS VSS sg13_lv_nmos ad=0.1428p pd=1.52u as=79.8f ps=0.8u w=0.42u l=0.13u
X4940 a_9895_18965# C VSS VSS sg13_lv_nmos ad=0.1406p pd=1.12u as=0.18575p ps=1.26u w=0.74u l=0.13u
X4941 a_40642_7625# A_uq94 VDD VDD sg13_lv_pmos ad=0.2856p pd=2.36u as=0.2114p ps=1.54u w=0.84u l=0.13u
X4942 a_28748_64631# a_28867_64308# VSS VSS sg13_lv_nmos ad=0.2516p pd=2.16u as=0.1406p ps=1.12u w=0.74u l=0.13u
X4943 a_5514_21557# a_6319_21130# a_5774_21087# VDD sg13_lv_pmos ad=0.1428p pd=1.52u as=79.8f ps=0.8u w=0.42u l=0.13u
X4944 a_5608_24893# D_uq9 a_5514_24893# VSS sg13_lv_nmos ad=60.89999f pd=0.71u as=0.1428p ps=1.52u w=0.42u l=0.13u
X4945 a_8111_34591# B_uq79 VSS VSS sg13_lv_nmos ad=0.1406p pd=1.12u as=0.2516p ps=2.16u w=0.74u l=0.13u
X4946 VSS Q_uq48 Y_uq347 VSS sg13_lv_nmos ad=0.2516p pd=2.16u as=0.2516p ps=2.16u w=0.74u l=0.13u
X4947 a_8075_34111# Y_uq178 VDD VDD sg13_lv_pmos ad=0.1428p pd=1.52u as=0.1523p ps=1.38u w=0.42u l=0.13u
X4948 a_6563_38009# Y_uq205 VSS VSS sg13_lv_nmos ad=0.187p pd=1.78u as=0.17255p ps=1.25u w=0.55u l=0.13u
X4949 VDD a_5811_42044# a_5847_41975# VDD sg13_lv_pmos ad=1.86053p pd=12.055u as=0.3864p ps=2.93u w=1.12u l=0.13u
X4950 A_uq38 a_44500_66644# VSS VSS sg13_lv_nmos ad=0.2886p pd=2.26u as=0.14875p ps=1.16u w=0.74u l=0.13u
X4951 a_9583_31769# a_9583_31324# VDD VDD sg13_lv_pmos ad=79.8f pd=0.8u as=1.17462p ps=7.44u w=0.42u l=0.13u
X4952 a_39600_67372# a_40119_67379# a_40859_67729# VSS sg13_lv_nmos ad=0.3473p pd=2.71u as=0.12665p ps=1.145u w=0.74u l=0.13u
X4953 VSS a_7292_38117# X_uq303 VSS sg13_lv_nmos ad=0.1371p pd=1.12u as=0.2516p ps=2.16u w=0.74u l=0.13u
X4954 Y_uq35 C_uq5 VSS VSS sg13_lv_nmos ad=0.1406p pd=1.12u as=0.2516p ps=2.16u w=0.74u l=0.13u
X4955 D_uq28 a_4297_39287# VSS VSS sg13_lv_nmos ad=0.1406p pd=1.12u as=0.17255p ps=1.25u w=0.74u l=0.13u
X4956 a_8837_40975# a_8835_41852# a_8916_41546# VSS sg13_lv_nmos ad=79.8f pd=0.8u as=0.1296p ps=1.52u w=0.42u l=0.13u
X4957 a_47644_66098# L_HI_uq13 VDD VDD sg13_lv_pmos ad=79.8f pd=0.8u as=1.41367p ps=8.85u w=0.42u l=0.13u
X4958 VDD a_37499_69707# a_38166_69928# VDD sg13_lv_pmos ad=0.2128p pd=1.5u as=0.3864p ps=2.93u w=1.12u l=0.13u
X4959 VDD a_44408_64308# q[19] VDD sg13_lv_pmos ad=0.2114p pd=1.54u as=0.42p ps=2.99u w=1.12u l=0.13u
X4960 a_9235_35163# Y_uq219 Y_uq178 VSS sg13_lv_nmos ad=0.1406p pd=1.12u as=0.2516p ps=2.16u w=0.74u l=0.13u
X4961 VSS a_46018_6863# X_uq1 VSS sg13_lv_nmos ad=0.14875p pd=1.16u as=0.2886p ps=2.26u w=0.74u l=0.13u
X4962 a_33621_66997# a_33264_66924# VDD VDD sg13_lv_pmos ad=63f pd=0.72u as=0.1563p ps=1.22u w=0.42u l=0.13u
X4963 Y_uq322 X_uq447 VSS VSS sg13_lv_nmos ad=0.1694p pd=1.21u as=0.2618p ps=2.22u w=0.77u l=0.13u
X4964 a_46808_69594# X_uq450 VDD VDD sg13_lv_pmos ad=0.2856p pd=2.36u as=0.2114p ps=1.54u w=0.84u l=0.13u
X4965 VSS a_3579_22936# a_3579_22936# VSS sg13_lv_nmos ad=1.6335p pd=10.61u as=0.111p ps=1.34u w=0.3u l=0.13u
X4966 Y_uq141 X_uq276 VSS VSS sg13_lv_nmos ad=0.2516p pd=2.16u as=0.2516p ps=2.16u w=0.74u l=0.13u
X4967 VDD Q_uq51 Y_uq356 VDD sg13_lv_pmos ad=0.3808p pd=2.92u as=0.3808p ps=2.92u w=1.12u l=0.13u
X4968 a_6599_40417# X_uq314 a_6563_39963# VSS sg13_lv_nmos ad=0.13135p pd=1.095u as=0.1628p ps=1.18u w=0.74u l=0.13u
X4969 a_5047_36407# Y_uq189 VDD VDD sg13_lv_pmos ad=79.8f pd=0.8u as=1.86053p ps=12.055u w=0.42u l=0.13u
X4970 a_32792_68082# X_uq432 VSS VSS sg13_lv_nmos ad=0.187p pd=1.78u as=0.14875p ps=1.16u w=0.55u l=0.13u
X4971 VDD a_29315_66687# a_29315_66921# VDD sg13_lv_pmos ad=1.19383p pd=7.16u as=0.2442p ps=2.06u w=0.66u l=0.13u
X4972 VDD a_8075_39007# a_8111_38939# VDD sg13_lv_pmos ad=0.1523p pd=1.38u as=0.34p ps=2.68u w=1u l=0.5u
X4973 VSS L_HI_uq40 a_28656_69630# VSS sg13_lv_nmos ad=0.1626p pd=1.415u as=60.89999f ps=0.71u w=0.42u l=0.13u
X4974 D_uq18 D_uq14 a_7357_31815# VDD sg13_lv_pmos ad=0.4368p pd=3.02u as=0.2128p ps=1.5u w=1.12u l=0.13u
X4975 a_29330_69318# D_uq59 VDD VDD sg13_lv_pmos ad=79.8f pd=0.8u as=0.1428p ps=1.52u w=0.42u l=0.13u
X4976 VDD a_42562_7625# X_uq44 VDD sg13_lv_pmos ad=0.2114p pd=1.54u as=0.42p ps=2.99u w=1.12u l=0.13u
X4977 a_46786_8375# Y_uq26 VDD VDD sg13_lv_pmos ad=0.2856p pd=2.36u as=0.2114p ps=1.54u w=0.84u l=0.13u
X4978 a_8120_31531# Y_uq163 VSS VSS sg13_lv_nmos ad=37.8f pd=0.6u as=0.1701p ps=1.65u w=0.42u l=0.13u
X4979 C_uq57 X_uq420 VSS VSS sg13_lv_nmos ad=0.1406p pd=1.12u as=0.2516p ps=2.16u w=0.74u l=0.13u
X4980 Y_uq208 Y_uq206 a_5087_38335# VSS sg13_lv_nmos ad=0.2516p pd=2.16u as=0.1406p ps=1.12u w=0.74u l=0.13u
X4981 a_5809_39675# X_uq313 a_5869_39807# VDD sg13_lv_pmos ad=0.2225p pd=1.445u as=0.2975p ps=1.595u w=1u l=0.13u
X4982 a_52718_65094# L_HI_uq17 VSS VSS sg13_lv_nmos ad=60.89999f pd=0.71u as=0.1626p ps=1.415u w=0.42u l=0.13u
X4983 VDD Y_uq35 a_9233_18599# VDD sg13_lv_pmos ad=0.2114p pd=1.54u as=0.2856p ps=2.36u w=0.84u l=0.13u
X4984 VDD a_41410_6863# X_uq13 VDD sg13_lv_pmos ad=0.2114p pd=1.54u as=0.42p ps=2.99u w=1.12u l=0.13u
X4985 a_5047_36571# a_5062_35274# a_5083_36339# VSS sg13_lv_nmos ad=0.12665p pd=1.145u as=0.1428p ps=1.52u w=0.42u l=0.13u
X4986 a_35726_10067# B_uq29 a_35868_10301# VDD sg13_lv_pmos ad=0.2856p pd=2.36u as=0.1596p ps=1.22u w=0.84u l=0.13u
X4987 VDD a_33851_69707# a_34518_69928# VDD sg13_lv_pmos ad=0.2128p pd=1.5u as=0.3864p ps=2.93u w=1.12u l=0.13u
X4988 C_uq8 A_N VDD VDD sg13_lv_pmos ad=0.2128p pd=1.5u as=0.2198p ps=1.53u w=1.12u l=0.13u
X4989 VSS A_uq75 a_43814_10301# VSS sg13_lv_nmos ad=0.1469p pd=1.155u as=0.1045p ps=0.93u w=0.55u l=0.13u
X4990 C_uq62 X_uq450 VSS VSS sg13_lv_nmos ad=0.1406p pd=1.12u as=0.2516p ps=2.16u w=0.74u l=0.13u
X4991 VDD X_uq319 Y_uq172 VDD sg13_lv_pmos ad=0.3808p pd=2.92u as=0.3808p ps=2.92u w=1.12u l=0.13u
X4992 a_45755_69241# a_44913_68891# a_45661_69241# VSS sg13_lv_nmos ad=0.12665p pd=1.145u as=0.1428p ps=1.52u w=0.42u l=0.13u
X4993 a_4681_21156# a_4681_21156# VSS VSS sg13_lv_nmos ad=0.111p pd=1.34u as=2.0486p ps=12.405u w=0.3u l=0.13u
X4994 a_28867_64308# a_29427_64431# a_29448_64705# VSS sg13_lv_nmos ad=0.12665p pd=1.145u as=0.3473p ps=2.71u w=0.74u l=0.13u
X4995 VDD a_10345_37044# a_10345_37146# VDD sg13_lv_pmos ad=0.2128p pd=1.5u as=0.3864p ps=2.93u w=1.12u l=0.13u
X4996 VDD a_10078_21061# C_uq5 VDD sg13_lv_pmos ad=0.2128p pd=1.5u as=0.3808p ps=2.92u w=1.12u l=0.13u
X4997 VDD X_uq399 a_40186_65136# VDD sg13_lv_pmos ad=0.2618p pd=1.63u as=0.2856p ps=2.36u w=0.84u l=0.13u
X4998 VDD a_78757_29192# X_uq279 VDD sg13_lv_pmos ad=0.2254p pd=1.53u as=0.4256p ps=3u w=1.12u l=0.13u
X4999 VDD Y_uq164 a_10468_31961# VDD sg13_lv_pmos ad=1.17462p pd=7.44u as=79.8f ps=0.8u w=0.42u l=0.13u
X5000 Y_uq289 a_43450_66648# VSS VSS sg13_lv_nmos ad=0.1406p pd=1.12u as=0.17255p ps=1.25u w=0.74u l=0.13u
X5001 X_uq262 a_75295_26017# VDD VDD sg13_lv_pmos ad=0.42p pd=2.99u as=0.2114p ps=1.54u w=1.12u l=0.13u
X5002 a_34800_65860# a_34774_65824# VSS VSS sg13_lv_nmos ad=0.2516p pd=2.16u as=0.1626p ps=1.415u w=0.74u l=0.13u
X5003 VSS Y_uq45 a_77245_19957# VSS sg13_lv_nmos ad=0.2516p pd=2.16u as=0.1406p ps=1.12u w=0.74u l=0.13u
X5004 Y_uq176 D_uq30 VSS VSS sg13_lv_nmos ad=0.1406p pd=1.12u as=0.2516p ps=2.16u w=0.74u l=0.13u
X5005 a_41026_7625# Y_uq30 VSS VSS sg13_lv_nmos ad=0.187p pd=1.78u as=0.14875p ps=1.16u w=0.55u l=0.13u
X5006 a_37838_8555# X_uq162 VSS VSS sg13_lv_nmos ad=0.1045p pd=0.93u as=0.1469p ps=1.155u w=0.55u l=0.13u
X5007 a_30526_69630# L_HI_uq40 VSS VSS sg13_lv_nmos ad=37.8f pd=0.6u as=79.8f ps=0.8u w=0.42u l=0.13u
X5008 a_78574_28217# a_79134_28340# a_79155_28614# VSS sg13_lv_nmos ad=0.12665p pd=1.145u as=0.3473p ps=2.71u w=0.74u l=0.13u
X5009 VDD a_5047_33019# a_5047_33402# VDD sg13_lv_pmos ad=0.2128p pd=1.5u as=0.3864p ps=2.93u w=1.12u l=0.13u
X5010 VDD D_uq18 a_3571_33467# VDD sg13_lv_pmos ad=0.1428p pd=1.52u as=79.8f ps=0.8u w=0.42u l=0.13u
X5011 X_uq276 a_76351_29041# VDD VDD sg13_lv_pmos ad=0.42p pd=2.99u as=0.2114p ps=1.54u w=1.12u l=0.13u
X5012 a_10345_37457# Y_uq192 VSS VSS sg13_lv_nmos ad=0.187p pd=1.78u as=0.14875p ps=1.16u w=0.55u l=0.13u
X5013 a_46714_65283# a_46829_65284# VDD VDD sg13_lv_pmos ad=0.34p pd=2.68u as=0.2254p ps=1.53u w=1u l=0.5u
X5014 Q_uq45 a_35286_68416# VDD VDD sg13_lv_pmos ad=0.3808p pd=2.92u as=0.2128p ps=1.5u w=1.12u l=0.13u
X5015 Q a_6190_22167# VSS VSS sg13_lv_nmos ad=0.2516p pd=2.16u as=0.1406p ps=1.12u w=0.74u l=0.13u
X5016 VDD L_HI_uq11 a_37942_64312# VDD sg13_lv_pmos ad=0.1563p pd=1.22u as=0.147p ps=1.54u w=0.42u l=0.13u
X5017 a_36478_66294# L_HI_uq15 VSS VSS sg13_lv_nmos ad=37.8f pd=0.6u as=79.8f ps=0.8u w=0.42u l=0.13u
X5018 B_uq51 Q_uq3 a_76953_25229# VDD sg13_lv_pmos ad=0.3808p pd=2.92u as=0.2128p ps=1.5u w=1.12u l=0.13u
X5019 A_uq24 a_36436_63620# VSS VSS sg13_lv_nmos ad=0.2886p pd=2.26u as=0.14875p ps=1.16u w=0.74u l=0.13u
X5020 a_33170_64782# a_33975_64355# a_33430_64312# VDD sg13_lv_pmos ad=0.1428p pd=1.52u as=79.8f ps=0.8u w=0.42u l=0.13u
X5021 a_34726_67332# Q_uq45 VSS VSS sg13_lv_nmos ad=0.1428p pd=1.52u as=79.8f ps=0.8u w=0.42u l=0.13u
X5022 VDD X_uq448 a_46330_68160# VDD sg13_lv_pmos ad=0.2618p pd=1.63u as=0.2856p ps=2.36u w=0.84u l=0.13u
X5023 a_41154_10221# a_40932_9965# VDD VDD sg13_lv_pmos ad=0.1176p pd=1.33u as=0.2618p ps=1.63u w=1.12u l=0.13u
X5024 a_78941_22959# a_78671_22959# VDD VDD sg13_lv_pmos ad=0.34p pd=2.68u as=0.1523p ps=1.38u w=1u l=0.5u
X5025 VDD a_79043_25943# C_uq23 VDD sg13_lv_pmos ad=0.2114p pd=1.54u as=0.42p ps=2.99u w=1.12u l=0.13u
X5026 C_uq59 Q_uq37 VSS VSS sg13_lv_nmos ad=0.1406p pd=1.12u as=0.2516p ps=2.16u w=0.74u l=0.13u
X5027 Y_uq289 Q_uq31 a_43672_66904# VDD sg13_lv_pmos ad=0.3808p pd=2.92u as=0.1176p ps=1.33u w=1.12u l=0.13u
X5028 a_11455_24183# X_uq236 VDD VDD sg13_lv_pmos ad=0.2128p pd=1.5u as=0.3808p ps=2.92u w=1.12u l=0.13u
X5029 a_48758_66904# X_uq450 VDD VDD sg13_lv_pmos ad=0.1176p pd=1.33u as=0.4032p ps=2.96u w=1.12u l=0.13u
X5030 a_34520_68844# X_uq431 VDD VDD sg13_lv_pmos ad=0.2856p pd=2.36u as=0.2114p ps=1.54u w=0.84u l=0.13u
X5031 VDD a_34876_68338# a_34821_68433# VDD sg13_lv_pmos ad=1.42837p pd=8.61u as=93.45f ps=0.865u w=0.42u l=0.13u
X5032 VSS SLN[9] a_34686_10685# VSS sg13_lv_nmos ad=0.14875p pd=1.16u as=0.187p ps=1.78u w=0.55u l=0.13u
X5033 a_46128_65860# a_46102_65824# VSS VSS sg13_lv_nmos ad=0.2516p pd=2.16u as=0.1626p ps=1.415u w=0.74u l=0.13u
X5034 a_50563_65058# a_51123_65312# a_51144_65058# VSS sg13_lv_nmos ad=0.12665p pd=1.145u as=0.3473p ps=2.71u w=0.74u l=0.13u
X5035 Y_uq270 Y_uq271 VSS VSS sg13_lv_nmos ad=0.1694p pd=1.21u as=0.1463p ps=1.15u w=0.77u l=0.13u
X5036 a_42934_67336# a_43377_67379# a_42674_67806# VSS sg13_lv_nmos ad=79.8f pd=0.8u as=0.1296p ps=1.52u w=0.42u l=0.13u
X5037 VSS X_uq208 Y_uq74 VSS sg13_lv_nmos ad=0.2516p pd=2.16u as=0.1406p ps=1.12u w=0.74u l=0.13u
X5038 VDD a_80197_23984# X_uq215 VDD sg13_lv_pmos ad=0.2254p pd=1.53u as=0.4256p ps=3u w=1.12u l=0.13u
X5039 VDD a_42779_69707# a_43036_69850# VDD sg13_lv_pmos ad=1.6733p pd=10.405u as=79.8f ps=0.8u w=0.42u l=0.13u
X5040 VSS C_uq67 D_uq59 VSS sg13_lv_nmos ad=0.1463p pd=1.15u as=0.2618p ps=2.22u w=0.77u l=0.13u
X5041 VSS din[5] a_76351_29041# VSS sg13_lv_nmos ad=0.14875p pd=1.16u as=0.187p ps=1.78u w=0.55u l=0.13u
X5042 a_51964_64586# L_HI_uq33 VDD VDD sg13_lv_pmos ad=79.8f pd=0.8u as=1.4745p ps=9.07u w=0.42u l=0.13u
X5043 q[5] a_27604_63620# VDD VDD sg13_lv_pmos ad=0.42p pd=2.99u as=0.2114p ps=1.54u w=1.12u l=0.13u
X5044 VDD a_5062_31722# a_5058_32645# VDD sg13_lv_pmos ad=1.86053p pd=12.055u as=0.3864p ps=2.93u w=1.12u l=0.13u
X5045 VDD a_51144_65058# a_52167_65485# VDD sg13_lv_pmos ad=0.1563p pd=1.22u as=63f ps=0.72u w=0.42u l=0.13u
X5046 VSS C_uq16 Y_uq40 VSS sg13_lv_nmos ad=0.2618p pd=2.22u as=0.1694p ps=1.21u w=0.77u l=0.13u
X5047 VSS Y_uq272 a_49508_65897# VSS sg13_lv_nmos ad=79.8f pd=0.8u as=0.1428p ps=1.52u w=0.42u l=0.13u
X5048 VSS a_52565_66552# a_52486_66827# VSS sg13_lv_nmos ad=1.8643p pd=11.96u as=0.27427p ps=2.28u w=0.795u l=0.13u
X5049 VDD X_uq82 a_39006_6937# VDD sg13_lv_pmos ad=0.2114p pd=1.54u as=0.2856p ps=2.36u w=0.84u l=0.13u
X5050 VSS a_51704_69594# q[28] VSS sg13_lv_nmos ad=0.14875p pd=1.16u as=0.2886p ps=2.26u w=0.74u l=0.13u
X5051 a_49137_64344# X_uq445 VDD VDD sg13_lv_pmos ad=0.2464p pd=1.56u as=0.3808p ps=2.92u w=1.12u l=0.13u
X5052 a_44964_9149# B_uq2 a_44870_9149# VDD sg13_lv_pmos ad=0.1596p pd=1.22u as=0.2856p ps=2.36u w=0.84u l=0.13u
X5053 X_uq197 a_75295_20693# VDD VDD sg13_lv_pmos ad=0.42p pd=2.99u as=0.2114p ps=1.54u w=1.12u l=0.13u
X5054 a_35674_66795# a_35789_66796# VDD VDD sg13_lv_pmos ad=0.34p pd=2.68u as=0.2254p ps=1.53u w=1u l=0.5u
X5055 a_80593_23681# Q_uq2 VDD VDD sg13_lv_pmos ad=0.1428p pd=1.52u as=0.1523p ps=1.38u w=0.42u l=0.13u
X5056 VDD a_48914_65098# a_49026_65162# VDD sg13_lv_pmos ad=0.2254p pd=1.53u as=0.34p ps=2.68u w=1u l=0.5u
X5057 a_34774_65824# a_35217_65867# a_35157_65903# VDD sg13_lv_pmos ad=79.8f pd=0.8u as=63f ps=0.72u w=0.42u l=0.13u
X5058 VDD clk a_9598_32468# VDD sg13_lv_pmos ad=1.12945p pd=7.155u as=0.4088p ps=2.97u w=1.12u l=0.13u
X5059 a_11340_18599# D_uq7 a_11238_18599# VDD sg13_lv_pmos ad=0.2464p pd=1.56u as=0.2128p ps=1.5u w=1.12u l=0.13u
X5060 Q_uq2 a_80577_24765# VSS VSS sg13_lv_nmos ad=0.2516p pd=2.16u as=0.1406p ps=1.12u w=0.74u l=0.13u
X5061 VSS Q_uq34 Y_uq265 VSS sg13_lv_nmos ad=0.2516p pd=2.16u as=0.2516p ps=2.16u w=0.74u l=0.13u
X5062 a_4703_37834# B_uq86 VSS VSS sg13_lv_nmos ad=0.1406p pd=1.12u as=0.14505p ps=1.15u w=0.74u l=0.13u
X5063 X_uq313 a_6585_39650# VDD VDD sg13_lv_pmos ad=0.3808p pd=2.92u as=0.1918p ps=1.5u w=1.12u l=0.13u
X5064 VDD Y_uq22 a_37854_6937# VDD sg13_lv_pmos ad=0.2114p pd=1.54u as=0.2856p ps=2.36u w=0.84u l=0.13u
X5065 X_uq222 a_75295_23717# VSS VSS sg13_lv_nmos ad=0.2886p pd=2.26u as=0.14875p ps=1.16u w=0.74u l=0.13u
X5066 VSS a_6194_25922# D_uq9 VSS sg13_lv_nmos ad=0.1426p pd=1.16u as=0.2516p ps=2.16u w=0.74u l=0.13u
X5067 VDD clk a_79286_20664# VDD sg13_lv_pmos ad=2.04445p pd=13.405u as=0.4088p ps=2.97u w=1.12u l=0.13u
X5068 VDD A2 a_76747_23253# VDD sg13_lv_pmos ad=0.3808p pd=2.92u as=0.2128p ps=1.5u w=1.12u l=0.13u
X5069 C_uq48 X_uq397 VSS VSS sg13_lv_nmos ad=0.1406p pd=1.12u as=0.2516p ps=2.16u w=0.74u l=0.13u
X5070 VDD a_50168_63546# A_uq44 VDD sg13_lv_pmos ad=0.2114p pd=1.54u as=0.42p ps=2.99u w=1.12u l=0.13u
X5071 VSS A_uq88 Y_uq22 VSS sg13_lv_nmos ad=0.2516p pd=2.16u as=0.1406p ps=1.12u w=0.74u l=0.13u
X5072 a_8075_33721# a_8111_34043# VSS VSS sg13_lv_nmos ad=0.1428p pd=1.52u as=0.1426p ps=1.16u w=0.42u l=0.5u
X5073 a_39226_63771# a_39341_63772# VSS VSS sg13_lv_nmos ad=0.1428p pd=1.52u as=0.1426p ps=1.16u w=0.42u l=0.5u
X5074 VSS a_5833_34271# a_5809_34453# VSS sg13_lv_nmos ad=0.1426p pd=1.16u as=0.1428p ps=1.52u w=0.42u l=0.5u
X5075 L_HI_uq25 a_29514_66858# VDD VDD sg13_lv_pmos ad=0.3927p pd=2.99u as=1.19383p ps=7.16u w=1.155u l=0.13u
X5076 VSS VDD VSS VSS sg13_lv_nmos ad=0.1428p pd=1.52u as=0 ps=-0 w=0.42u l=1u
X5077 a_8849_39933# D_uq25 VDD VDD sg13_lv_pmos ad=0.2128p pd=1.5u as=0.3808p ps=2.92u w=1.12u l=0.15u
X5078 VSS a_44408_64308# q[19] VSS sg13_lv_nmos ad=0.14875p pd=1.16u as=0.2886p ps=2.26u w=0.74u l=0.13u
X5079 a_50614_67336# a_51057_67379# a_50354_67806# VSS sg13_lv_nmos ad=79.8f pd=0.8u as=0.1296p ps=1.52u w=0.42u l=0.13u
X5080 VDD VSS VDD VDD sg13_lv_pmos ad=0.19p pd=1.38u as=0 ps=0 w=1u l=1u
X5081 a_10661_35594# a_10385_35049# a_10806_35275# VSS sg13_lv_nmos ad=0.1428p pd=1.52u as=37.8f ps=0.6u w=0.42u l=0.13u
X5082 a_8833_38292# a_8835_37148# a_8873_36297# VDD sg13_lv_pmos ad=0.2048p pd=1.63u as=0.34p ps=2.68u w=1u l=0.13u
X5083 VSS L_HI_uq9 a_47810_64769# VSS sg13_lv_nmos ad=0.1701p pd=1.65u as=37.8f ps=0.6u w=0.42u l=0.13u
X5084 a_51610_63771# a_51725_63772# VDD VDD sg13_lv_pmos ad=0.34p pd=2.68u as=0.2254p ps=1.53u w=1u l=0.5u
X5085 VDD L_HI_uq17 a_50776_65094# VDD sg13_lv_pmos ad=1.41367p pd=8.85u as=79.8f ps=0.8u w=0.42u l=0.13u
X5086 VDD L_HI_uq10 a_41974_64312# VDD sg13_lv_pmos ad=0.1563p pd=1.22u as=0.147p ps=1.54u w=0.42u l=0.13u
X5087 a_46402_8375# A_uq15 VSS VSS sg13_lv_nmos ad=0.187p pd=1.78u as=0.14875p ps=1.16u w=0.55u l=0.13u
X5088 a_78113_24765# C_uq29 VDD VDD sg13_lv_pmos ad=0.1176p pd=1.33u as=0.4032p ps=2.96u w=1.12u l=0.13u
X5089 a_28752_66294# D_uq46 a_28658_66294# VSS sg13_lv_nmos ad=60.89999f pd=0.71u as=0.1428p ps=1.52u w=0.42u l=0.13u
X5090 a_44219_67729# a_43377_67379# a_42960_67372# VDD sg13_lv_pmos ad=0.2048p pd=1.63u as=0.34p ps=2.68u w=1u l=0.13u
X5091 VSS a_46012_69122# a_45661_69241# VSS sg13_lv_nmos ad=79.8f pd=0.8u as=0.1428p ps=1.52u w=0.42u l=0.13u
X5092 X_uq343 a_40468_63620# VSS VSS sg13_lv_nmos ad=0.2886p pd=2.26u as=0.14875p ps=1.16u w=0.74u l=0.13u
X5093 a_40258_8375# X_uq145 VSS VSS sg13_lv_nmos ad=0.187p pd=1.78u as=0.14875p ps=1.16u w=0.55u l=0.13u
X5094 Y_uq178 Y_uq219 VDD VDD sg13_lv_pmos ad=0.2128p pd=1.5u as=0.3808p ps=2.92u w=1.12u l=0.13u
X5095 a_78757_29192# a_78872_29193# VSS VSS sg13_lv_nmos ad=0.1428p pd=1.52u as=0.1426p ps=1.16u w=0.42u l=0.5u
X5096 VDD L_HI_uq29 a_36242_67806# VDD sg13_lv_pmos ad=0.36237p pd=2.605u as=79.8f ps=0.8u w=0.42u l=0.13u
X5097 Y_uq295 Q_uq37 a_40408_65392# VDD sg13_lv_pmos ad=0.3808p pd=2.92u as=0.1176p ps=1.33u w=1.12u l=0.13u
X5098 VSS a_37934_9489# X_uq84 VSS sg13_lv_nmos ad=0.1469p pd=1.155u as=0.2516p ps=2.16u w=0.74u l=0.13u
X5099 VDD X_uq168 a_33828_10301# VDD sg13_lv_pmos ad=0.2226p pd=1.535u as=0.1596p ps=1.22u w=0.84u l=0.13u
X5100 a_44032_8709# A_uq75 Y_uq0 VDD sg13_lv_pmos ad=0.1176p pd=1.33u as=0.3808p ps=2.92u w=1.12u l=0.13u
X5101 X_uq382 a_52098_65880# VSS VSS sg13_lv_nmos ad=0.2516p pd=2.16u as=0.1426p ps=1.16u w=0.74u l=0.13u
X5102 a_34270_69630# L_HI_uq39 VSS VSS sg13_lv_nmos ad=37.8f pd=0.6u as=79.8f ps=0.8u w=0.42u l=0.13u
X5103 Y_uq88 X_uq221 VSS VSS sg13_lv_nmos ad=0.2516p pd=2.16u as=0.2516p ps=2.16u w=0.74u l=0.13u
X5104 a_36226_7625# q[7] VDD VDD sg13_lv_pmos ad=0.2856p pd=2.36u as=0.2114p ps=1.54u w=0.84u l=0.13u
X5105 Y_uq104 Q_uq2 VDD VDD sg13_lv_pmos ad=0.3808p pd=2.92u as=0.3808p ps=2.92u w=1.12u l=0.13u
X5106 a_6574_41610# clk VDD VDD sg13_lv_pmos ad=0.4088p pd=2.97u as=2.24605p ps=14.69u w=1.12u l=0.13u
X5107 VDD X_uq436 a_28463_68880# VDD sg13_lv_pmos ad=0.3808p pd=2.92u as=0.2464p ps=1.56u w=1.12u l=0.13u
X5108 a_78577_21411# Q_uq6 VDD VDD sg13_lv_pmos ad=0.1428p pd=1.52u as=0.1523p ps=1.38u w=0.42u l=0.13u
X5109 a_78757_23984# a_78872_23983# VDD VDD sg13_lv_pmos ad=0.34p pd=2.68u as=0.2254p ps=1.53u w=1u l=0.5u
X5110 VSS a_31907_69711# a_31907_69711# VSS sg13_lv_nmos ad=2.01085p pd=12.81u as=0.111p ps=1.34u w=0.3u l=0.13u
X5111 a_41410_6863# Y_uq19 VDD VDD sg13_lv_pmos ad=0.2856p pd=2.36u as=0.2114p ps=1.54u w=0.84u l=0.13u
X5112 VSS Q_uq8 C1_uq6 VSS sg13_lv_nmos ad=0.2618p pd=2.22u as=0.1694p ps=1.21u w=0.77u l=0.13u
X5113 VDD X_uq420 a_28186_65912# VDD sg13_lv_pmos ad=0.2618p pd=1.63u as=0.2856p ps=2.36u w=0.84u l=0.13u
X5114 a_4771_42871# Y_uq238 VSS VSS sg13_lv_nmos ad=37.8f pd=0.6u as=79.8f ps=0.8u w=0.42u l=0.13u
X5115 a_12533_24647# C_uq15 Y_uq107 VDD sg13_lv_pmos ad=0.1176p pd=1.33u as=0.3808p ps=2.92u w=1.12u l=0.13u
X5116 VSS X_uq399 a_43450_66648# VSS sg13_lv_nmos ad=0.17255p pd=1.25u as=0.187p ps=1.78u w=0.55u l=0.13u
X5117 a_45411_64344# Y_uq246 a_45297_64344# VDD sg13_lv_pmos ad=0.2128p pd=1.5u as=0.2464p ps=1.56u w=1.12u l=0.13u
X5118 VSS B_uq67 a_76805_27133# VSS sg13_lv_nmos ad=0.2516p pd=2.16u as=96.2f ps=1u w=0.74u l=0.13u
X5119 a_12256_21623# C_uq15 a_12142_21623# VDD sg13_lv_pmos ad=0.2128p pd=1.5u as=0.2464p ps=1.56u w=1.12u l=0.13u
X5120 VSS L_HI_uq27 a_42768_67806# VSS sg13_lv_nmos ad=0.1626p pd=1.415u as=60.89999f ps=0.71u w=0.42u l=0.13u
X5121 Y_uq39 C_uq4 VSS VSS sg13_lv_nmos ad=0.1406p pd=1.12u as=0.2516p ps=2.16u w=0.74u l=0.13u
X5122 C_uq20 C_uq16 VDD VDD sg13_lv_pmos ad=0.2128p pd=1.5u as=0.2198p ps=1.53u w=1.12u l=0.13u
X5123 a_50486_65856# X_uq446 VDD VDD sg13_lv_pmos ad=0.1176p pd=1.33u as=0.4032p ps=2.96u w=1.12u l=0.13u
X5124 Y_uq318 Q_uq50 a_46552_68416# VDD sg13_lv_pmos ad=0.3808p pd=2.92u as=0.1176p ps=1.33u w=1.12u l=0.13u
X5125 L_HI_uq39 a_32106_69882# VDD VDD sg13_lv_pmos ad=0.3927p pd=2.99u as=1.6733p ps=10.405u w=1.155u l=0.13u
X5126 a_29232_66281# a_29463_65867# a_28918_65824# VSS sg13_lv_nmos ad=0.2373p pd=1.97u as=79.8f ps=0.8u w=0.42u l=0.13u
X5127 a_48117_70021# a_47760_69948# VDD VDD sg13_lv_pmos ad=63f pd=0.72u as=0.1563p ps=1.22u w=0.42u l=0.13u
X5128 VDD X_uq167 a_35076_8453# VDD sg13_lv_pmos ad=0.2618p pd=1.63u as=0.2856p ps=2.36u w=0.84u l=0.13u
X5129 VDD L_HI_uq11 a_37682_64782# VDD sg13_lv_pmos ad=0.36237p pd=2.605u as=79.8f ps=0.8u w=0.42u l=0.13u
X5130 VDD a_4681_21848# a_4783_21991# VDD sg13_lv_pmos ad=1.37097p pd=8.54u as=0.3864p ps=2.93u w=1.12u l=0.13u
X5131 Q_uq12 a_5047_33402# VSS VSS sg13_lv_nmos ad=0.2516p pd=2.16u as=0.1406p ps=1.12u w=0.74u l=0.13u
X5132 a_8120_41323# Y_uq234 VSS VSS sg13_lv_nmos ad=37.8f pd=0.6u as=0.1701p ps=1.65u w=0.42u l=0.13u
X5133 a_47480_66570# Q_uq50 VSS VSS sg13_lv_nmos ad=0.187p pd=1.78u as=0.14875p ps=1.16u w=0.55u l=0.13u
X5134 a_41494_69853# a_41937_69609# a_41877_70021# VDD sg13_lv_pmos ad=79.8f pd=0.8u as=63f ps=0.72u w=0.42u l=0.13u
X5135 a_33123_68880# Y_uq344 a_33009_68880# VDD sg13_lv_pmos ad=0.2128p pd=1.5u as=0.2464p ps=1.56u w=1.12u l=0.13u
X5136 VSS a_8075_38143# a_8111_38075# VSS sg13_lv_nmos ad=79.8f pd=0.8u as=0.1428p ps=1.52u w=0.42u l=0.5u
X5137 VDD L_HI_uq8 a_78787_28691# VDD sg13_lv_pmos ad=1.59725p pd=10.05u as=79.8f ps=0.8u w=0.42u l=0.13u
X5138 a_4681_34894# B_uq78 VSS VSS sg13_lv_nmos ad=0.1216p pd=1.02u as=0.1331p ps=1.12u w=0.64u l=0.13u
X5139 a_10791_24647# B_uq58 a_10689_24647# VDD sg13_lv_pmos ad=0.2128p pd=1.5u as=0.2128p ps=1.5u w=1.12u l=0.13u
X5140 VSS Q_uq30 Y_uq249 VSS sg13_lv_nmos ad=0.2516p pd=2.16u as=0.1406p ps=1.12u w=0.74u l=0.13u
X5141 VDD VSS VDD VDD sg13_lv_pmos ad=0.34p pd=2.68u as=0 ps=0 w=1u l=1u
X5142 VSS clk a_9598_32468# VSS sg13_lv_nmos ad=3.58025p pd=22.71u as=0.2516p ps=2.16u w=0.74u l=0.13u
X5143 a_46323_67455# a_46475_67339# VSS VSS sg13_lv_nmos ad=0.2516p pd=2.16u as=2.08687p ps=13.23u w=0.74u l=0.13u
X5144 VDD L_HI_uq3 a_5514_23381# VDD sg13_lv_pmos ad=0.36237p pd=2.605u as=79.8f ps=0.8u w=0.42u l=0.13u
X5145 a_5813_41167# a_5811_42044# a_5892_41550# VDD sg13_lv_pmos ad=79.8f pd=0.8u as=63f ps=0.72u w=0.42u l=0.13u
X5146 a_7321_37166# Q_uq19 a_7705_37294# VSS sg13_lv_nmos ad=0.2176p pd=1.96u as=0.1216p ps=1.02u w=0.64u l=0.13u
X5147 B2 X_uq189 VSS VSS sg13_lv_nmos ad=0.2516p pd=2.16u as=0.2516p ps=2.16u w=0.74u l=0.13u
X5148 a_27593_65392# C_uq52 Y_uq270 VDD sg13_lv_pmos ad=0.2128p pd=1.5u as=0.3808p ps=2.92u w=1.12u l=0.13u
X5149 VDD a_46018_8375# B_uq1 VDD sg13_lv_pmos ad=0.2114p pd=1.54u as=0.42p ps=2.99u w=1.12u l=0.13u
X5150 VDD Y_uq293 a_36436_63620# VDD sg13_lv_pmos ad=0.2114p pd=1.54u as=0.2856p ps=2.36u w=0.84u l=0.13u
X5151 D_uq35 a_29250_63650# VSS VSS sg13_lv_nmos ad=0.2516p pd=2.16u as=0.1426p ps=1.16u w=0.74u l=0.13u
X5152 VSS SLN[5] a_34686_8449# VSS sg13_lv_nmos ad=0.14875p pd=1.16u as=0.187p ps=1.78u w=0.55u l=0.13u
X5153 VDD C_uq15 a_11957_18599# VDD sg13_lv_pmos ad=0.4032p pd=2.96u as=0.1176p ps=1.33u w=1.12u l=0.13u
X5154 VDD A_uq97 a_33342_9173# VDD sg13_lv_pmos ad=0.2114p pd=1.54u as=0.2856p ps=2.36u w=0.84u l=0.13u
X5155 a_46786_6863# Y_uq17 VSS VSS sg13_lv_nmos ad=0.187p pd=1.78u as=0.14875p ps=1.16u w=0.55u l=0.13u
X5156 a_8107_31019# D_uq13 VDD VDD sg13_lv_pmos ad=79.8f pd=0.8u as=0.1428p ps=1.52u w=0.42u l=0.13u
X5157 VSS X_uq407 Y_uq317 VSS sg13_lv_nmos ad=0.2516p pd=2.16u as=0.1406p ps=1.12u w=0.74u l=0.13u
X5158 a_42417_64355# clk VSS VSS sg13_lv_nmos ad=0.2516p pd=2.16u as=4.19255p ps=26u w=0.74u l=0.13u
X5159 VSS a_4557_21457# a_4478_21360# VSS sg13_lv_nmos ad=2.0486p pd=12.405u as=0.27427p ps=2.28u w=0.795u l=0.13u
X5160 Y_uq16 X_uq168 VSS VSS sg13_lv_nmos ad=0.1406p pd=1.12u as=0.2516p ps=2.16u w=0.74u l=0.13u
X5161 VSS Q_uq37 Y_uq295 VSS sg13_lv_nmos ad=0.2516p pd=2.16u as=0.1406p ps=1.12u w=0.74u l=0.13u
X5162 a_79910_24544# a_79068_24446# a_79816_24544# VSS sg13_lv_nmos ad=0.12665p pd=1.145u as=0.1428p ps=1.52u w=0.42u l=0.13u
X5163 a_76805_27133# Y_uq148 Y_uq137 VSS sg13_lv_nmos ad=96.2f pd=1u as=0.2664p ps=1.46u w=0.74u l=0.13u
X5164 VDD X_uq150 a_39972_9965# VDD sg13_lv_pmos ad=0.2618p pd=1.63u as=0.2856p ps=2.36u w=0.84u l=0.13u
X5165 a_79008_26788# a_78651_26745# VDD VDD sg13_lv_pmos ad=63f pd=0.72u as=0.1563p ps=1.22u w=0.42u l=0.13u
X5166 VSS a_5051_43135# a_5087_43067# VSS sg13_lv_nmos ad=79.8f pd=0.8u as=0.1428p ps=1.52u w=0.42u l=0.5u
X5167 a_50933_69576# a_51057_69673# VDD VDD sg13_lv_pmos ad=0.2442p pd=2.06u as=1.6733p ps=10.405u w=0.66u l=0.13u
X5168 a_50422_64312# a_50865_64355# a_50162_64782# VSS sg13_lv_nmos ad=79.8f pd=0.8u as=0.1296p ps=1.52u w=0.42u l=0.13u
X5169 a_44098_6863# Y_uq1 VDD VDD sg13_lv_pmos ad=0.2856p pd=2.36u as=0.2114p ps=1.54u w=0.84u l=0.13u
X5170 D_uq64 C_uq71 VSS VSS sg13_lv_nmos ad=0.2618p pd=2.22u as=0.1463p ps=1.15u w=0.77u l=0.13u
X5171 VSS L_HI_uq23 a_50448_67806# VSS sg13_lv_nmos ad=0.1626p pd=1.415u as=60.89999f ps=0.71u w=0.42u l=0.13u
X5172 VSS Y_uq286 a_46148_66610# VSS sg13_lv_nmos ad=79.8f pd=0.8u as=0.1428p ps=1.52u w=0.42u l=0.13u
X5173 VSS B_uq93 a_5109_39206# VSS sg13_lv_nmos ad=0.2516p pd=2.16u as=0.1406p ps=1.12u w=0.74u l=0.13u
X5174 VSS L_HI_uq19 a_43152_66294# VSS sg13_lv_nmos ad=0.1626p pd=1.415u as=60.89999f ps=0.71u w=0.42u l=0.13u
X5175 a_50133_68509# a_49776_68436# VDD VDD sg13_lv_pmos ad=63f pd=0.72u as=0.1563p ps=1.22u w=0.42u l=0.13u
X5176 D_uq10 C_uq29 VSS VSS sg13_lv_nmos ad=0.2618p pd=2.22u as=0.1463p ps=1.15u w=0.77u l=0.13u
X5177 a_5396_24385# L_HI_uq6 VDD VDD sg13_lv_pmos ad=79.8f pd=0.8u as=1.02937p ps=6.325u w=0.42u l=0.13u
X5178 a_6427_24143# B_uq64 a_6313_24143# VDD sg13_lv_pmos ad=0.2128p pd=1.5u as=0.2464p ps=1.56u w=1.12u l=0.13u
X5179 a_36059_66217# a_35217_65867# a_35965_66217# VSS sg13_lv_nmos ad=0.12665p pd=1.145u as=0.1428p ps=1.52u w=0.42u l=0.13u
X5180 VSS B_uq28 a_37070_11001# VSS sg13_lv_nmos ad=0.187p pd=1.78u as=0.1045p ps=0.93u w=0.55u l=0.13u
X5181 X_uq25 a_36702_6937# VSS VSS sg13_lv_nmos ad=0.2886p pd=2.26u as=0.14875p ps=1.16u w=0.74u l=0.13u
X5182 VSS Y_uq236 a_6595_41001# VSS sg13_lv_nmos ad=0.1626p pd=1.415u as=60.89999f ps=0.71u w=0.42u l=0.13u
X5183 VDD Y_uq269 a_32900_65098# VDD sg13_lv_pmos ad=0.1523p pd=1.38u as=0.1428p ps=1.52u w=0.42u l=0.13u
X5184 VDD a_31270_66097# L_HI_uq16 VDD sg13_lv_pmos ad=1.41367p pd=8.85u as=0.3927p ps=2.99u w=1.155u l=0.13u
X5185 VDD VSS VDD VDD sg13_lv_pmos ad=0.34p pd=2.68u as=0 ps=0 w=1u l=1u
X5186 VSS L_HI_uq7 a_78459_27179# VSS sg13_lv_nmos ad=0.1626p pd=1.415u as=60.89999f ps=0.71u w=0.42u l=0.13u
X5187 VSS Q_uq54 Y_uq291 VSS sg13_lv_nmos ad=0.2516p pd=2.16u as=0.2516p ps=2.16u w=0.74u l=0.13u
X5188 VDD C_uq15 a_12533_22671# VDD sg13_lv_pmos ad=0.4032p pd=2.96u as=0.1176p ps=1.33u w=1.12u l=0.13u
X5189 VSS a_52376_68844# q[31] VSS sg13_lv_nmos ad=0.14875p pd=1.16u as=0.2886p ps=2.26u w=0.74u l=0.13u
X5190 VSS Y_uq31 a_9713_17875# VSS sg13_lv_nmos ad=0.14875p pd=1.16u as=0.187p ps=1.78u w=0.55u l=0.13u
X5191 A_uq2 a_32116_64344# VDD VDD sg13_lv_pmos ad=0.42p pd=2.99u as=0.2114p ps=1.54u w=1.12u l=0.13u
X5192 a_52186_68307# a_52301_68308# VSS VSS sg13_lv_nmos ad=0.1428p pd=1.52u as=0.1426p ps=1.16u w=0.42u l=0.5u
X5193 a_5083_34571# D_uq20 VDD VDD sg13_lv_pmos ad=79.8f pd=0.8u as=0.1428p ps=1.52u w=0.42u l=0.13u
X5194 a_3594_24581# a_4399_24154# a_3854_24111# VDD sg13_lv_pmos ad=0.1428p pd=1.52u as=79.8f ps=0.8u w=0.42u l=0.13u
X5195 a_8071_32855# Y_uq163 VDD VDD sg13_lv_pmos ad=79.8f pd=0.8u as=1.5243p ps=9.795u w=0.42u l=0.13u
X5196 VDD VSS VDD VDD sg13_lv_pmos ad=0.34p pd=2.68u as=0 ps=0 w=1u l=1u
X5197 VDD X_uq312 a_7357_35257# VDD sg13_lv_pmos ad=0.3808p pd=2.92u as=0.2128p ps=1.5u w=1.12u l=0.13u
X5198 VDD L_HI_uq10 a_41714_64782# VDD sg13_lv_pmos ad=0.36237p pd=2.605u as=79.8f ps=0.8u w=0.42u l=0.13u
X5199 SLN[6] a_29716_63620# VDD VDD sg13_lv_pmos ad=0.42p pd=2.99u as=0.2114p ps=1.54u w=1.12u l=0.13u
X5200 C_uq51 X_uq409 a_33398_65856# VDD sg13_lv_pmos ad=0.3808p pd=2.92u as=0.1176p ps=1.33u w=1.12u l=0.13u
X5201 a_76556_20693# Y_uq56 VDD VDD sg13_lv_pmos ad=0.2128p pd=1.5u as=0.2128p ps=1.5u w=1.12u l=0.13u
X5202 VDD A_N C_uq4 VDD sg13_lv_pmos ad=0.2128p pd=1.5u as=0.2128p ps=1.5u w=1.12u l=0.13u
X5203 Y_uq84 B_uq43 VSS VSS sg13_lv_nmos ad=0.1694p pd=1.21u as=0.2618p ps=2.22u w=0.77u l=0.13u
X5204 VSS a_33536_68844# Y_uq344 VSS sg13_lv_nmos ad=0.17255p pd=1.25u as=0.1406p ps=1.12u w=0.74u l=0.13u
X5205 q[10] a_33364_63620# VSS VSS sg13_lv_nmos ad=0.2886p pd=2.26u as=0.14875p ps=1.16u w=0.74u l=0.13u
X5206 a_37787_67729# a_36945_67379# a_37693_67729# VSS sg13_lv_nmos ad=0.12665p pd=1.145u as=0.1428p ps=1.52u w=0.42u l=0.13u
X5207 C_uq26 B1_uq5 a_76939_27517# VSS sg13_lv_nmos ad=0.2516p pd=2.16u as=0.1406p ps=1.12u w=0.74u l=0.13u
X5208 a_29045_69218# a_29169_68917# VDD VDD sg13_lv_pmos ad=0.2442p pd=2.06u as=1.42837p ps=8.61u w=0.66u l=0.13u
X5209 VDD X_uq430 a_36952_68880# VDD sg13_lv_pmos ad=0.4032p pd=2.96u as=0.1176p ps=1.33u w=1.12u l=0.13u
X5210 VSS X_uq168 a_33254_10301# VSS sg13_lv_nmos ad=0.1469p pd=1.155u as=0.1045p ps=0.93u w=0.55u l=0.13u
X5211 a_3535_31228# a_3546_31883# a_3535_31809# VSS sg13_lv_nmos ad=0.12665p pd=1.145u as=0.3473p ps=2.71u w=0.74u l=0.13u
X5212 VDD a_79155_22566# a_80178_22252# VDD sg13_lv_pmos ad=0.1563p pd=1.22u as=63f ps=0.72u w=0.42u l=0.13u
X5213 VSS a_3535_38609# B_uq86 VSS sg13_lv_nmos ad=0.14875p pd=1.16u as=0.2886p ps=2.26u w=0.74u l=0.13u
X5214 a_80329_27179# L_HI_uq7 VSS VSS sg13_lv_nmos ad=37.8f pd=0.6u as=79.8f ps=0.8u w=0.42u l=0.13u
X5215 VDD a_10660_21679# D_uq1 VDD sg13_lv_pmos ad=0.3808p pd=2.92u as=0.2128p ps=1.5u w=1.12u l=0.13u
X5216 a_40642_6863# Y_uq20 VSS VSS sg13_lv_nmos ad=0.187p pd=1.78u as=0.14875p ps=1.16u w=0.55u l=0.13u
X5217 VDD a_29830_65062# a_29549_65284# VDD sg13_lv_pmos ad=0.1523p pd=1.38u as=0.34p ps=2.68u w=1u l=0.5u
X5218 VSS a_45094_65062# a_44813_65284# VSS sg13_lv_nmos ad=79.8f pd=0.8u as=0.1428p ps=1.52u w=0.42u l=0.5u
X5219 VDD B_uq65 a_3788_24931# VDD sg13_lv_pmos ad=0.2114p pd=1.54u as=0.2856p ps=2.36u w=0.84u l=0.13u
X5220 a_51707_64705# a_50865_64355# a_50448_64348# VDD sg13_lv_pmos ad=0.2048p pd=1.63u as=0.34p ps=2.68u w=1u l=0.13u
X5221 a_43701_65903# a_43344_65860# VDD VDD sg13_lv_pmos ad=63f pd=0.72u as=0.1563p ps=1.22u w=0.42u l=0.13u
X5222 VDD Y_uq264 a_40468_63620# VDD sg13_lv_pmos ad=0.2114p pd=1.54u as=0.2856p ps=2.36u w=0.84u l=0.13u
X5223 VDD Y_uq360 a_38852_69634# VDD sg13_lv_pmos ad=0.1523p pd=1.38u as=0.1428p ps=1.52u w=0.42u l=0.13u
X5224 VSS a_50746_69147# X_uq424 VSS sg13_lv_nmos ad=0.1426p pd=1.16u as=0.2516p ps=2.16u w=0.74u l=0.13u
X5225 VSS C_uq6 D_uq0 VSS sg13_lv_nmos ad=0.1463p pd=1.15u as=0.2618p ps=2.22u w=0.77u l=0.13u
X5226 VSS Y_uq345 a_30100_63620# VSS sg13_lv_nmos ad=0.14875p pd=1.16u as=0.187p ps=1.78u w=0.55u l=0.13u
X5227 VDD X_uq448 a_46810_68160# VDD sg13_lv_pmos ad=0.2618p pd=1.63u as=0.2856p ps=2.36u w=0.84u l=0.13u
X5228 VDD X_uq431 a_38543_68416# VDD sg13_lv_pmos ad=0.3808p pd=2.92u as=0.2464p ps=1.56u w=1.12u l=0.13u
X5229 X_uq18 a_39390_6937# VSS VSS sg13_lv_nmos ad=0.2886p pd=2.26u as=0.14875p ps=1.16u w=0.74u l=0.13u
X5230 a_9235_35367# C_uq39 a_9235_35265# VSS sg13_lv_nmos ad=0.1406p pd=1.12u as=0.1406p ps=1.12u w=0.74u l=0.13u
X5231 a_9294_36523# Y_uq197 VSS VSS sg13_lv_nmos ad=37.8f pd=0.6u as=0.1701p ps=1.65u w=0.42u l=0.13u
X5232 a_40476_9149# A_uq87 VDD VDD sg13_lv_pmos ad=0.1596p pd=1.22u as=0.2226p ps=1.535u w=0.84u l=0.13u
X5233 Y_uq93 Q_uq0 VSS VSS sg13_lv_nmos ad=0.1406p pd=1.12u as=0.2516p ps=2.16u w=0.74u l=0.13u
X5234 a_6608_41419# Y_uq236 VSS VSS sg13_lv_nmos ad=37.8f pd=0.6u as=0.1701p ps=1.65u w=0.42u l=0.13u
X5235 VDD B1_uq7 a_76172_25229# VDD sg13_lv_pmos ad=0.2128p pd=1.5u as=0.3808p ps=2.92u w=1.12u l=0.13u
X5236 D_uq53 C_uq62 VSS VSS sg13_lv_nmos ad=0.2618p pd=2.22u as=0.1463p ps=1.15u w=0.77u l=0.13u
X5237 VDD a_31448_68082# q[1] VDD sg13_lv_pmos ad=0.2114p pd=1.54u as=0.42p ps=2.99u w=1.12u l=0.13u
X5238 X_uq323 a_5047_40319# VDD VDD sg13_lv_pmos ad=0.42p pd=2.99u as=0.2114p ps=1.54u w=1.12u l=0.13u
X5239 a_49750_68341# a_50193_68097# a_50133_68509# VDD sg13_lv_pmos ad=79.8f pd=0.8u as=63f ps=0.72u w=0.42u l=0.13u
X5240 VSS B_uq29 a_35726_10067# VSS sg13_lv_nmos ad=0.187p pd=1.78u as=0.1045p ps=0.93u w=0.55u l=0.13u
X5241 VSS Y_uq49 a_12209_18599# VSS sg13_lv_nmos ad=0.14875p pd=1.16u as=0.187p ps=1.78u w=0.55u l=0.13u
X5242 VDD X_uq157 a_38052_9965# VDD sg13_lv_pmos ad=0.2618p pd=1.63u as=0.2856p ps=2.36u w=0.84u l=0.13u
X5243 a_33334_68341# a_33777_68097# a_33074_68118# VSS sg13_lv_nmos ad=79.8f pd=0.8u as=0.1296p ps=1.52u w=0.42u l=0.13u
X5244 VSS clk a_29579_64315# VSS sg13_lv_nmos ad=4.19255p pd=26u as=0.2516p ps=2.16u w=0.74u l=0.13u
X5245 X_uq30 a_34782_6937# VDD VDD sg13_lv_pmos ad=0.42p pd=2.99u as=0.2114p ps=1.54u w=1.12u l=0.13u
X5246 VSS X_uq383 C_uq49 VSS sg13_lv_nmos ad=0.2516p pd=2.16u as=0.1406p ps=1.12u w=0.74u l=0.13u
X5247 a_46065_65392# X_uq445 VDD VDD sg13_lv_pmos ad=0.2464p pd=1.56u as=0.3808p ps=2.92u w=1.12u l=0.13u
X5248 VSS a_47110_65062# a_46829_65284# VSS sg13_lv_nmos ad=79.8f pd=0.8u as=0.1428p ps=1.52u w=0.42u l=0.5u
X5249 VSS C_uq20 Y_uq95 VSS sg13_lv_nmos ad=0.2516p pd=2.16u as=0.1406p ps=1.12u w=0.74u l=0.13u
X5250 a_76459_24765# Y_uq105 VDD VDD sg13_lv_pmos ad=0.2128p pd=1.5u as=0.3808p ps=2.92u w=1.12u l=0.13u
X5251 Y_uq49 C_uq4 VSS VSS sg13_lv_nmos ad=0.2618p pd=2.22u as=0.1463p ps=1.15u w=0.77u l=0.13u
X5252 X_uq195 a_76447_18457# VSS VSS sg13_lv_nmos ad=0.2886p pd=2.26u as=0.14875p ps=1.16u w=0.74u l=0.13u
X5253 D_uq20 C_uq32 VSS VSS sg13_lv_nmos ad=0.2618p pd=2.22u as=0.1463p ps=1.15u w=0.77u l=0.13u
X5254 a_8835_41852# clk VDD VDD sg13_lv_pmos ad=0.4088p pd=2.97u as=1.4396p ps=9.25u w=1.12u l=0.13u
X5255 a_5780_22089# L_HI_uq1 VDD VDD sg13_lv_pmos ad=79.8f pd=0.8u as=1.37097p ps=8.54u w=0.42u l=0.13u
X5256 VDD Y_uq288 a_45268_66644# VDD sg13_lv_pmos ad=0.2114p pd=1.54u as=0.2856p ps=2.36u w=0.84u l=0.13u
X5257 a_47032_68416# a_46810_68160# VDD VDD sg13_lv_pmos ad=0.1176p pd=1.33u as=0.2618p ps=1.63u w=1.12u l=0.13u
X5258 a_46906_69147# a_47021_69146# VSS VSS sg13_lv_nmos ad=0.1428p pd=1.52u as=0.1426p ps=1.16u w=0.42u l=0.5u
X5259 VDD Q_uq5 a_7724_25655# VDD sg13_lv_pmos ad=0.2114p pd=1.54u as=0.2856p ps=2.36u w=0.84u l=0.13u
X5260 VDD X_uq251 a_77827_26277# VDD sg13_lv_pmos ad=0.4032p pd=2.96u as=0.1176p ps=1.33u w=1.12u l=0.13u
X5261 VSS a_42250_9137# Y_uq10 VSS sg13_lv_nmos ad=0.17255p pd=1.25u as=0.1406p ps=1.12u w=0.74u l=0.13u
X5262 a_41824_10685# X_uq144 Y_uq29 VDD sg13_lv_pmos ad=0.1176p pd=1.33u as=0.3808p ps=2.92u w=1.12u l=0.13u
X5263 VSS X_uq236 Y_uq129 VSS sg13_lv_nmos ad=0.2516p pd=2.16u as=0.1406p ps=1.12u w=0.74u l=0.13u
X5264 VSS X_uq447 Y_uq294 VSS sg13_lv_nmos ad=0.2618p pd=2.22u as=0.1694p ps=1.21u w=0.77u l=0.13u
X5265 VSS A_uq75 Y VSS sg13_lv_nmos ad=0.2516p pd=2.16u as=0.1406p ps=1.12u w=0.74u l=0.13u
X5266 VSS A_uq97 a_33342_9173# VSS sg13_lv_nmos ad=0.14875p pd=1.16u as=0.187p ps=1.78u w=0.55u l=0.13u
X5267 VSS a_10345_31414# Q_uq10 VSS sg13_lv_nmos ad=0.1406p pd=1.12u as=0.2516p ps=2.16u w=0.74u l=0.13u
X5268 VDD a_44603_66217# a_44860_66098# VDD sg13_lv_pmos ad=1.41367p pd=8.85u as=79.8f ps=0.8u w=0.42u l=0.13u
X5269 VSS a_41884_66098# a_41533_66217# VSS sg13_lv_nmos ad=79.8f pd=0.8u as=0.1428p ps=1.52u w=0.42u l=0.13u
X5270 VSS VDD VSS VSS sg13_lv_nmos ad=0.1428p pd=1.52u as=0 ps=-0 w=0.42u l=1u
X5271 a_51992_68844# Y_uq335 VDD VDD sg13_lv_pmos ad=0.2856p pd=2.36u as=0.2114p ps=1.54u w=0.84u l=0.13u
X5272 a_5800_25211# a_5774_25116# VSS VSS sg13_lv_nmos ad=0.2516p pd=2.16u as=0.1626p ps=1.415u w=0.74u l=0.13u
X5273 a_39516_9149# A_uq88 VDD VDD sg13_lv_pmos ad=0.1596p pd=1.22u as=0.2226p ps=1.535u w=0.84u l=0.13u
X5274 VSS a_36945_67379# a_37047_67379# VSS sg13_lv_nmos ad=2.08687p pd=13.23u as=0.2516p ps=2.16u w=0.74u l=0.13u
X5275 a_79982_20740# a_79286_20664# a_80076_20740# VSS sg13_lv_nmos ad=0.1296p pd=1.52u as=79.8f ps=0.8u w=0.42u l=0.13u
X5276 a_38853_65979# a_37911_65867# a_38651_66217# VDD sg13_lv_pmos ad=93.45f pd=0.865u as=0.2048p ps=1.63u w=0.42u l=0.13u
X5277 a_35722_8379# X_uq68 VDD VDD sg13_lv_pmos ad=0.2856p pd=2.36u as=0.2618p ps=1.63u w=0.84u l=0.13u
X5278 VSS X_uq294 D_uq15 VSS sg13_lv_nmos ad=0.2516p pd=2.16u as=0.1406p ps=1.12u w=0.74u l=0.13u
X5279 VSS a_5150_24861# a_4869_25083# VSS sg13_lv_nmos ad=79.8f pd=0.8u as=0.1428p ps=1.52u w=0.42u l=0.5u
X5280 Y_uq228 X_uq323 VSS VSS sg13_lv_nmos ad=0.2516p pd=2.16u as=0.2516p ps=2.16u w=0.74u l=0.13u
X5281 VSS X_uq376 C_uq45 VSS sg13_lv_nmos ad=0.2516p pd=2.16u as=0.1406p ps=1.12u w=0.74u l=0.13u
X5282 X_uq34 a_33246_6937# VSS VSS sg13_lv_nmos ad=0.2886p pd=2.26u as=0.14875p ps=1.16u w=0.74u l=0.13u
X5283 B_uq30 a_32766_10685# VDD VDD sg13_lv_pmos ad=0.42p pd=2.99u as=0.2114p ps=1.54u w=1.12u l=0.13u
X5284 X_uq255 a_7724_25655# VDD VDD sg13_lv_pmos ad=0.42p pd=2.99u as=0.2114p ps=1.54u w=1.12u l=0.13u
X5285 VSS X_uq399 a_40762_64400# VSS sg13_lv_nmos ad=0.17255p pd=1.25u as=0.187p ps=1.78u w=0.55u l=0.13u
X5286 a_36778_9891# X_uq113 VDD VDD sg13_lv_pmos ad=0.2856p pd=2.36u as=0.2618p ps=1.63u w=0.84u l=0.13u
X5287 X_uq23 a_37470_6937# VDD VDD sg13_lv_pmos ad=0.42p pd=2.99u as=0.2114p ps=1.54u w=1.12u l=0.13u
X5288 VSS a_5051_41791# a_5087_41723# VSS sg13_lv_nmos ad=79.8f pd=0.8u as=0.1428p ps=1.52u w=0.42u l=0.5u
X5289 A_uq2 a_32116_64344# VSS VSS sg13_lv_nmos ad=0.2886p pd=2.26u as=0.14875p ps=1.16u w=0.74u l=0.13u
X5290 B_uq33 a_8561_19387# VDD VDD sg13_lv_pmos ad=0.42p pd=2.99u as=0.2114p ps=1.54u w=1.12u l=0.13u
X5291 a_76453_19181# B1_uq7 a_76555_19181# VDD sg13_lv_pmos ad=0.3808p pd=2.92u as=0.2128p ps=1.5u w=1.12u l=0.13u
X5292 a_8107_42775# Y_uq234 VSS VSS sg13_lv_nmos ad=37.8f pd=0.6u as=79.8f ps=0.8u w=0.42u l=0.13u
X5293 VDD a_50168_69594# A_uq20 VDD sg13_lv_pmos ad=0.2114p pd=1.54u as=0.42p ps=2.99u w=1.12u l=0.13u
X5294 Y_uq57 A_N VSS VSS sg13_lv_nmos ad=0.1694p pd=1.21u as=0.2618p ps=2.22u w=0.77u l=0.13u
X5295 a_79982_22252# D_uq2 a_80729_22643# VSS sg13_lv_nmos ad=0.1428p pd=1.52u as=60.89999f ps=0.71u w=0.42u l=0.13u
X5296 VSS L_HI_uq12 a_33264_64782# VSS sg13_lv_nmos ad=0.1626p pd=1.415u as=60.89999f ps=0.71u w=0.42u l=0.13u
X5297 VDD VSS VDD VDD sg13_lv_pmos ad=0.34p pd=2.68u as=0 ps=0 w=1u l=1u
X5298 a_34428_10301# X_uq168 VDD VDD sg13_lv_pmos ad=0.1596p pd=1.22u as=0.2226p ps=1.535u w=0.84u l=0.13u
X5299 a_32696_66570# X_uq435 VSS VSS sg13_lv_nmos ad=0.187p pd=1.78u as=0.14875p ps=1.16u w=0.55u l=0.13u
X5300 VDD a_52582_66097# L_HI_uq18 VDD sg13_lv_pmos ad=1.41367p pd=8.85u as=0.3927p ps=2.99u w=1.155u l=0.13u
X5301 a_31832_68082# Y_uq364 VSS VSS sg13_lv_nmos ad=0.187p pd=1.78u as=0.14875p ps=1.16u w=0.55u l=0.13u
X5302 Y_uq54 C_uq4 VSS VSS sg13_lv_nmos ad=0.1406p pd=1.12u as=0.2516p ps=2.16u w=0.74u l=0.13u
X5303 B_uq64 a_5618_25711# VSS VSS sg13_lv_nmos ad=0.1406p pd=1.12u as=0.17255p ps=1.25u w=0.74u l=0.13u
X5304 VSS Y_uq347 a_31732_65856# VSS sg13_lv_nmos ad=0.14875p pd=1.16u as=0.187p ps=1.78u w=0.55u l=0.13u
X5305 VSS Y_uq130 a_9233_25435# VSS sg13_lv_nmos ad=0.14875p pd=1.16u as=0.187p ps=1.78u w=0.55u l=0.13u
X5306 VDD a_3535_41755# a_3535_41591# VDD sg13_lv_pmos ad=1.31615p pd=8.395u as=79.8f ps=0.8u w=0.42u l=0.13u
X5307 a_4380_41738# D_uq33 VDD VDD sg13_lv_pmos ad=79.8f pd=0.8u as=0.1428p ps=1.52u w=0.42u l=0.13u
X5308 Q_uq27 a_5809_43290# VDD VDD sg13_lv_pmos ad=0.3808p pd=2.92u as=0.2128p ps=1.5u w=1.12u l=0.13u
X5309 C_uq53 X_uq407 a_47126_66904# VDD sg13_lv_pmos ad=0.3808p pd=2.92u as=0.1176p ps=1.33u w=1.12u l=0.13u
X5310 VDD C_uq21 a_11477_18135# VDD sg13_lv_pmos ad=0.4032p pd=2.96u as=0.1176p ps=1.33u w=1.12u l=0.13u
X5311 Y_uq303 X_uq424 a_49912_67368# VDD sg13_lv_pmos ad=0.3808p pd=2.92u as=0.1176p ps=1.33u w=1.12u l=0.13u
X5312 VSS a_52006_63550# a_51725_63772# VSS sg13_lv_nmos ad=79.8f pd=0.8u as=0.1428p ps=1.52u w=0.42u l=0.5u
X5313 Y_uq88 X_uq221 VDD VDD sg13_lv_pmos ad=0.3808p pd=2.92u as=0.3808p ps=2.92u w=1.12u l=0.13u
X5314 VSS a_34330_67635# X_uq434 VSS sg13_lv_nmos ad=0.1426p pd=1.16u as=0.2516p ps=2.16u w=0.74u l=0.13u
X5315 a_5833_34271# a_5809_33991# VDD VDD sg13_lv_pmos ad=0.34p pd=2.68u as=0.1523p ps=1.38u w=1u l=0.5u
X5316 VSS a_29361_65867# a_29463_65867# VSS sg13_lv_nmos ad=1.8643p pd=11.96u as=0.2516p ps=2.16u w=0.74u l=0.13u
X5317 X_uq189 a_75295_18457# VDD VDD sg13_lv_pmos ad=0.42p pd=2.99u as=0.2114p ps=1.54u w=1.12u l=0.13u
X5318 VSS A_uq99 a_32382_9961# VSS sg13_lv_nmos ad=0.14875p pd=1.16u as=0.187p ps=1.78u w=0.55u l=0.13u
X5319 a_34766_10067# B_uq11 a_34908_10301# VDD sg13_lv_pmos ad=0.2856p pd=2.36u as=0.1596p ps=1.22u w=0.84u l=0.13u
X5320 a_4703_39700# a_4297_39674# B_uq93 VSS sg13_lv_nmos ad=0.1406p pd=1.12u as=0.333p ps=2.38u w=0.74u l=0.13u
X5321 VDD Q_uq24 a_9583_43295# VDD sg13_lv_pmos ad=0.2114p pd=1.54u as=0.2856p ps=2.36u w=0.84u l=0.13u
X5322 VSS L_HI_uq28 a_39408_67806# VSS sg13_lv_nmos ad=0.1626p pd=1.415u as=60.89999f ps=0.71u w=0.42u l=0.13u
X5323 a_37701_69945# a_36759_69752# a_37499_69707# VDD sg13_lv_pmos ad=93.45f pd=0.865u as=0.2048p ps=1.63u w=0.42u l=0.13u
X5324 VDD a_49778_65856# a_49890_65880# VDD sg13_lv_pmos ad=0.2254p pd=1.53u as=0.34p ps=2.68u w=1u l=0.5u
X5325 VSS X_uq199 a_8561_19387# VSS sg13_lv_nmos ad=0.14875p pd=1.16u as=0.187p ps=1.78u w=0.55u l=0.13u
X5326 VSS q[17] a_38910_10685# VSS sg13_lv_nmos ad=0.14875p pd=1.16u as=0.187p ps=1.78u w=0.55u l=0.13u
X5327 Y_uq366 Q_uq60 VDD VDD sg13_lv_pmos ad=0.3808p pd=2.92u as=0.3808p ps=2.92u w=1.12u l=0.13u
X5328 D_uq50 X_uq445 VSS VSS sg13_lv_nmos ad=0.1694p pd=1.21u as=0.2618p ps=2.22u w=0.77u l=0.13u
X5329 a_46786_7625# Y_uq27 VSS VSS sg13_lv_nmos ad=0.187p pd=1.78u as=0.14875p ps=1.16u w=0.55u l=0.13u
X5330 a_34286_10067# X_uq168 VSS VSS sg13_lv_nmos ad=0.1045p pd=0.93u as=0.1469p ps=1.155u w=0.55u l=0.13u
X5331 VDD a_45176_63546# X_uq338 VDD sg13_lv_pmos ad=0.2114p pd=1.54u as=0.42p ps=2.99u w=1.12u l=0.13u
X5332 D_uq37 a_49026_65162# VSS VSS sg13_lv_nmos ad=0.2516p pd=2.16u as=0.1426p ps=1.16u w=0.74u l=0.13u
X5333 VDD a_29434_65283# X_uq390 VDD sg13_lv_pmos ad=0.2254p pd=1.53u as=0.4256p ps=3u w=1.12u l=0.13u
X5334 VDD Q_uq56 a_33364_63620# VDD sg13_lv_pmos ad=0.2114p pd=1.54u as=0.2856p ps=2.36u w=0.84u l=0.13u
X5335 a_7316_25113# a_7059_24970# a_7478_24893# VSS sg13_lv_nmos ad=0.1428p pd=1.52u as=37.8f ps=0.6u w=0.42u l=0.13u
X5336 VSS L_HI_uq26 a_46070_67806# VSS sg13_lv_nmos ad=79.8f pd=0.8u as=37.8f ps=0.6u w=0.42u l=0.13u
X5337 a_42634_8379# X_uq77 VSS VSS sg13_lv_nmos ad=0.187p pd=1.78u as=0.17255p ps=1.25u w=0.55u l=0.13u
X5338 VDD din[15] a_75295_24505# VDD sg13_lv_pmos ad=0.2114p pd=1.54u as=0.2856p ps=2.36u w=0.84u l=0.13u
X5339 X_uq99 a_43814_10301# VSS VSS sg13_lv_nmos ad=0.2516p pd=2.16u as=0.1469p ps=1.155u w=0.74u l=0.13u
X5340 A_uq88 a_38622_7661# VDD VDD sg13_lv_pmos ad=0.42p pd=2.99u as=0.2114p ps=1.54u w=1.12u l=0.13u
X5341 a_79153_28971# Q_uq8 VSS VSS sg13_lv_nmos ad=0.1428p pd=1.52u as=79.8f ps=0.8u w=0.42u l=0.13u
X5342 a_10819_42871# Y_uq231 VSS VSS sg13_lv_nmos ad=37.8f pd=0.6u as=79.8f ps=0.8u w=0.42u l=0.13u
X5343 a_9997_18965# B_uq33 a_9895_18965# VSS sg13_lv_nmos ad=0.1406p pd=1.12u as=0.1406p ps=1.12u w=0.74u l=0.13u
X5344 VSS din[29] a_76831_18457# VSS sg13_lv_nmos ad=0.14875p pd=1.16u as=0.187p ps=1.78u w=0.55u l=0.13u
X5345 X_uq57 a_32478_7661# VDD VDD sg13_lv_pmos ad=0.42p pd=2.99u as=0.2114p ps=1.54u w=1.12u l=0.13u
X5346 Y_uq178 C_uq39 VDD VDD sg13_lv_pmos ad=0.2128p pd=1.5u as=0.2128p ps=1.5u w=1.12u l=0.13u
X5347 VSS a_29734_68086# a_29453_68308# VSS sg13_lv_nmos ad=79.8f pd=0.8u as=0.1428p ps=1.52u w=0.42u l=0.5u
X5348 a_35398_69598# Q_uq56 VDD VDD sg13_lv_pmos ad=0.1428p pd=1.52u as=0.1523p ps=1.38u w=0.42u l=0.13u
X5349 a_29514_66858# a_29315_66921# VSS VSS sg13_lv_nmos ad=0.27427p pd=2.28u as=1.8643p ps=11.96u w=0.795u l=0.13u
X5350 VSS din[25] a_75295_18457# VSS sg13_lv_nmos ad=0.14875p pd=1.16u as=0.187p ps=1.78u w=0.55u l=0.13u
X5351 a_38961_67368# X_uq447 VDD VDD sg13_lv_pmos ad=0.2464p pd=1.56u as=0.3808p ps=2.92u w=1.12u l=0.13u
X5352 a_40194_10221# a_39972_9965# VDD VDD sg13_lv_pmos ad=0.1176p pd=1.33u as=0.2618p ps=1.63u w=1.12u l=0.13u
X5353 VSS a_45634_6863# X_uq2 VSS sg13_lv_nmos ad=0.14875p pd=1.16u as=0.2886p ps=2.26u w=0.74u l=0.13u
X5354 a_41278_67806# L_HI_uq28 VSS VSS sg13_lv_nmos ad=37.8f pd=0.6u as=79.8f ps=0.8u w=0.42u l=0.13u
X5355 a_77342_23741# C_uq9 a_77248_23741# VDD sg13_lv_pmos ad=0.19p pd=1.38u as=0.34p ps=2.68u w=1u l=0.13u
X5356 VDD a_48728_63546# X_uq333 VDD sg13_lv_pmos ad=0.2114p pd=1.54u as=0.42p ps=2.99u w=1.12u l=0.13u
X5357 VSS Y_uq283 a_27796_65856# VSS sg13_lv_nmos ad=0.14875p pd=1.16u as=0.187p ps=1.78u w=0.55u l=0.13u
X5358 VDD a_34780_66826# a_34725_66921# VDD sg13_lv_pmos ad=1.19383p pd=7.16u as=93.45f ps=0.865u w=0.42u l=0.13u
X5359 a_41520_69948# a_41494_69853# VSS VSS sg13_lv_nmos ad=0.2516p pd=2.16u as=0.1626p ps=1.415u w=0.74u l=0.13u
X5360 VDD a_3550_35754# a_3546_36677# VDD sg13_lv_pmos ad=1.31615p pd=8.395u as=0.3864p ps=2.93u w=1.12u l=0.13u
X5361 VDD D_uq47 a_51107_66997# VDD sg13_lv_pmos ad=0.1428p pd=1.52u as=79.8f ps=0.8u w=0.42u l=0.13u
X5362 VSS a_42368_68086# Y_uq337 VSS sg13_lv_nmos ad=0.17255p pd=1.25u as=0.1406p ps=1.12u w=0.74u l=0.13u
X5363 a_46690_9137# A_uq37 VDD VDD sg13_lv_pmos ad=0.2856p pd=2.36u as=0.2114p ps=1.54u w=0.84u l=0.13u
X5364 Q_uq26 a_6559_43290# VSS VSS sg13_lv_nmos ad=0.2516p pd=2.16u as=0.1406p ps=1.12u w=0.74u l=0.13u
X5365 a_43558_63550# Q_uq33 VSS VSS sg13_lv_nmos ad=0.1428p pd=1.52u as=79.8f ps=0.8u w=0.42u l=0.13u
X5366 a_48177_69609# clk VSS VSS sg13_lv_nmos ad=0.2516p pd=2.16u as=1.9335p ps=12.315u w=0.74u l=0.13u
X5367 VDD D_uq21 a_10428_32924# VDD sg13_lv_pmos ad=0.1428p pd=1.52u as=79.8f ps=0.8u w=0.42u l=0.13u
X5368 a_31349_66194# a_31473_65893# VDD VDD sg13_lv_pmos ad=0.2442p pd=2.06u as=1.41367p ps=8.85u w=0.66u l=0.13u
X5369 VDD X_uq147 a_40452_9965# VDD sg13_lv_pmos ad=0.2618p pd=1.63u as=0.2856p ps=2.36u w=0.84u l=0.13u
X5370 a_42446_10067# B_uq18 a_42588_10301# VDD sg13_lv_pmos ad=0.2856p pd=2.36u as=0.1596p ps=1.22u w=0.84u l=0.13u
X5371 D_uq11 X_uq279 VSS VSS sg13_lv_nmos ad=0.1406p pd=1.12u as=0.2516p ps=2.16u w=0.74u l=0.13u
X5372 VDD a_49019_69707# a_49276_69850# VDD sg13_lv_pmos ad=1.6733p pd=10.405u as=79.8f ps=0.8u w=0.42u l=0.13u
X5373 VDD a_39874_8375# X_uq65 VDD sg13_lv_pmos ad=0.2114p pd=1.54u as=0.42p ps=2.99u w=1.12u l=0.13u
X5374 a_50259_66824# a_50411_66876# VSS VSS sg13_lv_nmos ad=0.2516p pd=2.16u as=1.8643p ps=11.96u w=0.74u l=0.13u
X5375 A0_uq0 a_7321_40826# VDD VDD sg13_lv_pmos ad=0.2128p pd=1.5u as=0.3808p ps=2.92u w=1.12u l=0.13u
X5376 VDD X_uq260 a_4592_25655# VDD sg13_lv_pmos ad=0.4032p pd=2.96u as=0.1176p ps=1.33u w=1.12u l=0.13u
X5377 VSS a_4420_33911# a_4694_33526# VSS sg13_lv_nmos ad=79.8f pd=0.8u as=0.1428p ps=1.52u w=0.42u l=0.13u
X5378 a_43377_67379# clk VDD VDD sg13_lv_pmos ad=0.4088p pd=2.97u as=1.17087p ps=7.02u w=1.12u l=0.13u
X5379 a_4754_25082# a_4869_25083# VDD VDD sg13_lv_pmos ad=0.34p pd=2.68u as=0.2254p ps=1.53u w=1u l=0.5u
X5380 VSS X_uq215 a_78188_24087# VSS sg13_lv_nmos ad=0.1898p pd=1.36u as=0.2516p ps=2.16u w=0.74u l=0.13u
X5381 C_uq16 a_10289_21623# VDD VDD sg13_lv_pmos ad=0.42p pd=2.99u as=0.2114p ps=1.54u w=1.12u l=0.13u
X5382 VDD a_40546_10649# X_uq147 VDD sg13_lv_pmos ad=0.2114p pd=1.54u as=0.42p ps=2.99u w=1.12u l=0.13u
X5383 VDD X_uq343 a_38526_10685# VDD sg13_lv_pmos ad=0.2114p pd=1.54u as=0.2856p ps=2.36u w=0.84u l=0.13u
X5384 a_12582_24183# D_uq5 Y_uq97 VDD sg13_lv_pmos ad=0.2128p pd=1.5u as=0.3808p ps=2.92u w=1.12u l=0.13u
X5385 VDD Y_uq186 a_10428_35594# VDD sg13_lv_pmos ad=0.36237p pd=2.605u as=79.8f ps=0.8u w=0.42u l=0.13u
X5386 Q_uq53 a_44886_67368# VDD VDD sg13_lv_pmos ad=0.3808p pd=2.92u as=0.2128p ps=1.5u w=1.12u l=0.13u
X5387 VDD VSS VDD VDD sg13_lv_pmos ad=0.34p pd=2.68u as=0 ps=0 w=1u l=1u
X5388 a_40642_7625# A_uq94 VSS VSS sg13_lv_nmos ad=0.187p pd=1.78u as=0.14875p ps=1.16u w=0.55u l=0.13u
X5389 VDD L_HI_uq38 a_35954_69630# VDD sg13_lv_pmos ad=0.36237p pd=2.605u as=79.8f ps=0.8u w=0.42u l=0.13u
X5390 a_29448_64705# a_29579_64315# a_28867_64308# VDD sg13_lv_pmos ad=0.34p pd=2.68u as=0.2048p ps=1.63u w=1u l=0.13u
X5391 a_3539_37753# a_3575_38075# VSS VSS sg13_lv_nmos ad=0.1428p pd=1.52u as=0.1426p ps=1.16u w=0.42u l=0.5u
X5392 VSS a_31078_66574# a_30797_66796# VSS sg13_lv_nmos ad=79.8f pd=0.8u as=0.1428p ps=1.52u w=0.42u l=0.5u
X5393 VDD L_HI_uq37 a_39256_69318# VDD sg13_lv_pmos ad=1.42837p pd=8.61u as=79.8f ps=0.8u w=0.42u l=0.13u
X5394 X_uq348 a_37972_63620# VDD VDD sg13_lv_pmos ad=0.42p pd=2.99u as=0.2114p ps=1.54u w=1.12u l=0.13u
X5395 a_50002_68131# L_HI_uq31 VSS VSS sg13_lv_nmos ad=37.8f pd=0.6u as=0.1701p ps=1.65u w=0.42u l=0.13u
X5396 VDD a_7321_33723# X_uq286 VDD sg13_lv_pmos ad=0.2254p pd=1.53u as=0.4256p ps=3u w=1.12u l=0.13u
X5397 a_9615_34039# C_uq31 D_uq17 VSS sg13_lv_nmos ad=0.1406p pd=1.12u as=0.2516p ps=2.16u w=0.74u l=0.15u
X5398 a_10385_41193# a_10383_41975# a_10345_43188# VSS sg13_lv_nmos ad=0.3473p pd=2.71u as=0.12665p ps=1.145u w=0.74u l=0.13u
X5399 X_uq175 a_12593_18599# VDD VDD sg13_lv_pmos ad=0.42p pd=2.99u as=0.2114p ps=1.54u w=1.12u l=0.13u
X5400 VSS A_uq87 Y_uq11 VSS sg13_lv_nmos ad=0.2516p pd=2.16u as=0.1406p ps=1.12u w=0.74u l=0.13u
X5401 VDD q[9] a_36126_9173# VDD sg13_lv_pmos ad=0.2114p pd=1.54u as=0.2856p ps=2.36u w=0.84u l=0.13u
X5402 a_39622_63550# Q_uq29 VSS VSS sg13_lv_nmos ad=0.1428p pd=1.52u as=79.8f ps=0.8u w=0.42u l=0.13u
X5403 a_37366_65824# a_37809_65867# a_37749_65903# VDD sg13_lv_pmos ad=79.8f pd=0.8u as=63f ps=0.72u w=0.42u l=0.13u
X5404 a_36502_67336# a_36945_67379# a_36885_67415# VDD sg13_lv_pmos ad=79.8f pd=0.8u as=63f ps=0.72u w=0.42u l=0.13u
X5405 a_37329_65392# X_uq435 VDD VDD sg13_lv_pmos ad=0.2464p pd=1.56u as=0.3808p ps=2.92u w=1.12u l=0.13u
X5406 a_7346_22058# a_7461_22059# VDD VDD sg13_lv_pmos ad=0.34p pd=2.68u as=0.2254p ps=1.53u w=1u l=0.5u
X5407 X_uq152 a_38526_10685# VDD VDD sg13_lv_pmos ad=0.42p pd=2.99u as=0.2114p ps=1.54u w=1.12u l=0.13u
X5408 a_47644_66098# a_47387_66217# a_47806_66294# VSS sg13_lv_nmos ad=0.1428p pd=1.52u as=37.8f ps=0.6u w=0.42u l=0.13u
X5409 VDD L_HI_uq39 a_32306_69630# VDD sg13_lv_pmos ad=0.36237p pd=2.605u as=79.8f ps=0.8u w=0.42u l=0.13u
X5410 VDD a_44866_7625# X_uq42 VDD sg13_lv_pmos ad=0.2114p pd=1.54u as=0.42p ps=2.99u w=1.12u l=0.13u
X5411 a_80112_24782# a_79170_24589# a_79910_24544# VDD sg13_lv_pmos ad=93.45f pd=0.865u as=0.2048p ps=1.63u w=0.42u l=0.13u
X5412 a_11557_24183# C_uq19 a_11455_24183# VDD sg13_lv_pmos ad=0.2128p pd=1.5u as=0.2128p ps=1.5u w=1.12u l=0.13u
X5413 VDD Y_uq197 a_8837_36271# VDD sg13_lv_pmos ad=0.1563p pd=1.22u as=0.147p ps=1.54u w=0.42u l=0.13u
X5414 Y_uq252 a_36730_64400# VSS VSS sg13_lv_nmos ad=0.1406p pd=1.12u as=0.17255p ps=1.25u w=0.74u l=0.13u
X5415 a_5474_35214# a_5047_36237# VDD VDD sg13_lv_pmos ad=63f pd=0.72u as=0.1563p ps=1.22u w=0.42u l=0.13u
X5416 VSS a_42562_7625# X_uq44 VSS sg13_lv_nmos ad=0.14875p pd=1.16u as=0.2886p ps=2.26u w=0.74u l=0.13u
X5417 a_10510_24183# B_uq58 VDD VDD sg13_lv_pmos ad=0.2464p pd=1.56u as=0.3808p ps=2.92u w=1.12u l=0.13u
X5418 VDD a_7321_41297# A0 VDD sg13_lv_pmos ad=0.2114p pd=1.54u as=0.42p ps=2.99u w=1.12u l=0.13u
X5419 a_41937_69609# clk VDD VDD sg13_lv_pmos ad=0.4088p pd=2.97u as=1.621p ps=10.08u w=1.12u l=0.13u
X5420 a_51057_67379# clk VDD VDD sg13_lv_pmos ad=0.4088p pd=2.97u as=1.17087p ps=7.02u w=1.12u l=0.13u
X5421 VSS VDD VSS VSS sg13_lv_nmos ad=0.1428p pd=1.52u as=0 ps=-0 w=0.42u l=1u
X5422 VDD a_43714_6863# X_uq7 VDD sg13_lv_pmos ad=0.2114p pd=1.54u as=0.42p ps=2.99u w=1.12u l=0.13u
X5423 B_uq42 a_79053_23023# VDD VDD sg13_lv_pmos ad=0.4256p pd=3u as=0.2254p ps=1.53u w=1.12u l=0.13u
X5424 VSS a_27608_68082# X_uq420 VSS sg13_lv_nmos ad=0.14875p pd=1.16u as=0.2886p ps=2.26u w=0.74u l=0.13u
X5425 VDD a_45644_67655# Q_uq51 VDD sg13_lv_pmos ad=0.2128p pd=1.5u as=0.3808p ps=2.92u w=1.12u l=0.13u
X5426 VDD A_uq82 a_38622_6937# VDD sg13_lv_pmos ad=0.2114p pd=1.54u as=0.2856p ps=2.36u w=0.84u l=0.13u
X5427 VSS X_uq433 C_uq50 VSS sg13_lv_nmos ad=0.2516p pd=2.16u as=0.1406p ps=1.12u w=0.74u l=0.13u
X5428 a_52156_67610# L_HI_uq23 VDD VDD sg13_lv_pmos ad=79.8f pd=0.8u as=1.19383p ps=7.16u w=0.42u l=0.13u
X5429 VSS a_5051_34111# a_5087_34043# VSS sg13_lv_nmos ad=79.8f pd=0.8u as=0.1428p ps=1.52u w=0.42u l=0.5u
X5430 a_9583_41709# a_9594_41669# a_9583_42043# VSS sg13_lv_nmos ad=0.3473p pd=2.71u as=0.12665p ps=1.145u w=0.74u l=0.13u
X5431 a_38274_10221# a_38052_9965# VDD VDD sg13_lv_pmos ad=0.1176p pd=1.33u as=0.2618p ps=1.63u w=1.12u l=0.13u
X5432 a_33027_65856# Y_uq280 a_32913_65856# VDD sg13_lv_pmos ad=0.2128p pd=1.5u as=0.2464p ps=1.56u w=1.12u l=0.13u
X5433 Y_uq89 D_uq5 a_12160_23135# VDD sg13_lv_pmos ad=0.3808p pd=2.92u as=0.2128p ps=1.5u w=1.12u l=0.13u
X5434 a_78651_26745# a_78625_26709# VDD VDD sg13_lv_pmos ad=0.34p pd=2.68u as=0.36237p ps=2.605u w=1u l=0.13u
X5435 a_30897_65073# clk VSS VSS sg13_lv_nmos ad=0.2516p pd=2.16u as=4.19255p ps=26u w=0.74u l=0.13u
X5436 VSS a_5811_42044# a_5847_41975# VSS sg13_lv_nmos ad=5.69525p pd=37.455u as=0.2516p ps=2.16u w=0.74u l=0.13u
X5437 D_uq51 a_46530_66674# VSS VSS sg13_lv_nmos ad=0.2516p pd=2.16u as=0.1426p ps=1.16u w=0.74u l=0.13u
X5438 VDD a_30214_66574# a_29933_66796# VDD sg13_lv_pmos ad=0.1523p pd=1.38u as=0.34p ps=2.68u w=1u l=0.5u
X5439 a_41808_69643# a_42039_69752# a_41494_69853# VSS sg13_lv_nmos ad=0.2373p pd=1.97u as=79.8f ps=0.8u w=0.42u l=0.13u
X5440 VSS a_3550_35754# a_3546_36677# VSS sg13_lv_nmos ad=5.43125p pd=35.255u as=0.2516p ps=2.16u w=0.74u l=0.13u
X5441 Q_uq18 a_3535_37434# VSS VSS sg13_lv_nmos ad=0.2516p pd=2.16u as=0.1406p ps=1.12u w=0.74u l=0.13u
X5442 a_35793_68880# X_uq435 VDD VDD sg13_lv_pmos ad=0.2464p pd=1.56u as=0.3808p ps=2.92u w=1.12u l=0.13u
X5443 VSS X_uq444 C_uq73 VSS sg13_lv_nmos ad=0.2516p pd=2.16u as=0.1406p ps=1.12u w=0.74u l=0.13u
X5444 a_42288_64769# a_42519_64355# a_41974_64312# VSS sg13_lv_nmos ad=0.2373p pd=1.97u as=79.8f ps=0.8u w=0.42u l=0.13u
X5445 VDD a_31739_65171# a_31996_65314# VDD sg13_lv_pmos ad=1.41367p pd=8.85u as=79.8f ps=0.8u w=0.42u l=0.13u
X5446 Y_uq196 a_5809_37466# VDD VDD sg13_lv_pmos ad=0.2128p pd=1.5u as=0.3808p ps=2.92u w=1.12u l=0.13u
X5447 VSS a_6590_25619# a_6309_25921# VSS sg13_lv_nmos ad=79.8f pd=0.8u as=0.1428p ps=1.52u w=0.42u l=0.5u
X5448 VSS a_41937_69609# a_42039_69752# VSS sg13_lv_nmos ad=2.01085p pd=12.81u as=0.2516p ps=2.16u w=0.74u l=0.13u
X5449 a_4490_21882# L_HI_uq1 VSS VSS sg13_lv_nmos ad=37.8f pd=0.6u as=0.1701p ps=1.65u w=0.42u l=0.13u
X5450 VDD VSS VDD VDD sg13_lv_pmos ad=0.19p pd=1.38u as=0 ps=0 w=1u l=1u
X5451 VDD VSS VDD VDD sg13_lv_pmos ad=0.34p pd=2.68u as=0 ps=0 w=1u l=1u
X5452 VSS B_uq68 a_76957_28601# VSS sg13_lv_nmos ad=0.2516p pd=2.16u as=0.1406p ps=1.12u w=0.74u l=0.13u
X5453 a_37756_69850# a_37499_69707# a_37918_69630# VSS sg13_lv_nmos ad=0.1428p pd=1.52u as=37.8f ps=0.6u w=0.42u l=0.13u
X5454 a_30033_68891# clk VSS VSS sg13_lv_nmos ad=0.2516p pd=2.16u as=1.9335p ps=12.315u w=0.74u l=0.13u
X5455 A_uq81 a_39014_10301# VDD VDD sg13_lv_pmos ad=0.3976p pd=2.95u as=0.2226p ps=1.535u w=1.12u l=0.13u
X5456 a_6559_42743# a_6559_42907# a_6595_42871# VSS sg13_lv_nmos ad=0.1428p pd=1.52u as=37.8f ps=0.6u w=0.42u l=0.13u
X5457 VSS C1_uq5 Y_uq86 VSS sg13_lv_nmos ad=0.1406p pd=1.12u as=0.2516p ps=2.16u w=0.74u l=0.13u
X5458 VDD B_uq66 a_4562_23423# VDD sg13_lv_pmos ad=0.2618p pd=1.63u as=0.2856p ps=2.36u w=0.84u l=0.13u
X5459 VDD VSS VDD VDD sg13_lv_pmos ad=0.34p pd=2.68u as=0 ps=0 w=1u l=1u
X5460 X_uq243 a_11633_25435# VDD VDD sg13_lv_pmos ad=0.42p pd=2.99u as=0.2114p ps=1.54u w=1.12u l=0.13u
X5461 VSS X_uq449 C_uq48 VSS sg13_lv_nmos ad=0.2516p pd=2.16u as=0.1406p ps=1.12u w=0.74u l=0.13u
X5462 VDD VSS VDD VDD sg13_lv_pmos ad=0.34p pd=2.68u as=0 ps=0 w=1u l=1u
X5463 a_34520_68844# X_uq431 VSS VSS sg13_lv_nmos ad=0.187p pd=1.78u as=0.14875p ps=1.16u w=0.55u l=0.13u
X5464 VDD VSS VDD VDD sg13_lv_pmos ad=0.19p pd=1.38u as=0 ps=0 w=1u l=1u
X5465 a_40802_69305# a_39624_69241# a_40406_69160# VSS sg13_lv_nmos ad=37.8f pd=0.6u as=0.1428p ps=1.52u w=0.42u l=0.13u
X5466 a_7316_25113# L_HI_uq5 VDD VDD sg13_lv_pmos ad=79.8f pd=0.8u as=1.17282p ps=7.015u w=0.42u l=0.13u
X5467 VSS a_46808_63546# q[21] VSS sg13_lv_nmos ad=0.14875p pd=1.16u as=0.2886p ps=2.26u w=0.74u l=0.13u
X5468 D_uq36 a_49890_65162# VSS VSS sg13_lv_nmos ad=0.2516p pd=2.16u as=0.1426p ps=1.16u w=0.74u l=0.13u
X5469 VDD VSS VDD VDD sg13_lv_pmos ad=0.34p pd=2.68u as=0 ps=0 w=1u l=1u
X5470 a_9583_39287# Y_uq210 VDD VDD sg13_lv_pmos ad=79.8f pd=0.8u as=1.17462p ps=7.44u w=0.42u l=0.13u
X5471 D_uq49 C_uq51 VSS VSS sg13_lv_nmos ad=0.2618p pd=2.22u as=0.1463p ps=1.15u w=0.77u l=0.13u
X5472 VDD a_29265_69609# a_29367_69752# VDD sg13_lv_pmos ad=1.6733p pd=10.405u as=0.3864p ps=2.93u w=1.12u l=0.13u
X5473 X_uq73 a_44870_9149# VSS VSS sg13_lv_nmos ad=0.2516p pd=2.16u as=0.1469p ps=1.155u w=0.74u l=0.13u
X5474 Y_uq319 X_uq447 VSS VSS sg13_lv_nmos ad=0.1694p pd=1.21u as=0.2618p ps=2.22u w=0.77u l=0.13u
X5475 a_46690_9137# A_uq37 VSS VSS sg13_lv_nmos ad=0.187p pd=1.78u as=0.14875p ps=1.16u w=0.55u l=0.13u
X5476 VDD a_44698_65283# X_uq397 VDD sg13_lv_pmos ad=0.2254p pd=1.53u as=0.4256p ps=3u w=1.12u l=0.13u
X5477 a_50997_67415# a_50640_67372# VDD VDD sg13_lv_pmos ad=63f pd=0.72u as=0.1563p ps=1.22u w=0.42u l=0.13u
X5478 a_8086_31722# clk VSS VSS sg13_lv_nmos ad=0.2516p pd=2.16u as=5.69177p ps=37.635u w=0.74u l=0.13u
X5479 a_78625_26709# a_79068_26752# a_78365_27179# VSS sg13_lv_nmos ad=79.8f pd=0.8u as=0.1296p ps=1.52u w=0.42u l=0.13u
X5480 VSS C_uq19 a_9746_24671# VSS sg13_lv_nmos ad=0.1045p pd=0.93u as=0.187p ps=1.78u w=0.55u l=0.13u
X5481 VSS a_40474_66795# D_uq48 VSS sg13_lv_nmos ad=0.1426p pd=1.16u as=0.2516p ps=2.16u w=0.74u l=0.13u
X5482 VSS a_77219_28967# C_uq27 VSS sg13_lv_nmos ad=0.14875p pd=1.16u as=0.2886p ps=2.26u w=0.74u l=0.13u
X5483 VDD a_28280_69594# X_uq455 VDD sg13_lv_pmos ad=0.2114p pd=1.54u as=0.42p ps=2.99u w=1.12u l=0.13u
X5484 B_uq92 a_5051_39674# VDD VDD sg13_lv_pmos ad=0.2128p pd=1.5u as=0.3808p ps=2.92u w=1.12u l=0.13u
X5485 a_52088_69594# Y_uq352 VDD VDD sg13_lv_pmos ad=0.2856p pd=2.36u as=0.2114p ps=1.54u w=0.84u l=0.13u
X5486 a_3535_31673# a_3535_31228# VDD VDD sg13_lv_pmos ad=79.8f pd=0.8u as=1.31615p ps=8.395u w=0.42u l=0.13u
X5487 VSS X_uq256 a_8561_23923# VSS sg13_lv_nmos ad=0.14875p pd=1.16u as=0.187p ps=1.78u w=0.55u l=0.13u
X5488 a_42293_63528# a_42417_63625# VDD VDD sg13_lv_pmos ad=0.2442p pd=2.06u as=1.4745p ps=9.07u w=0.66u l=0.13u
X5489 X_uq170 a_9713_17875# VDD VDD sg13_lv_pmos ad=0.42p pd=2.99u as=0.2114p ps=1.54u w=1.12u l=0.13u
X5490 a_3535_41421# a_3546_41381# a_3535_41755# VSS sg13_lv_nmos ad=0.3473p pd=2.71u as=0.12665p ps=1.145u w=0.74u l=0.13u
X5491 a_44024_63546# Y_uq292 VSS VSS sg13_lv_nmos ad=0.187p pd=1.78u as=0.14875p ps=1.16u w=0.55u l=0.13u
X5492 Y_uq249 a_40762_64400# VSS VSS sg13_lv_nmos ad=0.1406p pd=1.12u as=0.17255p ps=1.25u w=0.74u l=0.13u
X5493 B_uq68 a_78852_19529# VSS VSS sg13_lv_nmos ad=0.2516p pd=2.16u as=0.1331p ps=1.12u w=0.74u l=0.13u
X5494 a_35842_7625# q[6] VDD VDD sg13_lv_pmos ad=0.2856p pd=2.36u as=0.2114p ps=1.54u w=0.84u l=0.13u
X5495 a_5083_34571# a_5058_36197# a_5092_34839# VDD sg13_lv_pmos ad=0.1428p pd=1.52u as=79.8f ps=0.8u w=0.42u l=0.13u
X5496 X_uq197 a_75295_20693# VSS VSS sg13_lv_nmos ad=0.2886p pd=2.26u as=0.14875p ps=1.16u w=0.74u l=0.13u
X5497 a_50259_66824# a_50411_66876# VDD VDD sg13_lv_pmos ad=0.3864p pd=2.93u as=1.19383p ps=7.16u w=1.12u l=0.13u
X5498 VDD a_79153_23681# a_78872_23983# VDD sg13_lv_pmos ad=0.1523p pd=1.38u as=0.34p ps=2.68u w=1u l=0.5u
X5499 a_47864_66570# Y_uq331 VDD VDD sg13_lv_pmos ad=0.2856p pd=2.36u as=0.2114p ps=1.54u w=0.84u l=0.13u
X5500 a_5800_25211# a_5774_25116# VDD VDD sg13_lv_pmos ad=0.34p pd=2.68u as=0.36237p ps=2.605u w=1u l=0.13u
X5501 a_79134_28340# a_79286_28224# VSS VSS sg13_lv_nmos ad=0.2516p pd=2.16u as=2.70687p ps=17.445u w=0.74u l=0.13u
X5502 Q_uq27 a_5809_43290# VSS VSS sg13_lv_nmos ad=0.2516p pd=2.16u as=0.1406p ps=1.12u w=0.74u l=0.13u
X5503 B2_uq6 X_uq241 VSS VSS sg13_lv_nmos ad=0.2516p pd=2.16u as=0.2516p ps=2.16u w=0.74u l=0.13u
X5504 VSS a_7316_21361# a_6965_21480# VSS sg13_lv_nmos ad=79.8f pd=0.8u as=0.1428p ps=1.52u w=0.42u l=0.13u
X5505 a_8075_39865# a_8111_40187# VDD VDD sg13_lv_pmos ad=0.34p pd=2.68u as=0.2254p ps=1.53u w=1u l=0.5u
X5506 a_37968_64348# a_38487_64355# a_39227_64705# VSS sg13_lv_nmos ad=0.3473p pd=2.71u as=0.12665p ps=1.145u w=0.74u l=0.13u
X5507 a_5314_23633# a_5115_23696# VSS VSS sg13_lv_nmos ad=0.27427p pd=2.28u as=1.6335p ps=10.61u w=0.795u l=0.13u
X5508 a_4238_22092# a_4681_21848# a_4621_22260# VDD sg13_lv_pmos ad=79.8f pd=0.8u as=63f ps=0.72u w=0.42u l=0.13u
X5509 VSS Y_uq104 a_78208_25253# VSS sg13_lv_nmos ad=0.13395p pd=1.12u as=0.198p ps=1.27u w=0.55u l=0.13u
X5510 a_5869_39807# a_5833_39781# VDD VDD sg13_lv_pmos ad=0.2975p pd=1.595u as=0.2198p ps=1.52u w=1u l=0.13u
X5511 VDD a_8086_41514# a_8082_42437# VDD sg13_lv_pmos ad=1.5243p pd=9.795u as=0.3864p ps=2.93u w=1.12u l=0.13u
X5512 a_5047_36237# a_5092_34839# VSS VSS sg13_lv_nmos ad=0.2516p pd=2.16u as=0.1626p ps=1.415u w=0.74u l=0.13u
X5513 q[14] a_37588_63620# VSS VSS sg13_lv_nmos ad=0.2886p pd=2.26u as=0.14875p ps=1.16u w=0.74u l=0.13u
X5514 X_uq277 a_75967_29041# VDD VDD sg13_lv_pmos ad=0.42p pd=2.99u as=0.2114p ps=1.54u w=1.12u l=0.13u
X5515 VSS L_HI_uq29 a_36336_67806# VSS sg13_lv_nmos ad=0.1626p pd=1.415u as=60.89999f ps=0.71u w=0.42u l=0.13u
X5516 VSS a_51142_68844# a_50861_69146# VSS sg13_lv_nmos ad=79.8f pd=0.8u as=0.1428p ps=1.52u w=0.42u l=0.5u
X5517 VSS a_35726_10067# A_uq90 VSS sg13_lv_nmos ad=0.1469p pd=1.155u as=0.2516p ps=2.16u w=0.74u l=0.13u
X5518 B a_37374_8449# VDD VDD sg13_lv_pmos ad=0.42p pd=2.99u as=0.2114p ps=1.54u w=1.12u l=0.13u
X5519 a_5062_35274# clk VSS VSS sg13_lv_nmos ad=0.2516p pd=2.16u as=4.1981p ps=26.905u w=0.74u l=0.13u
X5520 a_40082_66294# a_40887_65867# a_40342_65824# VDD sg13_lv_pmos ad=0.1428p pd=1.52u as=79.8f ps=0.8u w=0.42u l=0.13u
X5521 q[13] a_36052_63620# VSS VSS sg13_lv_nmos ad=0.2886p pd=2.26u as=0.14875p ps=1.16u w=0.74u l=0.13u
X5522 D_uq13 B_uq73 a_8869_32303# VDD sg13_lv_pmos ad=0.3808p pd=2.92u as=0.1176p ps=1.33u w=1.12u l=0.13u
X5523 A_uq71 a_43334_10301# VSS VSS sg13_lv_nmos ad=0.2516p pd=2.16u as=0.1469p ps=1.155u w=0.74u l=0.13u
X5524 a_9609_34825# Y_uq219 VDD VDD sg13_lv_pmos ad=0.2856p pd=2.36u as=0.1596p ps=1.22u w=0.84u l=0.13u
X5525 a_50064_68131# a_50295_68240# a_49750_68341# VSS sg13_lv_nmos ad=0.2373p pd=1.97u as=79.8f ps=0.8u w=0.42u l=0.13u
X5526 Q_uq40 a_52374_64344# VDD VDD sg13_lv_pmos ad=0.3808p pd=2.92u as=0.2128p ps=1.5u w=1.12u l=0.13u
X5527 a_43152_66294# D_uq43 a_43058_66294# VSS sg13_lv_nmos ad=60.89999f pd=0.71u as=0.1428p ps=1.52u w=0.42u l=0.13u
X5528 a_10347_35900# clk VDD VDD sg13_lv_pmos ad=0.4088p pd=2.97u as=1.12945p ps=7.155u w=1.12u l=0.13u
X5529 a_47760_69948# a_48279_69752# a_49019_69707# VSS sg13_lv_nmos ad=0.3473p pd=2.71u as=0.12665p ps=1.145u w=0.74u l=0.13u
X5530 VDD din[1] a_77215_28253# VDD sg13_lv_pmos ad=0.2114p pd=1.54u as=0.2856p ps=2.36u w=0.84u l=0.13u
X5531 a_44792_69594# X_uq450 VDD VDD sg13_lv_pmos ad=0.2856p pd=2.36u as=0.2114p ps=1.54u w=0.84u l=0.13u
X5532 a_79619_21407# B_uq68 VDD VDD sg13_lv_pmos ad=0.2856p pd=2.36u as=0.2114p ps=1.54u w=0.84u l=0.13u
X5533 VSS q[9] a_36126_9173# VSS sg13_lv_nmos ad=0.14875p pd=1.16u as=0.187p ps=1.78u w=0.55u l=0.13u
X5534 VSS a_79502_29084# a_79502_29084# VSS sg13_lv_nmos ad=2.70687p pd=17.445u as=0.111p ps=1.34u w=0.3u l=0.13u
X5535 Y_uq201 B_uq85 VDD VDD sg13_lv_pmos ad=0.2128p pd=1.5u as=0.3808p ps=2.92u w=1.12u l=0.13u
X5536 VDD a_42658_10649# X_uq141 VDD sg13_lv_pmos ad=0.2114p pd=1.54u as=0.42p ps=2.99u w=1.12u l=0.13u
X5537 VDD a_36206_10067# A_uq89 VDD sg13_lv_pmos ad=0.2226p pd=1.535u as=0.3976p ps=2.95u w=1.12u l=0.13u
X5538 VSS a_35770_65283# X_uq387 VSS sg13_lv_nmos ad=0.1426p pd=1.16u as=0.2516p ps=2.16u w=0.74u l=0.13u
X5539 B_uq43 a_79044_21489# VDD VDD sg13_lv_pmos ad=0.3808p pd=2.92u as=0.1918p ps=1.5u w=1.12u l=0.13u
X5540 a_7705_35563# Y_uq190 Y_uq181 VSS sg13_lv_nmos ad=0.1406p pd=1.12u as=0.2516p ps=2.16u w=0.74u l=0.13u
X5541 X_uq192 a_12209_20111# VSS VSS sg13_lv_nmos ad=0.2886p pd=2.26u as=0.14875p ps=1.16u w=0.74u l=0.13u
X5542 VDD a_45634_8375# B_uq2 VDD sg13_lv_pmos ad=0.2114p pd=1.54u as=0.42p ps=2.99u w=1.12u l=0.13u
X5543 a_38651_66217# a_37809_65867# a_38557_66217# VSS sg13_lv_nmos ad=0.12665p pd=1.145u as=0.1428p ps=1.52u w=0.42u l=0.13u
X5544 a_44554_9137# X_uq94 VDD VDD sg13_lv_pmos ad=0.2856p pd=2.36u as=0.2618p ps=1.63u w=0.84u l=0.13u
X5545 B_uq43 a_79044_21489# VSS VSS sg13_lv_nmos ad=0.2516p pd=2.16u as=0.1331p ps=1.12u w=0.74u l=0.13u
X5546 VSS din[6] a_75967_29041# VSS sg13_lv_nmos ad=0.14875p pd=1.16u as=0.187p ps=1.78u w=0.55u l=0.13u
X5547 a_49019_69707# a_48177_69609# a_47760_69948# VDD sg13_lv_pmos ad=0.2048p pd=1.63u as=0.34p ps=2.68u w=1u l=0.13u
X5548 Y_uq0 A_uq75 VSS VSS sg13_lv_nmos ad=0.1406p pd=1.12u as=0.2516p ps=2.16u w=0.74u l=0.13u
X5549 Y_uq230 X_uq323 VSS VSS sg13_lv_nmos ad=0.2516p pd=2.16u as=0.2516p ps=2.16u w=0.74u l=0.13u
X5550 VDD a_38182_65062# a_37901_65284# VDD sg13_lv_pmos ad=0.1523p pd=1.38u as=0.34p ps=2.68u w=1u l=0.5u
X5551 a_3571_31699# a_3550_32372# a_3535_31228# VSS sg13_lv_nmos ad=0.1428p pd=1.52u as=0.12665p ps=1.145u w=0.42u l=0.13u
X5552 VDD Y_uq13 a_35166_6937# VDD sg13_lv_pmos ad=0.2114p pd=1.54u as=0.2856p ps=2.36u w=0.84u l=0.13u
X5553 a_28559_63880# Y_uq256 a_28457_63880# VDD sg13_lv_pmos ad=0.2464p pd=1.56u as=0.2128p ps=1.5u w=1.12u l=0.13u
X5554 VSS a_51320_69594# A_uq19 VSS sg13_lv_nmos ad=0.14875p pd=1.16u as=0.2886p ps=2.26u w=0.74u l=0.13u
X5555 X_uq89 a_34302_8449# VSS VSS sg13_lv_nmos ad=0.2886p pd=2.26u as=0.14875p ps=1.16u w=0.74u l=0.13u
X5556 a_5809_35739# a_5833_35847# VSS VSS sg13_lv_nmos ad=0.1428p pd=1.52u as=0.1426p ps=1.16u w=0.42u l=0.5u
X5557 a_6157_21166# a_5800_21123# VDD VDD sg13_lv_pmos ad=63f pd=0.72u as=0.1563p ps=1.22u w=0.42u l=0.13u
X5558 a_8869_33750# X_uq286 VDD VDD sg13_lv_pmos ad=0.1225p pd=1.245u as=0.36p ps=2.72u w=1u l=0.13u
X5559 VDD B_uq96 B_uq93 VDD sg13_lv_pmos ad=0.2198p pd=1.53u as=0.2128p ps=1.5u w=1.12u l=0.13u
X5560 a_43714_6863# X_uq78 VDD VDD sg13_lv_pmos ad=0.2856p pd=2.36u as=0.2114p ps=1.54u w=0.84u l=0.13u
X5561 VSS Y_uq209 a_3539_39079# VSS sg13_lv_nmos ad=79.8f pd=0.8u as=0.1428p ps=1.52u w=0.42u l=0.13u
X5562 a_36226_7625# q[7] VSS VSS sg13_lv_nmos ad=0.187p pd=1.78u as=0.14875p ps=1.16u w=0.55u l=0.13u
X5563 a_5809_39675# A0 a_6215_39807# VSS sg13_lv_nmos ad=0.1628p pd=1.18u as=0.3367p ps=1.65u w=0.74u l=0.13u
X5564 a_8075_37753# a_8111_38075# VDD VDD sg13_lv_pmos ad=0.34p pd=2.68u as=0.2254p ps=1.53u w=1u l=0.5u
X5565 a_75877_23253# C1_uq4 Y_uq82 VDD sg13_lv_pmos ad=0.2128p pd=1.5u as=0.3808p ps=2.92u w=1.12u l=0.13u
X5566 a_45763_67332# a_46323_67455# a_46234_67491# VDD sg13_lv_pmos ad=0.2048p pd=1.63u as=93.45f ps=0.865u w=0.42u l=0.13u
X5567 a_44853_68927# a_44496_68884# VDD VDD sg13_lv_pmos ad=63f pd=0.72u as=0.1563p ps=1.22u w=0.42u l=0.13u
X5568 VSS VDD VSS VSS sg13_lv_nmos ad=0.1428p pd=1.52u as=0 ps=-0 w=0.42u l=1u
X5569 D_uq8 C_uq25 a_4411_25191# VDD sg13_lv_pmos ad=0.3808p pd=2.92u as=0.2128p ps=1.5u w=1.12u l=0.13u
X5570 VSS Y_uq164 a_10806_33275# VSS sg13_lv_nmos ad=0.1701p pd=1.65u as=37.8f ps=0.6u w=0.42u l=0.13u
X5571 X_uq224 a_10001_23923# VDD VDD sg13_lv_pmos ad=0.42p pd=2.99u as=0.2114p ps=1.54u w=1.12u l=0.13u
X5572 D_uq14 Y_uq159 VSS VSS sg13_lv_nmos ad=0.1406p pd=1.12u as=0.2516p ps=2.16u w=0.74u l=0.13u
X5573 VSS Y_uq74 a_78671_22959# VSS sg13_lv_nmos ad=79.8f pd=0.8u as=0.1428p ps=1.52u w=0.42u l=0.13u
X5574 VDD a_8833_34465# A2_uq9 VDD sg13_lv_pmos ad=0.3808p pd=2.92u as=0.3808p ps=2.92u w=1.12u l=0.13u
X5575 VDD a_43138_9137# B_uq9 VDD sg13_lv_pmos ad=0.2114p pd=1.54u as=0.42p ps=2.99u w=1.12u l=0.13u
X5576 a_41829_65979# a_40887_65867# a_41627_66217# VDD sg13_lv_pmos ad=93.45f pd=0.865u as=0.2048p ps=1.63u w=0.42u l=0.13u
X5577 VDD A_uq88 a_38628_10301# VDD sg13_lv_pmos ad=0.2226p pd=1.535u as=0.1596p ps=1.22u w=0.84u l=0.13u
X5578 a_40674_10221# a_40452_9965# VDD VDD sg13_lv_pmos ad=0.1176p pd=1.33u as=0.2618p ps=1.63u w=1.12u l=0.13u
X5579 B_uq6 a_45150_8449# VDD VDD sg13_lv_pmos ad=0.42p pd=2.99u as=0.2114p ps=1.54u w=1.12u l=0.13u
X5580 Y_uq201 S_uq0 a_7727_38815# VSS sg13_lv_nmos ad=0.2516p pd=2.16u as=0.1406p ps=1.12u w=0.74u l=0.13u
X5581 VSS X_uq66 a_36516_8453# VSS sg13_lv_nmos ad=0.17255p pd=1.25u as=0.187p ps=1.78u w=0.55u l=0.13u
X5582 a_33494_68880# X_uq434 Y_uq344 VDD sg13_lv_pmos ad=0.1176p pd=1.33u as=0.3808p ps=2.92u w=1.12u l=0.13u
X5583 Y_uq205 A0 VSS VSS sg13_lv_nmos ad=0.2618p pd=2.22u as=0.1463p ps=1.15u w=0.77u l=0.13u
X5584 C_uq37 D_uq30 VDD VDD sg13_lv_pmos ad=0.2128p pd=1.5u as=0.3808p ps=2.92u w=1.12u l=0.13u
X5585 L_HI_uq22 a_29130_66858# VDD VDD sg13_lv_pmos ad=0.3927p pd=2.99u as=1.19383p ps=7.16u w=1.155u l=0.13u
X5586 VDD D_uq51 a_47171_67415# VDD sg13_lv_pmos ad=0.1428p pd=1.52u as=79.8f ps=0.8u w=0.42u l=0.13u
X5587 VSS a_42417_64355# a_42519_64355# VSS sg13_lv_nmos ad=4.5737p pd=28.36u as=0.2516p ps=2.16u w=0.74u l=0.13u
X5588 VDD a_44476_67610# a_44421_67491# VDD sg13_lv_pmos ad=1.19383p pd=7.16u as=93.45f ps=0.865u w=0.42u l=0.13u
X5589 a_28848_69948# a_28822_69853# VSS VSS sg13_lv_nmos ad=0.2516p pd=2.16u as=0.1626p ps=1.415u w=0.74u l=0.13u
X5590 VDD X_uq159 a_37092_9965# VDD sg13_lv_pmos ad=0.2618p pd=1.63u as=0.2856p ps=2.36u w=0.84u l=0.13u
X5591 VSS a_40334_9489# X_uq80 VSS sg13_lv_nmos ad=0.1469p pd=1.155u as=0.2516p ps=2.16u w=0.74u l=0.13u
X5592 a_10349_35023# a_10347_35900# a_10428_35594# VSS sg13_lv_nmos ad=79.8f pd=0.8u as=0.1296p ps=1.52u w=0.42u l=0.13u
X5593 VDD X_uq328 a_32382_8449# VDD sg13_lv_pmos ad=0.2114p pd=1.54u as=0.2856p ps=2.36u w=0.84u l=0.13u
X5594 a_9583_31222# a_9583_31324# VDD VDD sg13_lv_pmos ad=0.3864p pd=2.93u as=0.2128p ps=1.5u w=1.12u l=0.13u
X5595 VSS A2_uq9 a_9615_34039# VSS sg13_lv_nmos ad=0.1406p pd=1.12u as=0.1406p ps=1.12u w=0.74u l=0.15u
X5596 A_uq76 a_41414_10301# VDD VDD sg13_lv_pmos ad=0.3976p pd=2.95u as=0.2226p ps=1.535u w=1.12u l=0.13u
X5597 a_5047_32685# a_5058_32645# a_5047_33019# VSS sg13_lv_nmos ad=0.3473p pd=2.71u as=0.12665p ps=1.145u w=0.74u l=0.13u
X5598 a_3535_31809# a_3550_32372# a_3535_31228# VDD sg13_lv_pmos ad=0.34p pd=2.68u as=0.2048p ps=1.63u w=1u l=0.13u
X5599 VDD clk a_51275_65364# VDD sg13_lv_pmos ad=1.37835p pd=8.63u as=0.4088p ps=2.97u w=1.12u l=0.13u
X5600 VSS X_uq319 a_4297_35327# VSS sg13_lv_nmos ad=0.14875p pd=1.16u as=0.187p ps=1.78u w=0.55u l=0.13u
X5601 VSS a_10347_35900# a_10383_35831# VSS sg13_lv_nmos ad=5.51925p pd=35.255u as=0.2516p ps=2.16u w=0.74u l=0.13u
X5602 VSS Y_uq75 a_12593_20111# VSS sg13_lv_nmos ad=0.14875p pd=1.16u as=0.187p ps=1.78u w=0.55u l=0.13u
X5603 a_5234_22898# a_5349_22897# VSS VSS sg13_lv_nmos ad=0.1428p pd=1.52u as=0.1426p ps=1.16u w=0.42u l=0.5u
X5604 a_48657_64344# X_uq431 VDD VDD sg13_lv_pmos ad=0.2464p pd=1.56u as=0.3808p ps=2.92u w=1.12u l=0.13u
X5605 VDD A_uq99 a_40734_9173# VDD sg13_lv_pmos ad=0.2114p pd=1.54u as=0.2856p ps=2.36u w=0.84u l=0.13u
X5606 a_9583_41709# a_9628_40311# VDD VDD sg13_lv_pmos ad=0.34p pd=2.68u as=0.36237p ps=2.605u w=1u l=0.13u
X5607 a_3535_41755# a_3550_40458# a_3535_41421# VDD sg13_lv_pmos ad=0.2048p pd=1.63u as=0.34p ps=2.68u w=1u l=0.13u
X5608 A_uq75 a_42078_8449# VSS VSS sg13_lv_nmos ad=0.2886p pd=2.26u as=0.14875p ps=1.16u w=0.74u l=0.13u
X5609 a_4297_43188# a_4299_42044# a_4337_41193# VDD sg13_lv_pmos ad=0.2048p pd=1.63u as=0.34p ps=2.68u w=1u l=0.13u
X5610 a_40545_68927# a_39603_68967# a_40451_68927# VDD sg13_lv_pmos ad=79.8f pd=0.8u as=0.1428p ps=1.52u w=0.42u l=0.13u
X5611 B_uq27 a_35454_10685# VDD VDD sg13_lv_pmos ad=0.42p pd=2.99u as=0.2114p ps=1.54u w=1.12u l=0.13u
X5612 VDD Y_uq210 a_9628_37719# VDD sg13_lv_pmos ad=0.1563p pd=1.22u as=0.147p ps=1.54u w=0.42u l=0.13u
X5613 VSS a_29315_66687# a_29315_66687# VSS sg13_lv_nmos ad=1.8643p pd=11.96u as=0.111p ps=1.34u w=0.3u l=0.13u
X5614 a_36202_8379# X_uq67 VSS VSS sg13_lv_nmos ad=0.187p pd=1.78u as=0.17255p ps=1.25u w=0.55u l=0.13u
X5615 VDD X_uq326 Y_uq235 VDD sg13_lv_pmos ad=0.2198p pd=1.53u as=0.2128p ps=1.5u w=1.12u l=0.13u
X5616 VDD Y_uq270 a_28484_65098# VDD sg13_lv_pmos ad=0.1523p pd=1.38u as=0.1428p ps=1.52u w=0.42u l=0.13u
X5617 a_75516_19181# X_uq251 VDD VDD sg13_lv_pmos ad=0.2464p pd=1.56u as=0.3808p ps=2.92u w=1.12u l=0.13u
X5618 VSS B_uq78 C_uq32 VSS sg13_lv_nmos ad=0.2516p pd=2.16u as=0.1406p ps=1.12u w=0.74u l=0.13u
X5619 a_6270_41419# Y_uq237 VSS VSS sg13_lv_nmos ad=37.8f pd=0.6u as=0.1701p ps=1.65u w=0.42u l=0.13u
X5620 a_10468_42743# Y_uq231 VDD VDD sg13_lv_pmos ad=79.8f pd=0.8u as=1.17462p ps=7.44u w=0.42u l=0.13u
X5621 Y_uq266 C_uq45 a_37443_64344# VDD sg13_lv_pmos ad=0.3808p pd=2.92u as=0.2128p ps=1.5u w=1.12u l=0.13u
X5622 VDD Y_uq228 a_9619_40043# VDD sg13_lv_pmos ad=0.36237p pd=2.605u as=79.8f ps=0.8u w=0.42u l=0.13u
X5623 VDD a_51142_68844# a_50861_69146# VDD sg13_lv_pmos ad=0.1523p pd=1.38u as=0.34p ps=2.68u w=1u l=0.5u
X5624 VSS Q_uq3 C1_uq5 VSS sg13_lv_nmos ad=0.2516p pd=2.16u as=0.2516p ps=2.16u w=0.74u l=0.13u
X5625 VDD Y_uq209 a_3539_39079# VDD sg13_lv_pmos ad=0.1523p pd=1.38u as=0.1428p ps=1.52u w=0.42u l=0.13u
X5626 Y_uq199 B_uq88 VDD VDD sg13_lv_pmos ad=0.2128p pd=1.5u as=0.3808p ps=2.92u w=1.12u l=0.13u
X5627 a_30460_66098# L_HI_uq22 VDD VDD sg13_lv_pmos ad=79.8f pd=0.8u as=1.41367p ps=8.85u w=0.42u l=0.13u
X5628 dout a_80575_25229# VSS VSS sg13_lv_nmos ad=0.2886p pd=2.26u as=0.14875p ps=1.16u w=0.74u l=0.13u
X5629 VDD Q_uq34 Y_uq265 VDD sg13_lv_pmos ad=0.3808p pd=2.92u as=0.3808p ps=2.92u w=1.12u l=0.13u
X5630 a_77618_27789# B1_uq7 VDD VDD sg13_lv_pmos ad=0.3808p pd=2.92u as=0.2128p ps=1.5u w=1.12u l=0.13u
X5631 a_36070_66574# Q_uq35 VSS VSS sg13_lv_nmos ad=0.1428p pd=1.52u as=79.8f ps=0.8u w=0.42u l=0.13u
X5632 a_44210_69318# D_uq58 VDD VDD sg13_lv_pmos ad=79.8f pd=0.8u as=0.1428p ps=1.52u w=0.42u l=0.13u
X5633 a_76651_26277# Y_uq127 VDD VDD sg13_lv_pmos ad=0.2128p pd=1.5u as=0.3808p ps=2.92u w=1.12u l=0.13u
X5634 VSS Y_uq93 Y_uq91 VSS sg13_lv_nmos ad=0.1463p pd=1.15u as=0.1694p ps=1.21u w=0.77u l=0.13u
X5635 VSS C1_uq2 B2_uq7 VSS sg13_lv_nmos ad=0.1406p pd=1.12u as=0.2516p ps=2.16u w=0.74u l=0.13u
X5636 a_11584_20111# D_uq7 a_11470_20111# VDD sg13_lv_pmos ad=0.2128p pd=1.5u as=0.2464p ps=1.56u w=1.12u l=0.13u
X5637 VSS Q_uq40 Y_uq351 VSS sg13_lv_nmos ad=0.2516p pd=2.16u as=0.2516p ps=2.16u w=0.74u l=0.13u
X5638 a_77604_21489# X_uq201 VDD VDD sg13_lv_pmos ad=0.1596p pd=1.22u as=0.2856p ps=2.36u w=0.84u l=0.13u
X5639 VSS a_39374_9489# X_uq82 VSS sg13_lv_nmos ad=0.1469p pd=1.155u as=0.2516p ps=2.16u w=0.74u l=0.13u
X5640 a_4944_25619# reset VDD VDD sg13_lv_pmos ad=0.2856p pd=2.36u as=0.2114p ps=1.54u w=0.84u l=0.13u
X5641 a_27977_68416# C_uq67 D_uq59 VDD sg13_lv_pmos ad=0.2128p pd=1.5u as=0.3808p ps=2.92u w=1.12u l=0.13u
X5642 Y_uq51 X_uq195 VSS VSS sg13_lv_nmos ad=0.2516p pd=2.16u as=0.2516p ps=2.16u w=0.74u l=0.13u
X5643 a_5774_23604# a_6217_23360# a_6157_23772# VDD sg13_lv_pmos ad=79.8f pd=0.8u as=63f ps=0.72u w=0.42u l=0.13u
X5644 a_9619_33479# Y_uq165 VSS VSS sg13_lv_nmos ad=60.89999f pd=0.71u as=0.1626p ps=1.415u w=0.42u l=0.13u
X5645 VDD C_uq16 a_11436_19647# VDD sg13_lv_pmos ad=0.3808p pd=2.92u as=0.2464p ps=1.56u w=1.12u l=0.13u
X5646 VDD Y_uq207 a_7357_36704# VDD sg13_lv_pmos ad=0.2128p pd=1.5u as=0.2128p ps=1.5u w=1.12u l=0.13u
X5647 VSS a_40184_63546# q[16] VSS sg13_lv_nmos ad=0.14875p pd=1.16u as=0.2886p ps=2.26u w=0.74u l=0.13u
X5648 a_44603_66217# a_43761_65867# a_43344_65860# VDD sg13_lv_pmos ad=0.2048p pd=1.63u as=0.34p ps=2.68u w=1u l=0.13u
X5649 a_10990_24183# B_uq58 VDD VDD sg13_lv_pmos ad=0.2464p pd=1.56u as=0.3808p ps=2.92u w=1.12u l=0.13u
X5650 VSS VDD VSS VSS sg13_lv_nmos ad=0.1428p pd=1.52u as=0 ps=-0 w=0.42u l=1u
X5651 Q_uq40 a_52374_64344# VSS VSS sg13_lv_nmos ad=0.2516p pd=2.16u as=0.1406p ps=1.12u w=0.74u l=0.13u
X5652 Q_uq58 a_32406_65392# VDD VDD sg13_lv_pmos ad=0.3808p pd=2.92u as=0.2128p ps=1.5u w=1.12u l=0.13u
X5653 VSS din[1] a_77215_28253# VSS sg13_lv_nmos ad=0.14875p pd=1.16u as=0.187p ps=1.78u w=0.55u l=0.13u
X5654 VDD a_30364_69850# a_30309_69945# VDD sg13_lv_pmos ad=1.6733p pd=10.405u as=93.45f ps=0.865u w=0.42u l=0.13u
X5655 VDD C_uq20 a_12341_19647# VDD sg13_lv_pmos ad=0.4032p pd=2.96u as=0.1176p ps=1.33u w=1.12u l=0.13u
X5656 a_79644_23717# B_uq43 VDD VDD sg13_lv_pmos ad=0.2464p pd=1.56u as=0.3808p ps=2.92u w=1.12u l=0.13u
X5657 a_29330_67806# D_uq57 VDD VDD sg13_lv_pmos ad=79.8f pd=0.8u as=0.1428p ps=1.52u w=0.42u l=0.13u
X5658 X_uq202 a_75295_21481# VSS VSS sg13_lv_nmos ad=0.2886p pd=2.26u as=0.14875p ps=1.16u w=0.74u l=0.13u
X5659 S_uq0 a_7321_31295# VSS VSS sg13_lv_nmos ad=0.2886p pd=2.26u as=0.14875p ps=1.16u w=0.74u l=0.13u
X5660 a_3571_31699# a_3535_31673# VSS VSS sg13_lv_nmos ad=0.1428p pd=1.52u as=79.8f ps=0.8u w=0.42u l=0.13u
X5661 VDD Q_uq29 a_37588_63620# VDD sg13_lv_pmos ad=0.2114p pd=1.54u as=0.2856p ps=2.36u w=0.84u l=0.13u
X5662 VSS Q_uq52 a_44884_66644# VSS sg13_lv_nmos ad=0.14875p pd=1.16u as=0.187p ps=1.78u w=0.55u l=0.13u
X5663 VDD a_38530_8375# B_uq3 VDD sg13_lv_pmos ad=0.2114p pd=1.54u as=0.42p ps=2.99u w=1.12u l=0.13u
X5664 VDD a_40006_66574# a_39725_66796# VDD sg13_lv_pmos ad=0.1523p pd=1.38u as=0.34p ps=2.68u w=1u l=0.5u
X5665 a_45842_66294# a_46647_65867# a_46102_65824# VDD sg13_lv_pmos ad=0.1428p pd=1.52u as=79.8f ps=0.8u w=0.42u l=0.13u
X5666 a_49580_66781# a_49699_66570# VSS VSS sg13_lv_nmos ad=0.2516p pd=2.16u as=0.1406p ps=1.12u w=0.74u l=0.13u
X5667 a_47522_67793# a_46344_67729# a_47126_67648# VSS sg13_lv_nmos ad=37.8f pd=0.6u as=0.1428p ps=1.52u w=0.42u l=0.13u
X5668 a_76837_20229# Q_uq3 C_uq9 VDD sg13_lv_pmos ad=0.2128p pd=1.5u as=0.3808p ps=2.92u w=1.12u l=0.13u
X5669 VSS Y_uq4 a_34398_6937# VSS sg13_lv_nmos ad=0.14875p pd=1.16u as=0.187p ps=1.78u w=0.55u l=0.13u
X5670 a_47553_64391# a_46611_64431# a_47459_64391# VDD sg13_lv_pmos ad=79.8f pd=0.8u as=0.1428p ps=1.52u w=0.42u l=0.13u
X5671 VDD B_uq67 a_76459_24765# VDD sg13_lv_pmos ad=0.3808p pd=2.92u as=0.2128p ps=1.5u w=1.12u l=0.13u
X5672 VDD Q_uq38 a_36052_63620# VDD sg13_lv_pmos ad=0.2114p pd=1.54u as=0.2856p ps=2.36u w=0.84u l=0.13u
X5673 VSS a_8835_37148# a_8871_37079# VSS sg13_lv_nmos ad=4.17695p pd=26.495u as=0.2516p ps=2.16u w=0.74u l=0.13u
X5674 VDD a_3535_31809# a_3962_32832# VDD sg13_lv_pmos ad=0.1563p pd=1.22u as=63f ps=0.72u w=0.42u l=0.13u
X5675 C_uq46 X_uq458 VSS VSS sg13_lv_nmos ad=0.1406p pd=1.12u as=0.2516p ps=2.16u w=0.74u l=0.13u
X5676 a_7321_41297# Q_uq23 VSS VSS sg13_lv_nmos ad=0.187p pd=1.78u as=0.14875p ps=1.16u w=0.55u l=0.13u
X5677 Q_uq5 a_5806_24143# VDD VDD sg13_lv_pmos ad=0.3808p pd=2.92u as=0.2128p ps=1.5u w=1.12u l=0.13u
X5678 a_34330_67635# a_34445_67634# VDD VDD sg13_lv_pmos ad=0.34p pd=2.68u as=0.2254p ps=1.53u w=1u l=0.5u
X5679 VDD a_6494_22595# a_6213_22897# VDD sg13_lv_pmos ad=0.1523p pd=1.38u as=0.34p ps=2.68u w=1u l=0.5u
X5680 VSS a_49664_64308# Y_uq242 VSS sg13_lv_nmos ad=0.17255p pd=1.25u as=0.1406p ps=1.12u w=0.74u l=0.13u
X5681 X_uq32 a_34014_6937# VSS VSS sg13_lv_nmos ad=0.2886p pd=2.26u as=0.14875p ps=1.16u w=0.74u l=0.13u
X5682 a_4784_23679# a_4562_23423# VDD VDD sg13_lv_pmos ad=0.1176p pd=1.33u as=0.2618p ps=1.63u w=1.12u l=0.13u
X5683 VDD a_7059_24970# a_7726_25191# VDD sg13_lv_pmos ad=0.2128p pd=1.5u as=0.3864p ps=2.93u w=1.12u l=0.13u
X5684 a_3535_38609# A_uq322 VDD VDD sg13_lv_pmos ad=0.2856p pd=2.36u as=0.2114p ps=1.54u w=0.84u l=0.13u
X5685 a_33264_64782# D_uq40 a_33170_64782# VSS sg13_lv_nmos ad=60.89999f pd=0.71u as=0.1428p ps=1.52u w=0.42u l=0.13u
X5686 VSS a_78577_21411# a_78296_21633# VSS sg13_lv_nmos ad=79.8f pd=0.8u as=0.1428p ps=1.52u w=0.42u l=0.5u
X5687 VDD a_38924_69167# Q_uq44 VDD sg13_lv_pmos ad=0.2128p pd=1.5u as=0.3808p ps=2.92u w=1.12u l=0.13u
X5688 a_29136_69643# a_29367_69752# a_28822_69853# VSS sg13_lv_nmos ad=0.2373p pd=1.97u as=79.8f ps=0.8u w=0.42u l=0.13u
X5689 a_51107_66997# a_50411_66876# a_51201_66764# VSS sg13_lv_nmos ad=0.1296p pd=1.52u as=79.8f ps=0.8u w=0.42u l=0.13u
X5690 VSS a_32216_68082# q[2] VSS sg13_lv_nmos ad=0.14875p pd=1.16u as=0.2886p ps=2.26u w=0.74u l=0.13u
X5691 VSS a_5208_21083# Y_uq66 VSS sg13_lv_nmos ad=0.17255p pd=1.25u as=0.1406p ps=1.12u w=0.74u l=0.13u
X5692 a_79043_25943# X_uq250 VSS VSS sg13_lv_nmos ad=0.187p pd=1.78u as=0.14875p ps=1.16u w=0.55u l=0.13u
X5693 VDD a_4297_40543# a_4321_40263# VDD sg13_lv_pmos ad=0.1523p pd=1.38u as=0.34p ps=2.68u w=1u l=0.5u
X5694 VDD VSS VDD VDD sg13_lv_pmos ad=0.19p pd=1.38u as=0 ps=0 w=1u l=1u
X5695 D_uq3 X_uq259 VSS VSS sg13_lv_nmos ad=0.1694p pd=1.21u as=0.2618p ps=2.22u w=0.77u l=0.13u
X5696 VSS X_uq255 a_8561_24647# VSS sg13_lv_nmos ad=0.14875p pd=1.16u as=0.187p ps=1.78u w=0.55u l=0.13u
X5697 VSS a_78455_22492# Q_uq3 VSS sg13_lv_nmos ad=0.1406p pd=1.12u as=0.2516p ps=2.16u w=0.74u l=0.13u
X5698 A_uq80 a_39494_10301# VDD VDD sg13_lv_pmos ad=0.3976p pd=2.95u as=0.2226p ps=1.535u w=1.12u l=0.13u
X5699 a_10689_17845# B_uq33 a_10587_17845# VSS sg13_lv_nmos ad=0.1406p pd=1.12u as=0.1406p ps=1.12u w=0.74u l=0.13u
X5700 VSS a_6559_42743# a_6595_42675# VSS sg13_lv_nmos ad=79.8f pd=0.8u as=0.1428p ps=1.52u w=0.42u l=0.13u
X5701 VDD X_uq448 a_45466_65136# VDD sg13_lv_pmos ad=0.2618p pd=1.63u as=0.2856p ps=2.36u w=0.84u l=0.13u
X5702 a_8405_35930# Y_uq190 VDD VDD sg13_lv_pmos ad=0.2128p pd=1.5u as=0.2128p ps=1.5u w=1.12u l=0.13u
X5703 VDD din[7] a_75583_29041# VDD sg13_lv_pmos ad=0.2114p pd=1.54u as=0.2856p ps=2.36u w=0.84u l=0.13u
X5704 Y_uq76 C_uq8 VSS VSS sg13_lv_nmos ad=0.2618p pd=2.22u as=0.1463p ps=1.15u w=0.77u l=0.13u
X5705 a_40952_63546# Q_uq30 VSS VSS sg13_lv_nmos ad=0.187p pd=1.78u as=0.14875p ps=1.16u w=0.55u l=0.13u
X5706 VSS VDD VSS VSS sg13_lv_nmos ad=0.1428p pd=1.52u as=0 ps=-0 w=0.42u l=1u
X5707 VSS a_43138_9137# B_uq9 VSS sg13_lv_nmos ad=0.14875p pd=1.16u as=0.2886p ps=2.26u w=0.74u l=0.13u
X5708 a_76549_26277# C1_uq4 A2_uq2 VDD sg13_lv_pmos ad=0.2128p pd=1.5u as=0.3808p ps=2.92u w=1.12u l=0.13u
X5709 a_12046_21159# A_N VDD VDD sg13_lv_pmos ad=0.2464p pd=1.56u as=0.3808p ps=2.92u w=1.12u l=0.13u
X5710 VDD C_uq20 a_12149_22671# VDD sg13_lv_pmos ad=0.4032p pd=2.96u as=0.1176p ps=1.33u w=1.12u l=0.13u
X5711 VDD a_43522_7625# B_N VDD sg13_lv_pmos ad=0.2114p pd=1.54u as=0.42p ps=2.99u w=1.12u l=0.13u
X5712 VSS VDD VSS VSS sg13_lv_nmos ad=0.1428p pd=1.52u as=0 ps=-0 w=0.42u l=1u
X5713 a_50866_67793# L_HI_uq23 VSS VSS sg13_lv_nmos ad=37.8f pd=0.6u as=0.1701p ps=1.65u w=0.42u l=0.13u
X5714 VDD a_5833_34271# a_5809_34453# VDD sg13_lv_pmos ad=0.2254p pd=1.53u as=0.34p ps=2.68u w=1u l=0.5u
X5715 a_78059_19145# C_uq23 VSS VSS sg13_lv_nmos ad=0.187p pd=1.78u as=0.17255p ps=1.25u w=0.55u l=0.13u
X5716 a_52568_69594# Y_uq351 VDD VDD sg13_lv_pmos ad=0.2856p pd=2.36u as=0.2114p ps=1.54u w=0.84u l=0.13u
X5717 a_7321_33723# a_7345_33831# VSS VSS sg13_lv_nmos ad=0.1428p pd=1.52u as=0.1426p ps=1.16u w=0.42u l=0.5u
X5718 X_uq281 a_8833_31967# VSS VSS sg13_lv_nmos ad=0.2886p pd=2.26u as=0.14875p ps=1.16u w=0.74u l=0.13u
X5719 VSS X_uq137 a_44774_10301# VSS sg13_lv_nmos ad=0.1469p pd=1.155u as=0.1045p ps=0.93u w=0.55u l=0.13u
X5720 VDD X_uq297 Y_uq165 VDD sg13_lv_pmos ad=0.3808p pd=2.92u as=0.3808p ps=2.92u w=1.12u l=0.13u
X5721 L_HI_uq14 a_39978_65346# VDD VDD sg13_lv_pmos ad=0.3927p pd=2.99u as=1.41367p ps=8.85u w=1.155u l=0.13u
X5722 VDD VSS VDD VDD sg13_lv_pmos ad=0.34p pd=2.68u as=0 ps=0 w=1u l=1u
X5723 VSS a_44554_9137# Y_uq8 VSS sg13_lv_nmos ad=0.17255p pd=1.25u as=0.1406p ps=1.12u w=0.74u l=0.13u
X5724 a_78881_21131# a_78574_20657# a_78787_21131# VSS sg13_lv_nmos ad=37.8f pd=0.6u as=0.1428p ps=1.52u w=0.42u l=0.13u
X5725 VSS D_uq25 a_9247_39835# VSS sg13_lv_nmos ad=0.1406p pd=1.12u as=0.2516p ps=2.16u w=0.74u l=0.15u
X5726 VSS Q_uq5 a_7724_25655# VSS sg13_lv_nmos ad=0.14875p pd=1.16u as=0.187p ps=1.78u w=0.55u l=0.13u
X5727 a_6608_41481# a_6570_42533# a_6604_41175# VSS sg13_lv_nmos ad=0.2373p pd=1.97u as=79.8f ps=0.8u w=0.42u l=0.13u
X5728 VSS A_uq99 a_40734_9173# VSS sg13_lv_nmos ad=0.14875p pd=1.16u as=0.187p ps=1.78u w=0.55u l=0.13u
X5729 D_uq3 C_uq13 a_3739_22167# VDD sg13_lv_pmos ad=0.3808p pd=2.92u as=0.2128p ps=1.5u w=1.12u l=0.13u
X5730 a_76459_24765# B2_uq6 a_76357_24765# VDD sg13_lv_pmos ad=0.2128p pd=1.5u as=0.2128p ps=1.5u w=1.12u l=0.13u
X5731 a_51123_65312# a_51275_65364# VSS VSS sg13_lv_nmos ad=0.2516p pd=2.16u as=4.5737p ps=28.36u w=0.74u l=0.13u
X5732 VDD X_uq208 a_78115_22205# VDD sg13_lv_pmos ad=0.4032p pd=2.96u as=0.1176p ps=1.33u w=1.12u l=0.13u
X5733 VSS Q_uq19 Y_uq190 VSS sg13_lv_nmos ad=0.2516p pd=2.16u as=0.2516p ps=2.16u w=0.74u l=0.13u
X5734 a_7470_20655# B_uq66 VDD VDD sg13_lv_pmos ad=0.1176p pd=1.33u as=0.4032p ps=2.96u w=1.12u l=0.13u
X5735 VSS Q_uq15 a_5809_34855# VSS sg13_lv_nmos ad=79.8f pd=0.8u as=0.1428p ps=1.52u w=0.42u l=0.13u
X5736 VDD VSS VDD VDD sg13_lv_pmos ad=0.34p pd=2.68u as=0 ps=0 w=1u l=1u
X5737 X_uq328 a_3535_43295# VDD VDD sg13_lv_pmos ad=0.42p pd=2.99u as=0.2114p ps=1.54u w=1.12u l=0.13u
X5738 a_50168_63546# Y_uq291 VSS VSS sg13_lv_nmos ad=0.187p pd=1.78u as=0.14875p ps=1.16u w=0.55u l=0.13u
X5739 a_48048_69643# a_47760_69948# a_47986_69643# VSS sg13_lv_nmos ad=0.1428p pd=1.52u as=37.8f ps=0.6u w=0.42u l=0.13u
X5740 a_51992_68844# Y_uq335 VSS VSS sg13_lv_nmos ad=0.187p pd=1.78u as=0.14875p ps=1.16u w=0.55u l=0.13u
X5741 Y_uq129 D_uq7 VSS VSS sg13_lv_nmos ad=0.1406p pd=1.12u as=0.23757p ps=2.16u w=0.74u l=0.13u
X5742 a_8873_41001# a_8837_40975# VDD VDD sg13_lv_pmos ad=0.34p pd=2.68u as=0.36237p ps=2.605u w=1u l=0.13u
X5743 a_49329_67368# X_uq445 VDD VDD sg13_lv_pmos ad=0.2464p pd=1.56u as=0.3808p ps=2.92u w=1.12u l=0.13u
X5744 VDD a_4297_34356# a_4297_34458# VDD sg13_lv_pmos ad=0.2128p pd=1.5u as=0.3864p ps=2.93u w=1.12u l=0.13u
X5745 a_78282_23717# X_uq215 VDD VDD sg13_lv_pmos ad=0.1428p pd=1.375u as=0.2891p ps=1.695u w=1.12u l=0.13u
X5746 a_6893_40095# a_6563_40069# VDD VDD sg13_lv_pmos ad=0.2975p pd=1.595u as=0.2198p ps=1.52u w=1u l=0.13u
X5747 VDD din[26] a_75679_18457# VDD sg13_lv_pmos ad=0.2114p pd=1.54u as=0.2856p ps=2.36u w=0.84u l=0.13u
X5748 X_uq28 a_35550_6937# VSS VSS sg13_lv_nmos ad=0.2886p pd=2.26u as=0.14875p ps=1.16u w=0.74u l=0.13u
X5749 VDD a_79153_28971# a_78872_29193# VDD sg13_lv_pmos ad=0.1523p pd=1.38u as=0.34p ps=2.68u w=1u l=0.5u
X5750 VDD Q_uq12 a_5809_33991# VDD sg13_lv_pmos ad=0.1523p pd=1.38u as=0.1428p ps=1.52u w=0.42u l=0.13u
X5751 VSS a_38470_68844# a_38189_69146# VSS sg13_lv_nmos ad=79.8f pd=0.8u as=0.1428p ps=1.52u w=0.42u l=0.5u
X5752 VSS VDD VSS VSS sg13_lv_nmos ad=0.1428p pd=1.52u as=0 ps=-0 w=0.42u l=1u
X5753 VDD a_80076_22252# a_79155_22566# VDD sg13_lv_pmos ad=0.36237p pd=2.605u as=0.34p ps=2.68u w=1u l=0.13u
X5754 B_uq30 a_32766_10685# VSS VSS sg13_lv_nmos ad=0.2886p pd=2.26u as=0.14875p ps=1.16u w=0.74u l=0.13u
X5755 VSS a_49019_69707# a_49686_69928# VSS sg13_lv_nmos ad=0.1406p pd=1.12u as=0.2516p ps=2.16u w=0.74u l=0.13u
X5756 a_10385_41193# a_10349_41167# VSS VSS sg13_lv_nmos ad=0.2516p pd=2.16u as=0.1626p ps=1.415u w=0.74u l=0.13u
X5757 X_uq255 a_7724_25655# VSS VSS sg13_lv_nmos ad=0.2886p pd=2.26u as=0.14875p ps=1.16u w=0.74u l=0.13u
X5758 a_37126_68086# Y_uq324 VDD VDD sg13_lv_pmos ad=0.1428p pd=1.52u as=0.1523p ps=1.38u w=0.42u l=0.13u
X5759 VDD a_5047_33019# a_5047_32855# VDD sg13_lv_pmos ad=1.86053p pd=12.055u as=79.8f ps=0.8u w=0.42u l=0.13u
X5760 a_7346_22898# a_7461_22897# VSS VSS sg13_lv_nmos ad=0.1428p pd=1.52u as=0.1426p ps=1.16u w=0.42u l=0.5u
X5761 VDD Y_uq103 a_80575_25229# VDD sg13_lv_pmos ad=0.2114p pd=1.54u as=0.2856p ps=2.36u w=0.84u l=0.13u
X5762 a_3886_31699# a_3535_31673# VDD VDD sg13_lv_pmos ad=93.45f pd=0.865u as=1.31615p ps=8.395u w=0.42u l=0.13u
X5763 Y_uq4 a_36516_8453# VSS VSS sg13_lv_nmos ad=0.1406p pd=1.12u as=0.17255p ps=1.25u w=0.74u l=0.13u
X5764 a_41602_8375# X_uq164 VDD VDD sg13_lv_pmos ad=0.2856p pd=2.36u as=0.2114p ps=1.54u w=0.84u l=0.13u
X5765 a_40785_65867# clk VDD VDD sg13_lv_pmos ad=0.4088p pd=2.97u as=1.37835p ps=8.63u w=1.12u l=0.13u
X5766 VSS a_51035_68195# a_51702_68416# VSS sg13_lv_nmos ad=0.1406p pd=1.12u as=0.2516p ps=2.16u w=0.74u l=0.13u
X5767 a_49490_68118# D_uq53 VDD VDD sg13_lv_pmos ad=79.8f pd=0.8u as=0.1428p ps=1.52u w=0.42u l=0.13u
X5768 VDD a_44602_68307# D_uq58 VDD sg13_lv_pmos ad=0.2254p pd=1.53u as=0.4256p ps=3u w=1.12u l=0.13u
X5769 a_7357_36139# C1_uq8 a_7321_35905# VDD sg13_lv_pmos ad=0.2125p pd=1.425u as=0.35p ps=2.7u w=1u l=0.13u
X5770 VSS a_34714_65283# D_uq45 VSS sg13_lv_nmos ad=0.1426p pd=1.16u as=0.2516p ps=2.16u w=0.74u l=0.13u
X5771 C_uq0 a_76063_18457# VSS VSS sg13_lv_nmos ad=0.2886p pd=2.26u as=0.14875p ps=1.16u w=0.74u l=0.13u
X5772 a_7735_37687# X_uq305 VSS VSS sg13_lv_nmos ad=0.2516p pd=2.16u as=0.1406p ps=1.12u w=0.74u l=0.15u
X5773 VSS a_5115_23462# a_5115_23462# VSS sg13_lv_nmos ad=1.6335p pd=10.61u as=0.111p ps=1.34u w=0.3u l=0.13u
X5774 VSS a_3539_38143# a_3575_38075# VSS sg13_lv_nmos ad=79.8f pd=0.8u as=0.1428p ps=1.52u w=0.42u l=0.5u
X5775 VSS a_43761_65867# a_43863_65867# VSS sg13_lv_nmos ad=1.8643p pd=11.96u as=0.2516p ps=2.16u w=0.74u l=0.13u
X5776 a_39888_67793# a_40119_67379# a_39574_67336# VSS sg13_lv_nmos ad=0.2373p pd=1.97u as=79.8f ps=0.8u w=0.42u l=0.13u
X5777 VDD L_HI_uq30 a_33334_68341# VDD sg13_lv_pmos ad=0.1563p pd=1.22u as=0.147p ps=1.54u w=0.42u l=0.13u
X5778 Y_uq133 X_uq259 VSS VSS sg13_lv_nmos ad=0.1694p pd=1.21u as=0.2618p ps=2.22u w=0.77u l=0.13u
X5779 VSS X_uq74 a_43908_9229# VSS sg13_lv_nmos ad=0.17255p pd=1.25u as=0.187p ps=1.78u w=0.55u l=0.13u
X5780 a_50938_66123# a_51053_66122# VSS VSS sg13_lv_nmos ad=0.1428p pd=1.52u as=0.1426p ps=1.16u w=0.42u l=0.5u
X5781 a_9615_34039# Y_uq176 VSS VSS sg13_lv_nmos ad=0.2516p pd=2.16u as=0.1406p ps=1.12u w=0.74u l=0.15u
X5782 Q_uq5 a_5806_24143# VSS VSS sg13_lv_nmos ad=0.2516p pd=2.16u as=0.1406p ps=1.12u w=0.74u l=0.13u
X5783 VSS a_31619_63663# a_31619_63663# VSS sg13_lv_nmos ad=3.5825p pd=23.78u as=0.111p ps=1.34u w=0.3u l=0.13u
X5784 a_43570_66281# L_HI_uq19 VSS VSS sg13_lv_nmos ad=37.8f pd=0.6u as=0.1701p ps=1.65u w=0.42u l=0.13u
X5785 a_28022_67368# X_uq411 Y_uq329 VDD sg13_lv_pmos ad=0.1176p pd=1.33u as=0.3808p ps=2.92u w=1.12u l=0.13u
X5786 a_9583_31324# a_9594_31979# a_9934_31795# VDD sg13_lv_pmos ad=0.2048p pd=1.63u as=93.45f ps=0.865u w=0.42u l=0.13u
X5787 Y_uq260 X_uq373 a_45688_65392# VDD sg13_lv_pmos ad=0.3808p pd=2.92u as=0.1176p ps=1.33u w=1.12u l=0.13u
X5788 VDD L_HI_uq4 a_78625_24690# VDD sg13_lv_pmos ad=0.1563p pd=1.22u as=0.147p ps=1.54u w=0.42u l=0.13u
X5789 VDD a_5234_22898# B_uq50 VDD sg13_lv_pmos ad=0.2254p pd=1.53u as=0.4256p ps=3u w=1.12u l=0.13u
X5790 a_5047_36407# a_5047_36571# a_5083_36535# VSS sg13_lv_nmos ad=0.1428p pd=1.52u as=37.8f ps=0.6u w=0.42u l=0.13u
X5791 a_6237_38195# S_uq0 B_uq84 VSS sg13_lv_nmos ad=96.2f pd=1u as=0.2664p ps=1.46u w=0.74u l=0.13u
X5792 a_35676_9149# A_uq98 VDD VDD sg13_lv_pmos ad=0.1596p pd=1.22u as=0.2226p ps=1.535u w=0.84u l=0.13u
X5793 a_37314_10221# a_37092_9965# VDD VDD sg13_lv_pmos ad=0.1176p pd=1.33u as=0.2618p ps=1.63u w=1.12u l=0.13u
X5794 a_33974_68880# X_uq433 VDD VDD sg13_lv_pmos ad=0.1176p pd=1.33u as=0.4032p ps=2.96u w=1.12u l=0.13u
X5795 a_10806_35275# Y_uq186 VSS VSS sg13_lv_nmos ad=37.8f pd=0.6u as=0.1701p ps=1.65u w=0.42u l=0.13u
X5796 a_7056_25619# X_uq282 VDD VDD sg13_lv_pmos ad=0.2856p pd=2.36u as=0.2114p ps=1.54u w=0.84u l=0.13u
X5797 Y_uq186 X_uq297 VDD VDD sg13_lv_pmos ad=0.3808p pd=2.92u as=0.3808p ps=2.92u w=1.12u l=0.13u
X5798 a_32106_69882# a_31907_69945# VSS VSS sg13_lv_nmos ad=0.27427p pd=2.28u as=2.01085p ps=12.81u w=0.795u l=0.13u
X5799 VDD VSS VDD VDD sg13_lv_pmos ad=0.19p pd=1.38u as=0 ps=0 w=1u l=1u
X5800 VSS Y_uq163 a_8107_31113# VSS sg13_lv_nmos ad=0.1626p pd=1.415u as=60.89999f ps=0.71u w=0.42u l=0.13u
X5801 VSS VDD VSS VSS sg13_lv_nmos ad=0.1428p pd=1.52u as=0 ps=-0 w=0.42u l=1u
X5802 VSS a_44134_68086# a_43853_68308# VSS sg13_lv_nmos ad=79.8f pd=0.8u as=0.1428p ps=1.52u w=0.42u l=0.5u
X5803 VDD a_40952_63546# q[17] VDD sg13_lv_pmos ad=0.2114p pd=1.54u as=0.42p ps=2.99u w=1.12u l=0.13u
X5804 VSS a_77699_18383# B_uq32 VSS sg13_lv_nmos ad=0.14875p pd=1.16u as=0.2886p ps=2.26u w=0.74u l=0.13u
X5805 X_uq167 a_32382_10685# VDD VDD sg13_lv_pmos ad=0.42p pd=2.99u as=0.2114p ps=1.54u w=1.12u l=0.13u
X5806 VDD X_uq112 a_37572_9965# VDD sg13_lv_pmos ad=0.2618p pd=1.63u as=0.2856p ps=2.36u w=0.84u l=0.13u
X5807 VSS a_48177_69609# a_48279_69752# VSS sg13_lv_nmos ad=2.01085p pd=12.81u as=0.2516p ps=2.16u w=0.74u l=0.13u
X5808 a_10428_32924# D_uq21 a_10819_33671# VSS sg13_lv_nmos ad=0.1428p pd=1.52u as=60.89999f ps=0.71u w=0.42u l=0.13u
X5809 A_uq88 a_38622_7661# VSS VSS sg13_lv_nmos ad=0.2886p pd=2.26u as=0.14875p ps=1.16u w=0.74u l=0.13u
X5810 VSS C1 Y_uq45 VSS sg13_lv_nmos ad=0.1406p pd=1.12u as=0.2516p ps=2.16u w=0.74u l=0.13u
X5811 VSS VDD VSS VSS sg13_lv_nmos ad=79.8f pd=0.8u as=0 ps=-0 w=0.42u l=1u
X5812 a_43334_10301# B_uq16 VSS VSS sg13_lv_nmos ad=0.1045p pd=0.93u as=0.187p ps=1.78u w=0.55u l=0.13u
X5813 X_uq57 a_32478_7661# VSS VSS sg13_lv_nmos ad=0.2886p pd=2.26u as=0.14875p ps=1.16u w=0.74u l=0.13u
X5814 VSS clk a_50411_66876# VSS sg13_lv_nmos ad=1.7977p pd=11.53u as=0.2516p ps=2.16u w=0.74u l=0.13u
X5815 X_uq33 a_33630_6937# VDD VDD sg13_lv_pmos ad=0.42p pd=2.99u as=0.2114p ps=1.54u w=1.12u l=0.13u
X5816 VDD a_44482_6863# X_uq5 VDD sg13_lv_pmos ad=0.2114p pd=1.54u as=0.42p ps=2.99u w=1.12u l=0.13u
X5817 a_79228_27495# B_uq70 VSS VSS sg13_lv_nmos ad=0.1406p pd=1.12u as=0.14505p ps=1.15u w=0.74u l=0.13u
X5818 VDD B_uq88 a_4333_38618# VDD sg13_lv_pmos ad=0.2128p pd=1.5u as=0.3808p ps=2.92u w=1.12u l=0.13u
X5819 a_41218_8375# Y_uq16 VSS VSS sg13_lv_nmos ad=0.187p pd=1.78u as=0.14875p ps=1.16u w=0.55u l=0.13u
X5820 VDD a_43377_67379# a_43479_67379# VDD sg13_lv_pmos ad=1.19383p pd=7.16u as=0.3864p ps=2.93u w=1.12u l=0.13u
X5821 a_36657_68917# a_36657_68917# VSS VSS sg13_lv_nmos ad=0.111p pd=1.34u as=2.01085p ps=12.81u w=0.3u l=0.13u
X5822 a_7357_40025# a_7320_39999# X_uq314 VDD sg13_lv_pmos ad=0.2128p pd=1.5u as=0.3808p ps=2.92u w=1.12u l=0.13u
X5823 a_33784_65856# X_uq387 C_uq50 VDD sg13_lv_pmos ad=0.1176p pd=1.33u as=0.3808p ps=2.92u w=1.12u l=0.13u
X5824 VSS a_30982_63550# a_30701_63772# VSS sg13_lv_nmos ad=79.8f pd=0.8u as=0.1428p ps=1.52u w=0.42u l=0.5u
X5825 a_33744_64769# a_33456_64348# a_33682_64769# VSS sg13_lv_nmos ad=0.1428p pd=1.52u as=37.8f ps=0.6u w=0.42u l=0.13u
X5826 a_46552_68416# a_46330_68160# VDD VDD sg13_lv_pmos ad=0.1176p pd=1.33u as=0.2618p ps=1.63u w=1.12u l=0.13u
X5827 a_78401_29301# X_uq279 VDD VDD sg13_lv_pmos ad=0.1176p pd=1.33u as=0.4032p ps=2.96u w=1.12u l=0.13u
X5828 a_10349_33537# Y_uq164 VDD VDD sg13_lv_pmos ad=0.147p pd=1.54u as=0.1563p ps=1.22u w=0.42u l=0.13u
X5829 VSS Y_uq242 Y_uq257 VSS sg13_lv_nmos ad=0.1463p pd=1.15u as=0.1694p ps=1.21u w=0.77u l=0.13u
X5830 a_32312_66570# Y_uq339 VSS VSS sg13_lv_nmos ad=0.187p pd=1.78u as=0.14875p ps=1.16u w=0.55u l=0.13u
X5831 a_42058_9891# X_uq141 VDD VDD sg13_lv_pmos ad=0.2856p pd=2.36u as=0.2618p ps=1.63u w=0.84u l=0.13u
X5832 VSS X_uq80 a_40158_6937# VSS sg13_lv_nmos ad=0.14875p pd=1.16u as=0.187p ps=1.78u w=0.55u l=0.13u
X5833 VDD a_79910_24544# a_80577_24765# VDD sg13_lv_pmos ad=0.2128p pd=1.5u as=0.3864p ps=2.93u w=1.12u l=0.13u
X5834 a_39603_68967# a_39755_68851# VDD VDD sg13_lv_pmos ad=0.3864p pd=2.93u as=1.42837p ps=8.61u w=1.12u l=0.13u
X5835 a_80076_22252# a_79134_22292# a_79982_22252# VDD sg13_lv_pmos ad=79.8f pd=0.8u as=0.1428p ps=1.52u w=0.42u l=0.13u
X5836 Y_uq44 X_uq190 VDD VDD sg13_lv_pmos ad=0.3808p pd=2.92u as=0.3808p ps=2.92u w=1.12u l=0.13u
X5837 VSS B_uq67 a_76709_22597# VSS sg13_lv_nmos ad=0.2516p pd=2.16u as=96.2f ps=1u w=0.74u l=0.13u
X5838 a_76939_19957# Y_uq47 VSS VSS sg13_lv_nmos ad=0.1406p pd=1.12u as=0.1406p ps=1.12u w=0.74u l=0.13u
X5839 a_37106_66294# a_37911_65867# a_37366_65824# VDD sg13_lv_pmos ad=0.1428p pd=1.52u as=79.8f ps=0.8u w=0.42u l=0.13u
X5840 VDD VSS VDD VDD sg13_lv_pmos ad=0.34p pd=2.68u as=0 ps=0 w=1u l=1u
X5841 a_50162_64782# a_50967_64355# a_50422_64312# VDD sg13_lv_pmos ad=0.1428p pd=1.52u as=79.8f ps=0.8u w=0.42u l=0.13u
X5842 VSS VDD VSS VSS sg13_lv_nmos ad=79.8f pd=0.8u as=0 ps=-0 w=0.42u l=1u
X5843 a_75996_19181# X_uq251 VDD VDD sg13_lv_pmos ad=0.2464p pd=1.56u as=0.3808p ps=2.92u w=1.12u l=0.13u
X5844 VDD C_uq20 a_11093_18135# VDD sg13_lv_pmos ad=0.4032p pd=2.96u as=0.1176p ps=1.33u w=1.12u l=0.13u
X5845 a_47674_65283# a_47789_65284# VSS VSS sg13_lv_nmos ad=0.1428p pd=1.52u as=0.1426p ps=1.16u w=0.42u l=0.5u
X5846 B_uq4 a_36510_9173# VDD VDD sg13_lv_pmos ad=0.42p pd=2.99u as=0.2114p ps=1.54u w=1.12u l=0.13u
X5847 VSS Q_uq35 Y_uq254 VSS sg13_lv_nmos ad=0.2516p pd=2.16u as=0.2516p ps=2.16u w=0.74u l=0.13u
X5848 a_44998_68086# Y_uq319 VSS VSS sg13_lv_nmos ad=0.1428p pd=1.52u as=79.8f ps=0.8u w=0.42u l=0.13u
X5849 VSS C_uq23 Y_uq37 VSS sg13_lv_nmos ad=0.1463p pd=1.15u as=0.1694p ps=1.21u w=0.77u l=0.13u
X5850 a_4297_40543# Q_uq22 VSS VSS sg13_lv_nmos ad=0.1428p pd=1.52u as=79.8f ps=0.8u w=0.42u l=0.13u
X5851 VDD a_43558_63550# a_43277_63772# VDD sg13_lv_pmos ad=0.1523p pd=1.38u as=0.34p ps=2.68u w=1u l=0.5u
X5852 D_uq53 C_uq62 a_48867_68416# VDD sg13_lv_pmos ad=0.3808p pd=2.92u as=0.2128p ps=1.5u w=1.12u l=0.13u
X5853 VSS a_7321_32187# D_uq12 VSS sg13_lv_nmos ad=0.1426p pd=1.16u as=0.2516p ps=2.16u w=0.74u l=0.13u
X5854 a_41627_66217# a_40785_65867# a_41533_66217# VSS sg13_lv_nmos ad=0.12665p pd=1.145u as=0.1428p ps=1.52u w=0.42u l=0.13u
X5855 VDD Q_uq46 Y_uq345 VDD sg13_lv_pmos ad=0.3808p pd=2.92u as=0.3808p ps=2.92u w=1.12u l=0.13u
X5856 VSS a_40546_10649# X_uq147 VSS sg13_lv_nmos ad=0.14875p pd=1.16u as=0.2886p ps=2.26u w=0.74u l=0.13u
X5857 a_42904_68416# X_uq413 C_uq64 VDD sg13_lv_pmos ad=0.1176p pd=1.33u as=0.3808p ps=2.92u w=1.12u l=0.13u
X5858 VDD a_38470_68844# a_38189_69146# VDD sg13_lv_pmos ad=0.1523p pd=1.38u as=0.34p ps=2.68u w=1u l=0.5u
X5859 VDD Y_uq137 a_76741_25229# VDD sg13_lv_pmos ad=0.3808p pd=2.92u as=0.2128p ps=1.5u w=1.12u l=0.13u
X5860 VDD Q_uq3 C1_uq5 VDD sg13_lv_pmos ad=0.3808p pd=2.92u as=0.3808p ps=2.92u w=1.12u l=0.13u
X5861 a_77248_23741# Y_uq86 VSS VSS sg13_lv_nmos ad=0.198p pd=1.27u as=0.1045p ps=0.93u w=0.55u l=0.13u
X5862 VSS X_uq343 a_38526_10685# VSS sg13_lv_nmos ad=0.14875p pd=1.16u as=0.187p ps=1.78u w=0.55u l=0.13u
X5863 a_42776_65820# X_uq450 VDD VDD sg13_lv_pmos ad=0.2856p pd=2.36u as=0.2114p ps=1.54u w=0.84u l=0.13u
X5864 VSS X_uq323 Y_uq236 VSS sg13_lv_nmos ad=0.2516p pd=2.16u as=0.2516p ps=2.16u w=0.74u l=0.13u
X5865 a_5234_22898# a_5349_22897# VDD VDD sg13_lv_pmos ad=0.34p pd=2.68u as=0.2254p ps=1.53u w=1u l=0.5u
X5866 VSS X_uq373 Y_uq260 VSS sg13_lv_nmos ad=0.2516p pd=2.16u as=0.1406p ps=1.12u w=0.74u l=0.13u
X5867 a_4297_39674# X_uq315 VSS VSS sg13_lv_nmos ad=0.187p pd=1.78u as=0.14505p ps=1.15u w=0.55u l=0.13u
X5868 X_uq148 a_40062_10685# VDD VDD sg13_lv_pmos ad=0.42p pd=2.99u as=0.2114p ps=1.54u w=1.12u l=0.13u
X5869 a_33170_65098# a_32900_65098# VDD VDD sg13_lv_pmos ad=0.34p pd=2.68u as=0.1523p ps=1.38u w=1u l=0.5u
X5870 VDD Y_uq109 a_12017_24647# VDD sg13_lv_pmos ad=0.2114p pd=1.54u as=0.2856p ps=2.36u w=0.84u l=0.13u
X5871 a_32792_68082# X_uq432 VDD VDD sg13_lv_pmos ad=0.2856p pd=2.36u as=0.2114p ps=1.54u w=0.84u l=0.13u
X5872 VDD a_39106_7625# X_uq53 VDD sg13_lv_pmos ad=0.2114p pd=1.54u as=0.42p ps=2.99u w=1.12u l=0.13u
X5873 a_10381_39578# Y_uq219 VDD VDD sg13_lv_pmos ad=0.2128p pd=1.5u as=0.2128p ps=1.5u w=1.12u l=0.13u
X5874 B1_uq7 X_uq251 VSS VSS sg13_lv_nmos ad=0.1406p pd=1.12u as=0.2516p ps=2.16u w=0.74u l=0.13u
X5875 VSS din[20] a_75679_22205# VSS sg13_lv_nmos ad=0.14875p pd=1.16u as=0.187p ps=1.78u w=0.55u l=0.13u
X5876 VDD X_uq447 a_41423_66904# VDD sg13_lv_pmos ad=0.3808p pd=2.92u as=0.2464p ps=1.56u w=1.12u l=0.13u
X5877 a_40017_67379# clk VSS VSS sg13_lv_nmos ad=0.2516p pd=2.16u as=2.0066p ps=12.72u w=0.74u l=0.13u
X5878 VSS a_35189_67706# a_35110_67609# VSS sg13_lv_nmos ad=2.08687p pd=13.23u as=0.27427p ps=2.28u w=0.795u l=0.13u
X5879 a_76709_22597# Y_uq72 B1 VSS sg13_lv_nmos ad=96.2f pd=1u as=0.2664p ps=1.46u w=0.74u l=0.13u
X5880 a_76747_22981# Y_uq82 VSS VSS sg13_lv_nmos ad=0.1406p pd=1.12u as=0.1406p ps=1.12u w=0.74u l=0.13u
X5881 VDD a_46690_9887# X_uq94 VDD sg13_lv_pmos ad=0.2114p pd=1.54u as=0.42p ps=2.99u w=1.12u l=0.13u
X5882 VSS a_30897_65073# a_30999_65216# VSS sg13_lv_nmos ad=4.5737p pd=28.36u as=0.2516p ps=2.16u w=0.74u l=0.13u
X5883 a_46402_7625# X_uq72 VDD VDD sg13_lv_pmos ad=0.2856p pd=2.36u as=0.2114p ps=1.54u w=0.84u l=0.13u
X5884 X_uq152 a_38526_10685# VSS VSS sg13_lv_nmos ad=0.2886p pd=2.26u as=0.14875p ps=1.16u w=0.74u l=0.13u
X5885 VSS a_44866_7625# X_uq42 VSS sg13_lv_nmos ad=0.14875p pd=1.16u as=0.2886p ps=2.26u w=0.74u l=0.13u
X5886 a_50563_65058# a_51123_65312# a_51034_65409# VDD sg13_lv_pmos ad=0.2048p pd=1.63u as=93.45f ps=0.865u w=0.42u l=0.13u
X5887 a_40258_7625# A_uq80 VDD VDD sg13_lv_pmos ad=0.2856p pd=2.36u as=0.2114p ps=1.54u w=0.84u l=0.13u
X5888 a_12533_22671# C_uq8 Y_uq90 VDD sg13_lv_pmos ad=0.1176p pd=1.33u as=0.3808p ps=2.92u w=1.12u l=0.13u
X5889 VDD a_35246_10067# A_uq91 VDD sg13_lv_pmos ad=0.2226p pd=1.535u as=0.3976p ps=2.95u w=1.12u l=0.13u
X5890 VDD a_5051_42745# X_uq324 VDD sg13_lv_pmos ad=0.2254p pd=1.53u as=0.4256p ps=3u w=1.12u l=0.13u
X5891 C_uq68 X_uq446 VSS VSS sg13_lv_nmos ad=0.1406p pd=1.12u as=0.2516p ps=2.16u w=0.74u l=0.13u
X5892 VDD a_30033_68891# a_30135_68891# VDD sg13_lv_pmos ad=1.42837p pd=8.61u as=0.3864p ps=2.93u w=1.12u l=0.13u
X5893 a_36059_66217# a_35217_65867# a_34800_65860# VDD sg13_lv_pmos ad=0.2048p pd=1.63u as=0.34p ps=2.68u w=1u l=0.13u
X5894 a_46545_65867# clk VDD VDD sg13_lv_pmos ad=0.4088p pd=2.97u as=1.37835p ps=8.63u w=1.12u l=0.13u
X5895 VDD X_uq89 a_34980_9229# VDD sg13_lv_pmos ad=0.2618p pd=1.63u as=0.2856p ps=2.36u w=0.84u l=0.13u
X5896 a_78939_27166# a_79170_26752# a_78625_26709# VSS sg13_lv_nmos ad=0.2373p pd=1.97u as=79.8f ps=0.8u w=0.42u l=0.13u
X5897 X_uq205 a_9905_21623# VDD VDD sg13_lv_pmos ad=0.42p pd=2.99u as=0.2114p ps=1.54u w=1.12u l=0.13u
X5898 a_47960_63546# Q_uq53 VDD VDD sg13_lv_pmos ad=0.2856p pd=2.36u as=0.2114p ps=1.54u w=0.84u l=0.13u
X5899 C_uq53 X_uq448 VSS VSS sg13_lv_nmos ad=0.1406p pd=1.12u as=0.2516p ps=2.16u w=0.74u l=0.13u
X5900 VDD Q_uq25 a_7357_40025# VDD sg13_lv_pmos ad=0.2128p pd=1.5u as=0.2128p ps=1.5u w=1.12u l=0.13u
X5901 VDD a_51704_69594# q[28] VDD sg13_lv_pmos ad=0.2114p pd=1.54u as=0.42p ps=2.99u w=1.12u l=0.13u
X5902 A_uq81 a_39014_10301# VSS VSS sg13_lv_nmos ad=0.2516p pd=2.16u as=0.1469p ps=1.155u w=0.74u l=0.13u
X5903 a_5079_37303# B_uq86 Y_uq195 VSS sg13_lv_nmos ad=0.1406p pd=1.12u as=0.2516p ps=2.16u w=0.74u l=0.15u
X5904 VDD X_uq458 a_32314_65912# VDD sg13_lv_pmos ad=0.2618p pd=1.63u as=0.2856p ps=2.36u w=0.84u l=0.13u
X5905 VDD clk a_46475_67339# VDD sg13_lv_pmos ad=1.17087p pd=7.02u as=0.4088p ps=2.97u w=1.12u l=0.13u
X5906 a_51899_67729# a_51057_67379# a_50640_67372# VDD sg13_lv_pmos ad=0.2048p pd=1.63u as=0.34p ps=2.68u w=1u l=0.13u
X5907 VSS X_uq61 a_42948_8453# VSS sg13_lv_nmos ad=0.17255p pd=1.25u as=0.187p ps=1.78u w=0.55u l=0.13u
X5908 a_77323_19181# Y_uq42 a_77221_19181# VDD sg13_lv_pmos ad=0.2128p pd=1.5u as=0.2128p ps=1.5u w=1.12u l=0.13u
X5909 a_36952_68880# X_uq433 C_uq70 VDD sg13_lv_pmos ad=0.1176p pd=1.33u as=0.3808p ps=2.92u w=1.12u l=0.13u
X5910 a_11526_24647# D_uq7 Y_uq113 VDD sg13_lv_pmos ad=0.2128p pd=1.5u as=0.3808p ps=2.92u w=1.12u l=0.13u
X5911 a_31077_67491# a_30135_67379# a_30875_67729# VDD sg13_lv_pmos ad=93.45f pd=0.865u as=0.2048p ps=1.63u w=0.42u l=0.13u
X5912 C_uq68 X_uq425 a_47798_68416# VDD sg13_lv_pmos ad=0.3808p pd=2.92u as=0.1176p ps=1.33u w=1.12u l=0.13u
X5913 VDD a_42178_7625# X_uq45 VDD sg13_lv_pmos ad=0.2114p pd=1.54u as=0.42p ps=2.99u w=1.12u l=0.13u
X5914 VDD X_uq449 a_44248_65392# VDD sg13_lv_pmos ad=0.4032p pd=2.96u as=0.1176p ps=1.33u w=1.12u l=0.13u
X5915 a_5774_21087# a_6217_21130# a_5514_21557# VSS sg13_lv_nmos ad=79.8f pd=0.8u as=0.1296p ps=1.52u w=0.42u l=0.13u
X5916 VDD L_HI_uq1 a_4238_22092# VDD sg13_lv_pmos ad=0.1563p pd=1.22u as=0.147p ps=1.54u w=0.42u l=0.13u
X5917 X_uq212 a_12593_23135# VDD VDD sg13_lv_pmos ad=0.42p pd=2.99u as=0.2114p ps=1.54u w=1.12u l=0.13u
X5918 a_3535_36717# a_3546_36677# a_3535_37051# VSS sg13_lv_nmos ad=0.3473p pd=2.71u as=0.12665p ps=1.145u w=0.74u l=0.13u
X5919 B_uq22 a_39678_10685# VDD VDD sg13_lv_pmos ad=0.42p pd=2.99u as=0.2114p ps=1.54u w=1.12u l=0.13u
X5920 VDD a_41026_6863# X_uq14 VDD sg13_lv_pmos ad=0.2114p pd=1.54u as=0.42p ps=2.99u w=1.12u l=0.13u
X5921 a_78787_22643# a_78574_22169# VDD VDD sg13_lv_pmos ad=79.8f pd=0.8u as=1.59725p ps=10.05u w=0.42u l=0.13u
X5922 a_35217_63625# a_35217_63625# VSS VSS sg13_lv_nmos ad=0.111p pd=1.34u as=3.5825p ps=23.78u w=0.3u l=0.13u
X5923 a_78574_28217# a_79134_28340# a_79045_28376# VDD sg13_lv_pmos ad=0.2048p pd=1.63u as=93.45f ps=0.865u w=0.42u l=0.13u
X5924 a_30837_65485# a_30480_65412# VDD VDD sg13_lv_pmos ad=63f pd=0.72u as=0.1563p ps=1.22u w=0.42u l=0.13u
X5925 Y_uq12 A_uq88 VSS VSS sg13_lv_nmos ad=0.1406p pd=1.12u as=0.2516p ps=2.16u w=0.74u l=0.13u
X5926 VDD clk a_50411_66876# VDD sg13_lv_pmos ad=1.17087p pd=7.02u as=0.4088p ps=2.97u w=1.12u l=0.13u
X5927 a_52582_68086# Q_uq49 VSS VSS sg13_lv_nmos ad=0.1428p pd=1.52u as=79.8f ps=0.8u w=0.42u l=0.13u
X5928 B_uq24 a_38142_10685# VDD VDD sg13_lv_pmos ad=0.42p pd=2.99u as=0.2114p ps=1.54u w=1.12u l=0.13u
X5929 a_30875_69241# a_30033_68891# a_29616_68884# VDD sg13_lv_pmos ad=0.2048p pd=1.63u as=0.34p ps=2.68u w=1u l=0.13u
X5930 a_79982_20740# L_HI_uq0 VDD VDD sg13_lv_pmos ad=79.8f pd=0.8u as=0.36237p ps=2.605u w=0.42u l=0.13u
X5931 a_44482_6863# A_uq71 VDD VDD sg13_lv_pmos ad=0.2856p pd=2.36u as=0.2114p ps=1.54u w=0.84u l=0.13u
X5932 VDD a_8075_38143# a_8111_38075# VDD sg13_lv_pmos ad=0.1523p pd=1.38u as=0.34p ps=2.68u w=1u l=0.5u
X5933 VSS B_uq33 a_10343_18965# VSS sg13_lv_nmos ad=0.18575p pd=1.26u as=0.187p ps=1.78u w=0.55u l=0.13u
X5934 VDD a_4297_34356# a_4420_33911# VDD sg13_lv_pmos ad=1.31615p pd=8.395u as=79.8f ps=0.8u w=0.42u l=0.13u
X5935 a_34972_64586# L_HI_uq12 VDD VDD sg13_lv_pmos ad=79.8f pd=0.8u as=1.4745p ps=9.07u w=0.42u l=0.13u
X5936 VDD a_7346_22898# B_uq49 VDD sg13_lv_pmos ad=0.2254p pd=1.53u as=0.4256p ps=3u w=1.12u l=0.13u
X5937 a_37980_8789# X_uq162 VDD VDD sg13_lv_pmos ad=0.1596p pd=1.22u as=0.2226p ps=1.535u w=0.84u l=0.13u
X5938 VSS a_79040_25567# a_78961_25470# VSS sg13_lv_nmos ad=5.79397p pd=37.885u as=0.27427p ps=2.28u w=0.795u l=0.13u
X5939 VDD Q_uq33 Y_uq292 VDD sg13_lv_pmos ad=0.3808p pd=2.92u as=0.3808p ps=2.92u w=1.12u l=0.13u
X5940 Y_uq113 B_uq55 VSS VSS sg13_lv_nmos ad=0.1694p pd=1.21u as=0.1463p ps=1.15u w=0.77u l=0.13u
X5941 Q_uq39 a_30870_65856# VDD VDD sg13_lv_pmos ad=0.3808p pd=2.92u as=0.2128p ps=1.5u w=1.12u l=0.13u
X5942 VDD Q_uq21 Y_uq233 VDD sg13_lv_pmos ad=0.3808p pd=2.92u as=0.3808p ps=2.92u w=1.12u l=0.13u
X5943 VSS B_uq9 a_42926_10067# VSS sg13_lv_nmos ad=0.187p pd=1.78u as=0.1045p ps=0.93u w=0.55u l=0.13u
X5944 L_HI_uq2 a_3778_22569# VDD VDD sg13_lv_pmos ad=0.3927p pd=2.99u as=1.37097p ps=8.54u w=1.155u l=0.13u
X5945 Y_uq149 X_uq277 VSS VSS sg13_lv_nmos ad=0.2516p pd=2.16u as=0.2516p ps=2.16u w=0.74u l=0.13u
X5946 VDD A_uq89 a_34782_6937# VDD sg13_lv_pmos ad=0.2114p pd=1.54u as=0.2856p ps=2.36u w=0.84u l=0.13u
X5947 B_uq4 a_36510_9173# VSS VSS sg13_lv_nmos ad=0.2886p pd=2.26u as=0.14875p ps=1.16u w=0.74u l=0.13u
X5948 VSS a_10345_37044# a_10345_37146# VSS sg13_lv_nmos ad=0.1406p pd=1.12u as=0.2516p ps=2.16u w=0.74u l=0.13u
X5949 VSS Q_uq44 a_36532_65132# VSS sg13_lv_nmos ad=0.14875p pd=1.16u as=0.187p ps=1.78u w=0.55u l=0.13u
X5950 VSS S_uq0 a_6215_40129# VSS sg13_lv_nmos ad=0.18945p pd=1.27u as=0.13135p ps=1.095u w=0.74u l=0.13u
X5951 a_35842_7625# q[6] VSS VSS sg13_lv_nmos ad=0.187p pd=1.78u as=0.14875p ps=1.16u w=0.55u l=0.13u
X5952 a_41520_69948# a_42039_69752# a_42779_69707# VSS sg13_lv_nmos ad=0.3473p pd=2.71u as=0.12665p ps=1.145u w=0.74u l=0.13u
X5953 VSS Y_uq237 a_6283_41001# VSS sg13_lv_nmos ad=0.1626p pd=1.415u as=60.89999f ps=0.71u w=0.42u l=0.13u
X5954 a_5780_22089# a_5523_21946# a_5942_21869# VSS sg13_lv_nmos ad=0.1428p pd=1.52u as=37.8f ps=0.6u w=0.42u l=0.13u
X5955 VSS a_51334_65820# a_51053_66122# VSS sg13_lv_nmos ad=79.8f pd=0.8u as=0.1428p ps=1.52u w=0.42u l=0.5u
X5956 VSS X_uq436 Y_uq328 VSS sg13_lv_nmos ad=0.2618p pd=2.22u as=0.1694p ps=1.21u w=0.77u l=0.13u
X5957 a_5047_32685# a_5092_31287# VDD VDD sg13_lv_pmos ad=0.34p pd=2.68u as=0.36237p ps=2.605u w=1u l=0.13u
X5958 Q_uq1 a_7726_23679# VSS VSS sg13_lv_nmos ad=0.2516p pd=2.16u as=0.1406p ps=1.12u w=0.74u l=0.13u
X5959 VDD a_10345_43188# a_10345_43290# VDD sg13_lv_pmos ad=0.2128p pd=1.5u as=0.3864p ps=2.93u w=1.12u l=0.13u
X5960 VDD X_uq137 a_45348_10301# VDD sg13_lv_pmos ad=0.2226p pd=1.535u as=0.1596p ps=1.22u w=0.84u l=0.13u
X5961 a_46402_8375# A_uq15 VDD VDD sg13_lv_pmos ad=0.2856p pd=2.36u as=0.2114p ps=1.54u w=0.84u l=0.13u
X5962 VSS Y_uq310 a_33748_63620# VSS sg13_lv_nmos ad=0.14875p pd=1.16u as=0.187p ps=1.78u w=0.55u l=0.13u
X5963 VSS a_5047_36571# a_5047_36954# VSS sg13_lv_nmos ad=0.1406p pd=1.12u as=0.2516p ps=2.16u w=0.74u l=0.13u
X5964 VSS A_uq98 Y_uq14 VSS sg13_lv_nmos ad=0.2516p pd=2.16u as=0.1406p ps=1.12u w=0.74u l=0.13u
X5965 a_5051_41791# X_uq321 VDD VDD sg13_lv_pmos ad=0.1428p pd=1.52u as=0.1523p ps=1.38u w=0.42u l=0.13u
X5966 a_78941_22959# a_78671_22959# VSS VSS sg13_lv_nmos ad=0.1428p pd=1.52u as=79.8f ps=0.8u w=0.42u l=0.5u
X5967 VDD a_80593_23681# a_80312_23983# VDD sg13_lv_pmos ad=0.1523p pd=1.38u as=0.34p ps=2.68u w=1u l=0.5u
X5968 a_42680_63546# Q_uq33 VDD VDD sg13_lv_pmos ad=0.2856p pd=2.36u as=0.2114p ps=1.54u w=0.84u l=0.13u
X5969 a_40258_8375# X_uq145 VDD VDD sg13_lv_pmos ad=0.2856p pd=2.36u as=0.2114p ps=1.54u w=0.84u l=0.13u
X5970 VDD Y_uq167 a_5083_31019# VDD sg13_lv_pmos ad=0.36237p pd=2.605u as=79.8f ps=0.8u w=0.42u l=0.13u
X5971 VDD a_35864_64308# q[9] VDD sg13_lv_pmos ad=0.2114p pd=1.54u as=0.42p ps=2.99u w=1.12u l=0.13u
X5972 a_46522_64782# a_46763_64315# a_46051_64308# VSS sg13_lv_nmos ad=0.1428p pd=1.52u as=0.12665p ps=1.145u w=0.42u l=0.13u
X5973 VDD L_HI_uq32 a_29590_68848# VDD sg13_lv_pmos ad=0.1563p pd=1.22u as=0.147p ps=1.54u w=0.42u l=0.13u
X5974 a_8869_32303# S_uq0 VDD VDD sg13_lv_pmos ad=0.1176p pd=1.33u as=0.4032p ps=2.96u w=1.12u l=0.13u
X5975 Y_uq304 Q_uq36 VSS VSS sg13_lv_nmos ad=0.2516p pd=2.16u as=0.2516p ps=2.16u w=0.74u l=0.13u
X5976 C_uq15 a_9671_18965# VDD VDD sg13_lv_pmos ad=0.3808p pd=2.92u as=0.2128p ps=1.5u w=1.12u l=0.13u
X5977 a_7321_33423# X_uq284 a_7705_33028# VSS sg13_lv_nmos ad=0.1216p pd=1.02u as=81.6f ps=0.895u w=0.64u l=0.13u
X5978 Y_uq205 A0 a_6893_37596# VDD sg13_lv_pmos ad=0.3808p pd=2.92u as=0.2128p ps=1.5u w=1.12u l=0.13u
X5979 a_33552_66619# a_33783_66728# a_33238_66829# VSS sg13_lv_nmos ad=0.2373p pd=1.97u as=79.8f ps=0.8u w=0.42u l=0.13u
X5980 a_33490_66619# L_HI_uq24 VSS VSS sg13_lv_nmos ad=37.8f pd=0.6u as=0.1701p ps=1.65u w=0.42u l=0.13u
X5981 VSS a_42658_10649# X_uq141 VSS sg13_lv_nmos ad=0.14875p pd=1.16u as=0.2886p ps=2.26u w=0.74u l=0.13u
X5982 a_45176_63546# Y_uq290 VSS VSS sg13_lv_nmos ad=0.187p pd=1.78u as=0.14875p ps=1.16u w=0.55u l=0.13u
X5983 a_38662_66574# Q_uq38 VSS VSS sg13_lv_nmos ad=0.1428p pd=1.52u as=79.8f ps=0.8u w=0.42u l=0.13u
X5984 VDD X_uq84 a_37470_6937# VDD sg13_lv_pmos ad=0.2114p pd=1.54u as=0.2856p ps=2.36u w=0.84u l=0.13u
X5985 a_37794_10221# a_37572_9965# VDD VDD sg13_lv_pmos ad=0.1176p pd=1.33u as=0.2618p ps=1.63u w=1.12u l=0.13u
X5986 a_7346_22898# a_7461_22897# VDD VDD sg13_lv_pmos ad=0.34p pd=2.68u as=0.2254p ps=1.53u w=1u l=0.5u
X5987 VDD L_HI_uq9 a_46264_64782# VDD sg13_lv_pmos ad=1.4745p pd=9.07u as=79.8f ps=0.8u w=0.42u l=0.13u
X5988 C_uq60 X_uq458 VSS VSS sg13_lv_nmos ad=0.1406p pd=1.12u as=0.2516p ps=2.16u w=0.74u l=0.13u
X5989 VSS a_44792_69594# X_uq449 VSS sg13_lv_nmos ad=0.14875p pd=1.16u as=0.2886p ps=2.26u w=0.74u l=0.13u
X5990 a_10385_35049# a_10349_35023# VDD VDD sg13_lv_pmos ad=0.34p pd=2.68u as=0.36237p ps=2.605u w=1u l=0.13u
X5991 VDD L_HI_uq18 a_49912_66606# VDD sg13_lv_pmos ad=1.19383p pd=7.16u as=79.8f ps=0.8u w=0.42u l=0.13u
X5992 VSS Q_uq46 Y_uq345 VSS sg13_lv_nmos ad=0.2516p pd=2.16u as=0.2516p ps=2.16u w=0.74u l=0.13u
X5993 a_78939_27166# a_78651_26745# a_78877_27166# VSS sg13_lv_nmos ad=0.1428p pd=1.52u as=37.8f ps=0.6u w=0.42u l=0.13u
X5994 a_5051_39674# Y_uq235 VDD VDD sg13_lv_pmos ad=0.2856p pd=2.36u as=0.2198p ps=1.53u w=0.84u l=0.13u
X5995 VDD a_51992_68844# A_uq37 VDD sg13_lv_pmos ad=0.2114p pd=1.54u as=0.42p ps=2.99u w=1.12u l=0.13u
X5996 X_uq194 a_9809_20111# VDD VDD sg13_lv_pmos ad=0.42p pd=2.99u as=0.2114p ps=1.54u w=1.12u l=0.13u
X5997 VDD Y_uq237 a_5892_41738# VDD sg13_lv_pmos ad=0.36237p pd=2.605u as=79.8f ps=0.8u w=0.42u l=0.13u
X5998 a_47480_66570# Q_uq50 VDD VDD sg13_lv_pmos ad=0.2856p pd=2.36u as=0.2114p ps=1.54u w=0.84u l=0.13u
X5999 a_40647_68927# a_39755_68851# a_40545_68927# VDD sg13_lv_pmos ad=63f pd=0.72u as=79.8f ps=0.8u w=0.42u l=0.13u
X6000 a_5809_40625# A_uq334 VDD VDD sg13_lv_pmos ad=0.2856p pd=2.36u as=0.2114p ps=1.54u w=0.84u l=0.13u
X6001 X_uq182 a_12593_19387# VSS VSS sg13_lv_nmos ad=0.2886p pd=2.26u as=0.14875p ps=1.16u w=0.74u l=0.13u
X6002 a_8835_37148# clk VDD VDD sg13_lv_pmos ad=0.4088p pd=2.97u as=1.4396p ps=9.25u w=1.12u l=0.13u
X6003 a_48728_63546# Y_uq358 VSS VSS sg13_lv_nmos ad=0.187p pd=1.78u as=0.14875p ps=1.16u w=0.55u l=0.13u
X6004 VSS B_uq65 a_3788_24931# VSS sg13_lv_nmos ad=0.14875p pd=1.16u as=0.187p ps=1.78u w=0.55u l=0.13u
X6005 VSS a_45173_69576# a_45094_69851# VSS sg13_lv_nmos ad=2.01085p pd=12.81u as=0.27427p ps=2.28u w=0.795u l=0.13u
X6006 VDD a_35074_7625# B_uq12 VDD sg13_lv_pmos ad=0.2114p pd=1.54u as=0.42p ps=2.99u w=1.12u l=0.13u
X6007 a_46018_8375# q[31] VSS VSS sg13_lv_nmos ad=0.187p pd=1.78u as=0.14875p ps=1.16u w=0.55u l=0.13u
X6008 VSS a_44866_8375# X_uq74 VSS sg13_lv_nmos ad=0.14875p pd=1.16u as=0.2886p ps=2.26u w=0.74u l=0.13u
X6009 VSS B1_uq7 a_77720_27517# VSS sg13_lv_nmos ad=0.2516p pd=2.16u as=0.1406p ps=1.12u w=0.74u l=0.13u
X6010 VSS X_uq156 a_38820_8453# VSS sg13_lv_nmos ad=0.17255p pd=1.25u as=0.187p ps=1.78u w=0.55u l=0.13u
X6011 C_uq39 Y_uq201 VDD VDD sg13_lv_pmos ad=0.2128p pd=1.5u as=0.3808p ps=2.92u w=1.12u l=0.15u
X6012 C_uq6 B_uq67 VSS VSS sg13_lv_nmos ad=0.1406p pd=1.12u as=0.2516p ps=2.16u w=0.74u l=0.13u
X6013 C_uq55 X_uq429 VSS VSS sg13_lv_nmos ad=0.1406p pd=1.12u as=0.2516p ps=2.16u w=0.74u l=0.13u
X6014 a_42250_9137# X_uq138 VSS VSS sg13_lv_nmos ad=0.187p pd=1.78u as=0.17255p ps=1.25u w=0.55u l=0.13u
X6015 a_76957_26005# Y_uq127 A2_uq2 VSS sg13_lv_nmos ad=0.1406p pd=1.12u as=0.2516p ps=2.16u w=0.74u l=0.13u
X6016 VDD a_5809_35739# B_uq78 VDD sg13_lv_pmos ad=0.2254p pd=1.53u as=0.4256p ps=3u w=1.12u l=0.13u
X6017 VDD Q_uq43 a_51716_65897# VDD sg13_lv_pmos ad=0.1523p pd=1.38u as=0.1428p ps=1.52u w=0.42u l=0.13u
X6018 X_uq212 a_12593_23135# VSS VSS sg13_lv_nmos ad=0.2886p pd=2.26u as=0.14875p ps=1.16u w=0.74u l=0.13u
X6019 VSS X_uq144 a_41414_10301# VSS sg13_lv_nmos ad=0.1469p pd=1.155u as=0.1045p ps=0.93u w=0.55u l=0.13u
X6020 VSS X_uq435 D_uq56 VSS sg13_lv_nmos ad=0.2618p pd=2.22u as=0.1694p ps=1.21u w=0.77u l=0.13u
X6021 VDD L_HI_uq35 a_44210_69318# VDD sg13_lv_pmos ad=0.36237p pd=2.605u as=79.8f ps=0.8u w=0.42u l=0.13u
X6022 VDD SLN[5] a_34686_8449# VDD sg13_lv_pmos ad=0.2114p pd=1.54u as=0.2856p ps=2.36u w=0.84u l=0.13u
X6023 Y_uq49 C_uq4 a_11584_20111# VDD sg13_lv_pmos ad=0.3808p pd=2.92u as=0.2128p ps=1.5u w=1.12u l=0.13u
X6024 a_77323_19181# Y_uq51 VDD VDD sg13_lv_pmos ad=0.2128p pd=1.5u as=0.3808p ps=2.92u w=1.12u l=0.13u
X6025 a_78455_22492# a_78574_22169# VDD VDD sg13_lv_pmos ad=0.3864p pd=2.93u as=0.2128p ps=1.5u w=1.12u l=0.13u
X6026 a_41414_9149# B_uq19 VSS VSS sg13_lv_nmos ad=0.1045p pd=0.93u as=0.187p ps=1.78u w=0.55u l=0.13u
X6027 a_76154_28253# Q_uq7 a_76052_28253# VDD sg13_lv_pmos ad=0.2464p pd=1.56u as=0.2128p ps=1.5u w=1.12u l=0.13u
X6028 VSS a_6574_41610# a_6570_42533# VSS sg13_lv_nmos ad=5.69525p pd=37.455u as=0.2516p ps=2.16u w=0.74u l=0.13u
X6029 D_uq16 S_uq0 VSS VSS sg13_lv_nmos ad=0.1694p pd=1.21u as=0.1463p ps=1.15u w=0.77u l=0.13u
X6030 a_41026_6863# X_uq64 VDD VDD sg13_lv_pmos ad=0.2856p pd=2.36u as=0.2114p ps=1.54u w=0.84u l=0.13u
X6031 L_HI_uq5 a_5410_25593# VDD VDD sg13_lv_pmos ad=0.3927p pd=2.99u as=1.17282p ps=7.015u w=1.155u l=0.13u
X6032 VDD a_42274_10649# B_uq20 VDD sg13_lv_pmos ad=0.2114p pd=1.54u as=0.42p ps=2.99u w=1.12u l=0.13u
X6033 VSS Q_uq7 C1_uq7 VSS sg13_lv_nmos ad=0.1463p pd=1.15u as=0.1694p ps=1.21u w=0.77u l=0.13u
X6034 C_uq55 X_uq400 a_37910_66904# VDD sg13_lv_pmos ad=0.3808p pd=2.92u as=0.1176p ps=1.33u w=1.12u l=0.13u
X6035 VSS A_N Y_uq68 VSS sg13_lv_nmos ad=0.1406p pd=1.12u as=0.1406p ps=1.12u w=0.74u l=0.13u
X6036 a_5047_33019# a_5062_31722# a_5083_32787# VSS sg13_lv_nmos ad=0.12665p pd=1.145u as=0.1428p ps=1.52u w=0.42u l=0.13u
X6037 a_10661_41738# a_10385_41193# a_10806_41419# VSS sg13_lv_nmos ad=0.1428p pd=1.52u as=37.8f ps=0.6u w=0.42u l=0.13u
X6038 VSS B_uq66 a_4562_23423# VSS sg13_lv_nmos ad=0.17255p pd=1.25u as=0.187p ps=1.78u w=0.55u l=0.13u
X6039 VSS a_8799_33220# X_uq284 VSS sg13_lv_nmos ad=0.1469p pd=1.155u as=0.2516p ps=2.16u w=0.74u l=0.13u
X6040 a_8107_31113# D_uq13 a_8107_31019# VSS sg13_lv_nmos ad=60.89999f pd=0.71u as=0.1428p ps=1.52u w=0.42u l=0.13u
X6041 C_uq14 a_75295_24505# VDD VDD sg13_lv_pmos ad=0.42p pd=2.99u as=0.2114p ps=1.54u w=1.12u l=0.13u
X6042 X_uq382 a_52098_65880# VDD VDD sg13_lv_pmos ad=0.4256p pd=3u as=0.2254p ps=1.53u w=1.12u l=0.13u
X6043 VDD a_7316_23601# a_7261_23696# VDD sg13_lv_pmos ad=1.02937p pd=6.325u as=93.45f ps=0.865u w=0.42u l=0.13u
X6044 VSS B_uq38 a_79138_21489# VSS sg13_lv_nmos ad=0.1331p pd=1.12u as=0.1216p ps=1.02u w=0.64u l=0.13u
X6045 a_30369_64391# a_29427_64431# a_30230_64624# VSS sg13_lv_nmos ad=79.8f pd=0.8u as=0.2373p ps=1.97u w=0.42u l=0.13u
X6046 X_uq233 a_12017_24647# VSS VSS sg13_lv_nmos ad=0.2886p pd=2.26u as=0.14875p ps=1.16u w=0.74u l=0.13u
X6047 B_uq27 a_35454_10685# VSS VSS sg13_lv_nmos ad=0.2886p pd=2.26u as=0.14875p ps=1.16u w=0.74u l=0.13u
X6048 X_uq97 a_44774_10301# VSS VSS sg13_lv_nmos ad=0.2516p pd=2.16u as=0.1469p ps=1.155u w=0.74u l=0.13u
X6049 VDD C_uq24 a_9942_24671# VDD sg13_lv_pmos ad=0.3822p pd=1.84u as=0.1575p ps=1.315u w=1u l=0.13u
X6050 VDD Y_uq68 a_12209_20111# VDD sg13_lv_pmos ad=0.2114p pd=1.54u as=0.2856p ps=2.36u w=0.84u l=0.13u
X6051 a_76357_21741# Y_uq64 A2 VDD sg13_lv_pmos ad=0.2128p pd=1.5u as=0.3808p ps=2.92u w=1.12u l=0.13u
X6052 VSS X_uq168 a_33542_10661# VSS sg13_lv_nmos ad=0.1469p pd=1.155u as=0.1045p ps=0.93u w=0.55u l=0.13u
X6053 a_36730_68307# a_36845_68308# VDD VDD sg13_lv_pmos ad=0.34p pd=2.68u as=0.2254p ps=1.53u w=1u l=0.5u
X6054 VSS Y_uq64 A2 VSS sg13_lv_nmos ad=0.1406p pd=1.12u as=0.2516p ps=2.16u w=0.74u l=0.13u
X6055 VDD a_45826_10649# B_uq17 VDD sg13_lv_pmos ad=0.2114p pd=1.54u as=0.42p ps=2.99u w=1.12u l=0.13u
X6056 Y_uq209 X_uq315 a_4333_38618# VDD sg13_lv_pmos ad=0.3808p pd=2.92u as=0.2128p ps=1.5u w=1.12u l=0.13u
X6057 a_5092_31287# a_5062_31722# a_5474_31662# VDD sg13_lv_pmos ad=79.8f pd=0.8u as=63f ps=0.72u w=0.42u l=0.13u
X6058 a_38908_66098# L_HI_uq20 VDD VDD sg13_lv_pmos ad=79.8f pd=0.8u as=1.41367p ps=8.85u w=0.42u l=0.13u
X6059 Y_uq180 B_uq81 VSS VSS sg13_lv_nmos ad=0.1694p pd=1.21u as=0.1463p ps=1.15u w=0.77u l=0.13u
X6060 VSS a_51986_65856# a_52098_65880# VSS sg13_lv_nmos ad=0.1426p pd=1.16u as=0.1428p ps=1.52u w=0.42u l=0.5u
X6061 a_45489_68416# X_uq447 VDD VDD sg13_lv_pmos ad=0.2464p pd=1.56u as=0.3808p ps=2.92u w=1.12u l=0.13u
X6062 A_uq82 a_38534_10301# VSS VSS sg13_lv_nmos ad=0.2516p pd=2.16u as=0.1469p ps=1.155u w=0.74u l=0.13u
X6063 VSS a_33634_8375# B_uq14 VSS sg13_lv_nmos ad=0.14875p pd=1.16u as=0.2886p ps=2.26u w=0.74u l=0.13u
X6064 a_3535_36717# a_3580_35319# VDD VDD sg13_lv_pmos ad=0.34p pd=2.68u as=0.36237p ps=2.605u w=1u l=0.13u
X6065 Y_uq261 C_uq48 VSS VSS sg13_lv_nmos ad=0.2618p pd=2.22u as=0.1463p ps=1.15u w=0.77u l=0.13u
X6066 Y_uq311 a_33370_67424# VSS VSS sg13_lv_nmos ad=0.1406p pd=1.12u as=0.17255p ps=1.25u w=0.74u l=0.13u
X6067 VSS C1_uq4 A2_uq2 VSS sg13_lv_nmos ad=0.1406p pd=1.12u as=0.2516p ps=2.16u w=0.74u l=0.13u
X6068 a_30460_66098# a_30203_66217# a_30622_66294# VSS sg13_lv_nmos ad=0.1428p pd=1.52u as=37.8f ps=0.6u w=0.42u l=0.13u
X6069 VDD VSS VDD VDD sg13_lv_pmos ad=0.34p pd=2.68u as=0 ps=0 w=1u l=1u
X6070 a_4944_25619# reset VSS VSS sg13_lv_nmos ad=0.187p pd=1.78u as=0.14875p ps=1.16u w=0.55u l=0.13u
X6071 VDD q[2] a_32958_9173# VDD sg13_lv_pmos ad=0.2114p pd=1.54u as=0.2856p ps=2.36u w=0.84u l=0.13u
X6072 VSS a_35864_64308# q[9] VSS sg13_lv_nmos ad=0.14875p pd=1.16u as=0.2886p ps=2.26u w=0.74u l=0.13u
X6073 VDD Y_uq194 a_3571_35051# VDD sg13_lv_pmos ad=0.36237p pd=2.605u as=79.8f ps=0.8u w=0.42u l=0.13u
X6074 VDD din[0] a_76063_26741# VDD sg13_lv_pmos ad=0.2114p pd=1.54u as=0.2856p ps=2.36u w=0.84u l=0.13u
X6075 VDD a_35726_10067# A_uq90 VDD sg13_lv_pmos ad=0.2226p pd=1.535u as=0.3976p ps=2.95u w=1.12u l=0.13u
X6076 VSS C_uq24 a_10239_20869# VSS sg13_lv_nmos ad=0.18575p pd=1.26u as=0.1406p ps=1.12u w=0.74u l=0.13u
X6077 VDD a_6936_21837# a_6894_22167# VDD sg13_lv_pmos ad=0.2618p pd=1.63u as=0.1176p ps=1.33u w=1.12u l=0.13u
X6078 X_uq193 a_10193_20111# VSS VSS sg13_lv_nmos ad=0.2886p pd=2.26u as=0.14875p ps=1.16u w=0.74u l=0.13u
X6079 VDD VSS VDD VDD sg13_lv_pmos ad=0.34p pd=2.68u as=0 ps=0 w=1u l=1u
X6080 a_28694_66904# X_uq455 VDD VDD sg13_lv_pmos ad=0.1176p pd=1.33u as=0.4032p ps=2.96u w=1.12u l=0.13u
X6081 B_uq26 a_36606_10685# VDD VDD sg13_lv_pmos ad=0.42p pd=2.99u as=0.2114p ps=1.54u w=1.12u l=0.13u
X6082 Y_uq63 X_uq202 VDD VDD sg13_lv_pmos ad=0.3808p pd=2.92u as=0.3808p ps=2.92u w=1.12u l=0.13u
X6083 D_uq10 C_uq29 a_78702_26277# VDD sg13_lv_pmos ad=0.3808p pd=2.92u as=0.2128p ps=1.5u w=1.12u l=0.13u
X6084 a_46234_67491# a_45976_67806# VDD VDD sg13_lv_pmos ad=93.45f pd=0.865u as=1.19383p ps=7.16u w=0.42u l=0.13u
X6085 B_uq31 a_33150_8449# VSS VSS sg13_lv_nmos ad=0.2886p pd=2.26u as=0.14875p ps=1.16u w=0.74u l=0.13u
X6086 X_uq26 a_36318_6937# VSS VSS sg13_lv_nmos ad=0.2886p pd=2.26u as=0.14875p ps=1.16u w=0.74u l=0.13u
X6087 a_41330_65098# a_41060_65098# VDD VDD sg13_lv_pmos ad=0.34p pd=2.68u as=0.1523p ps=1.38u w=1u l=0.5u
X6088 VSS L_HI_uq33 a_50256_64782# VSS sg13_lv_nmos ad=0.1626p pd=1.415u as=60.89999f ps=0.71u w=0.42u l=0.13u
X6089 VSS X_uq420 a_28186_65912# VSS sg13_lv_nmos ad=0.17255p pd=1.25u as=0.187p ps=1.78u w=0.55u l=0.13u
X6090 VDD B_uq81 B_uq75 VDD sg13_lv_pmos ad=0.3808p pd=2.92u as=0.2128p ps=1.5u w=1.12u l=0.13u
X6091 a_34715_64705# a_33873_64355# a_33456_64348# VDD sg13_lv_pmos ad=0.2048p pd=1.63u as=0.34p ps=2.68u w=1u l=0.13u
X6092 VSS a_5809_36127# a_5833_35847# VSS sg13_lv_nmos ad=79.8f pd=0.8u as=0.1428p ps=1.52u w=0.42u l=0.5u
X6093 VSS X_uq436 Y_uq240 VSS sg13_lv_nmos ad=0.2618p pd=2.22u as=0.1694p ps=1.21u w=0.77u l=0.13u
X6094 VSS a_38924_69167# Q_uq44 VSS sg13_lv_nmos ad=0.1406p pd=1.12u as=0.2516p ps=2.16u w=0.74u l=0.13u
X6095 VSS B_uq27 a_37934_9489# VSS sg13_lv_nmos ad=0.187p pd=1.78u as=0.1045p ps=0.93u w=0.55u l=0.13u
X6096 VDD a_30875_67729# a_31542_67368# VDD sg13_lv_pmos ad=0.2128p pd=1.5u as=0.3864p ps=2.93u w=1.12u l=0.13u
X6097 a_3535_31126# a_3535_31228# VDD VDD sg13_lv_pmos ad=0.3864p pd=2.93u as=0.2128p ps=1.5u w=1.12u l=0.13u
X6098 VDD a_45418_10649# a_45376_10685# VDD sg13_lv_pmos ad=0.2618p pd=1.63u as=0.1176p ps=1.33u w=1.12u l=0.13u
X6099 VDD B_uq68 a_76171_27789# VDD sg13_lv_pmos ad=0.3808p pd=2.92u as=0.2128p ps=1.5u w=1.12u l=0.13u
X6100 VDD a_40859_67729# a_41116_67610# VDD sg13_lv_pmos ad=1.19383p pd=7.16u as=79.8f ps=0.8u w=0.42u l=0.13u
X6101 VDD VSS VDD VDD sg13_lv_pmos ad=0.34p pd=2.68u as=0 ps=0 w=1u l=1u
X6102 a_29330_67806# a_30135_67379# a_29590_67336# VDD sg13_lv_pmos ad=0.1428p pd=1.52u as=79.8f ps=0.8u w=0.42u l=0.13u
X6103 VDD L_HI_uq2 a_5514_21557# VDD sg13_lv_pmos ad=0.36237p pd=2.605u as=79.8f ps=0.8u w=0.42u l=0.13u
X6104 VDD a_36440_64308# q[11] VDD sg13_lv_pmos ad=0.2114p pd=1.54u as=0.42p ps=2.99u w=1.12u l=0.13u
X6105 a_37200_66294# D_uq44 a_37106_66294# VSS sg13_lv_nmos ad=60.89999f pd=0.71u as=0.1428p ps=1.52u w=0.42u l=0.13u
X6106 VSS a_35534_9489# X_uq91 VSS sg13_lv_nmos ad=0.1469p pd=1.155u as=0.2516p ps=2.16u w=0.74u l=0.13u
X6107 a_29904_67793# a_29616_67372# a_29842_67793# VSS sg13_lv_nmos ad=0.1428p pd=1.52u as=37.8f ps=0.6u w=0.42u l=0.13u
X6108 D_uq20 C_uq32 a_5845_33564# VDD sg13_lv_pmos ad=0.3808p pd=2.92u as=0.2128p ps=1.5u w=1.12u l=0.13u
X6109 a_3978_21869# D_uq3 VDD VDD sg13_lv_pmos ad=79.8f pd=0.8u as=0.1428p ps=1.52u w=0.42u l=0.13u
X6110 a_46402_6863# Y_uq28 VSS VSS sg13_lv_nmos ad=0.187p pd=1.78u as=0.14875p ps=1.16u w=0.55u l=0.13u
X6111 Q_uq57 a_30774_69928# VSS VSS sg13_lv_nmos ad=0.2516p pd=2.16u as=0.1406p ps=1.12u w=0.74u l=0.13u
X6112 a_33734_10301# B_uq13 VSS VSS sg13_lv_nmos ad=0.1045p pd=0.93u as=0.187p ps=1.78u w=0.55u l=0.13u
X6113 a_4297_40543# Q_uq22 VDD VDD sg13_lv_pmos ad=0.1428p pd=1.52u as=0.1523p ps=1.38u w=0.42u l=0.13u
X6114 VSS a_43522_7625# B_N VSS sg13_lv_nmos ad=0.14875p pd=1.16u as=0.2886p ps=2.26u w=0.74u l=0.13u
X6115 a_41808_69643# a_41520_69948# a_41746_69643# VSS sg13_lv_nmos ad=0.1428p pd=1.52u as=37.8f ps=0.6u w=0.42u l=0.13u
X6116 a_5087_42292# a_5051_42266# Y_uq235 VSS sg13_lv_nmos ad=0.1406p pd=1.12u as=0.333p ps=2.38u w=0.74u l=0.13u
X6117 VSS VDD VSS VSS sg13_lv_nmos ad=79.8f pd=0.8u as=0 ps=-0 w=0.42u l=1u
X6118 Y_uq89 C_uq19 VSS VSS sg13_lv_nmos ad=0.1694p pd=1.21u as=0.2618p ps=2.22u w=0.77u l=0.13u
X6119 VSS C_uq24 a_10852_23191# VSS sg13_lv_nmos ad=0.14505p pd=1.15u as=0.187p ps=1.78u w=0.55u l=0.13u
X6120 a_42446_10067# X_uq144 VSS VSS sg13_lv_nmos ad=0.1045p pd=0.93u as=0.1469p ps=1.155u w=0.55u l=0.13u
X6121 a_42417_64355# clk VDD VDD sg13_lv_pmos ad=0.4088p pd=2.97u as=1.4357p ps=8.83u w=1.12u l=0.13u
X6122 VDD L_HI_uq31 a_49490_68118# VDD sg13_lv_pmos ad=0.36237p pd=2.605u as=79.8f ps=0.8u w=0.42u l=0.13u
X6123 a_8425_36573# Y_uq190 VDD VDD sg13_lv_pmos ad=0.2128p pd=1.5u as=0.3808p ps=2.92u w=1.12u l=0.15u
X6124 VSS C_uq54 Y_uq294 VSS sg13_lv_nmos ad=0.1463p pd=1.15u as=0.2618p ps=2.22u w=0.77u l=0.13u
X6125 VDD X_uq426 a_48148_68880# VDD sg13_lv_pmos ad=0.2114p pd=1.54u as=0.2856p ps=2.36u w=0.84u l=0.13u
X6126 VDD a_5051_33721# X_uq294 VDD sg13_lv_pmos ad=0.2254p pd=1.53u as=0.4256p ps=3u w=1.12u l=0.13u
X6127 a_5800_23699# a_5774_23604# VDD VDD sg13_lv_pmos ad=0.34p pd=2.68u as=0.36237p ps=2.605u w=1u l=0.13u
X6128 VSS a_29338_68307# X_uq438 VSS sg13_lv_nmos ad=0.1426p pd=1.16u as=0.2516p ps=2.16u w=0.74u l=0.13u
X6129 a_43558_63550# Q_uq33 VDD VDD sg13_lv_pmos ad=0.1428p pd=1.52u as=0.1523p ps=1.38u w=0.42u l=0.13u
X6130 a_39014_10301# B_uq24 VSS VSS sg13_lv_nmos ad=0.1045p pd=0.93u as=0.187p ps=1.78u w=0.55u l=0.13u
X6131 X_uq241 a_75679_25229# VDD VDD sg13_lv_pmos ad=0.42p pd=2.99u as=0.2114p ps=1.54u w=1.12u l=0.13u
X6132 a_10349_35023# a_10347_35900# a_10428_35406# VDD sg13_lv_pmos ad=79.8f pd=0.8u as=63f ps=0.72u w=0.42u l=0.13u
X6133 VDD VSS VDD VDD sg13_lv_pmos ad=0.19p pd=1.38u as=0 ps=0 w=1u l=1u
X6134 X_uq31 a_34398_6937# VDD VDD sg13_lv_pmos ad=0.42p pd=2.99u as=0.2114p ps=1.54u w=1.12u l=0.13u
X6135 a_5809_35739# a_5833_35847# VDD VDD sg13_lv_pmos ad=0.34p pd=2.68u as=0.2254p ps=1.53u w=1u l=0.5u
X6136 a_76171_27789# Y_uq149 a_76069_27789# VDD sg13_lv_pmos ad=0.2128p pd=1.5u as=0.2128p ps=1.5u w=1.12u l=0.13u
X6137 VDD a_40785_65867# a_40887_65867# VDD sg13_lv_pmos ad=1.41367p pd=8.85u as=0.3864p ps=2.93u w=1.12u l=0.13u
X6138 VSS a_44219_67729# a_44886_67368# VSS sg13_lv_nmos ad=0.1406p pd=1.12u as=0.2516p ps=2.16u w=0.74u l=0.13u
X6139 VSS a_31061_68064# a_30982_68339# VSS sg13_lv_nmos ad=2.08687p pd=13.23u as=0.27427p ps=2.28u w=0.795u l=0.13u
X6140 Y_uq15 a_34500_9229# VSS VSS sg13_lv_nmos ad=0.1406p pd=1.12u as=0.17255p ps=1.25u w=0.74u l=0.13u
X6141 a_51057_69673# a_51057_69673# VSS VSS sg13_lv_nmos ad=0.111p pd=1.34u as=2.01085p ps=12.81u w=0.3u l=0.13u
X6142 a_11392_22671# D_uq7 a_11278_22671# VDD sg13_lv_pmos ad=0.2128p pd=1.5u as=0.2464p ps=1.56u w=1.12u l=0.13u
X6143 a_3539_37753# a_3575_38075# VDD VDD sg13_lv_pmos ad=0.34p pd=2.68u as=0.2254p ps=1.53u w=1u l=0.5u
X6144 a_42010_65283# a_42125_65284# VDD VDD sg13_lv_pmos ad=0.34p pd=2.68u as=0.2254p ps=1.53u w=1u l=0.5u
X6145 a_32696_66570# X_uq435 VDD VDD sg13_lv_pmos ad=0.2856p pd=2.36u as=0.2114p ps=1.54u w=0.84u l=0.13u
X6146 a_49221_69945# a_48279_69752# a_49019_69707# VDD sg13_lv_pmos ad=93.45f pd=0.865u as=0.2048p ps=1.63u w=0.42u l=0.13u
X6147 a_31832_68082# Y_uq364 VDD VDD sg13_lv_pmos ad=0.2856p pd=2.36u as=0.2114p ps=1.54u w=0.84u l=0.13u
X6148 Y_uq75 C_uq21 VSS VSS sg13_lv_nmos ad=0.1406p pd=1.12u as=0.2516p ps=2.16u w=0.74u l=0.13u
X6149 VSS a_39484_64586# a_39133_64705# VSS sg13_lv_nmos ad=79.8f pd=0.8u as=0.1428p ps=1.52u w=0.42u l=0.13u
X6150 VDD Y_uq130 a_9233_25435# VDD sg13_lv_pmos ad=0.2114p pd=1.54u as=0.2856p ps=2.36u w=0.84u l=0.13u
X6151 VDD VSS VDD VDD sg13_lv_pmos ad=0.19p pd=1.38u as=0 ps=0 w=1u l=1u
X6152 a_7337_37793# X_uq303 C_uq39 VDD sg13_lv_pmos ad=0.2128p pd=1.5u as=0.2128p ps=1.5u w=1.12u l=0.15u
X6153 a_47265_67415# L_HI_uq26 VDD VDD sg13_lv_pmos ad=0.147p pd=1.54u as=0.1563p ps=1.22u w=0.42u l=0.13u
X6154 VSS q[2] a_32958_9173# VSS sg13_lv_nmos ad=0.14875p pd=1.16u as=0.187p ps=1.78u w=0.55u l=0.13u
X6155 VDD a_39779_65175# a_39779_65409# VDD sg13_lv_pmos ad=1.41367p pd=8.85u as=0.2442p ps=2.06u w=0.66u l=0.13u
X6156 a_5809_40625# A_uq334 VSS VSS sg13_lv_nmos ad=0.187p pd=1.78u as=0.14875p ps=1.16u w=0.55u l=0.13u
X6157 a_43170_8709# a_42948_8453# VDD VDD sg13_lv_pmos ad=0.1176p pd=1.33u as=0.2618p ps=1.63u w=1.12u l=0.13u
X6158 Y_uq232 X_uq323 VSS VSS sg13_lv_nmos ad=0.2516p pd=2.16u as=0.2516p ps=2.16u w=0.74u l=0.13u
X6159 Q_uq49 a_52566_67368# VDD VDD sg13_lv_pmos ad=0.3808p pd=2.92u as=0.2128p ps=1.5u w=1.12u l=0.13u
X6160 VDD a_46906_69147# X_uq427 VDD sg13_lv_pmos ad=0.2254p pd=1.53u as=0.4256p ps=3u w=1.12u l=0.13u
X6161 VDD a_43750_65062# a_43469_65284# VDD sg13_lv_pmos ad=0.1523p pd=1.38u as=0.34p ps=2.68u w=1u l=0.5u
X6162 B1_uq1 Y_uq116 a_76266_25577# VSS sg13_lv_nmos ad=0.1406p pd=1.12u as=0.1406p ps=1.12u w=0.74u l=0.13u
X6163 Q_uq55 a_38166_69928# VSS VSS sg13_lv_nmos ad=0.2516p pd=2.16u as=0.1406p ps=1.12u w=0.74u l=0.13u
X6164 VSS VDD VSS VSS sg13_lv_nmos ad=0.1428p pd=1.52u as=0 ps=-0 w=0.42u l=1u
X6165 a_39484_64586# a_39227_64705# a_39646_64782# VSS sg13_lv_nmos ad=0.1428p pd=1.52u as=37.8f ps=0.6u w=0.42u l=0.13u
X6166 VDD X_uq297 Y_uq163 VDD sg13_lv_pmos ad=0.3808p pd=2.92u as=0.3808p ps=2.92u w=1.12u l=0.13u
X6167 VDD a_34286_10067# A_uq93 VDD sg13_lv_pmos ad=0.2226p pd=1.535u as=0.3976p ps=2.95u w=1.12u l=0.13u
X6168 a_39622_63550# Q_uq29 VDD VDD sg13_lv_pmos ad=0.1428p pd=1.52u as=0.1523p ps=1.38u w=0.42u l=0.13u
X6169 VSS a_40277_68064# a_40198_68339# VSS sg13_lv_nmos ad=2.08687p pd=13.23u as=0.27427p ps=2.28u w=0.795u l=0.13u
X6170 a_48914_65098# a_48644_65098# VSS VSS sg13_lv_nmos ad=0.1428p pd=1.52u as=79.8f ps=0.8u w=0.42u l=0.5u
X6171 X_uq235 a_11057_24647# VDD VDD sg13_lv_pmos ad=0.42p pd=2.99u as=0.2114p ps=1.54u w=1.12u l=0.13u
X6172 VSS C_uq72 D_uq65 VSS sg13_lv_nmos ad=0.1463p pd=1.15u as=0.2618p ps=2.22u w=0.77u l=0.13u
X6173 VSS L_HI a_78881_22643# VSS sg13_lv_nmos ad=79.8f pd=0.8u as=37.8f ps=0.6u w=0.42u l=0.13u
X6174 VDD din[29] a_76831_18457# VDD sg13_lv_pmos ad=0.2114p pd=1.54u as=0.2856p ps=2.36u w=0.84u l=0.13u
X6175 VSS a_51899_67729# a_52566_67368# VSS sg13_lv_nmos ad=0.1406p pd=1.12u as=0.2516p ps=2.16u w=0.74u l=0.13u
X6176 VSS a_80076_22252# a_79155_22566# VSS sg13_lv_nmos ad=0.1626p pd=1.415u as=0.2516p ps=2.16u w=0.74u l=0.13u
X6177 VDD C_uq24 a_10103_25775# VDD sg13_lv_pmos ad=0.2226p pd=1.535u as=0.1596p ps=1.22u w=0.84u l=0.13u
X6178 VDD a_44326_69598# a_44045_69820# VDD sg13_lv_pmos ad=0.1523p pd=1.38u as=0.34p ps=2.68u w=1u l=0.5u
X6179 a_5932_42743# a_5809_43188# a_6283_42871# VSS sg13_lv_nmos ad=0.1428p pd=1.52u as=37.8f ps=0.6u w=0.42u l=0.13u
X6180 VDD din[25] a_75295_18457# VDD sg13_lv_pmos ad=0.2114p pd=1.54u as=0.2856p ps=2.36u w=0.84u l=0.13u
X6181 a_7056_25619# X_uq282 VSS VSS sg13_lv_nmos ad=0.187p pd=1.78u as=0.14875p ps=1.16u w=0.55u l=0.13u
X6182 a_11566_21159# A_N VDD VDD sg13_lv_pmos ad=0.2464p pd=1.56u as=0.3808p ps=2.92u w=1.12u l=0.13u
X6183 VSS a_42562_6863# X_uq10 VSS sg13_lv_nmos ad=0.14875p pd=1.16u as=0.2886p ps=2.26u w=0.74u l=0.13u
X6184 C a_8945_19387# VSS VSS sg13_lv_nmos ad=0.2886p pd=2.26u as=0.14875p ps=1.16u w=0.74u l=0.13u
X6185 Q_uq56 a_34518_69928# VSS VSS sg13_lv_nmos ad=0.2516p pd=2.16u as=0.1406p ps=1.12u w=0.74u l=0.13u
X6186 a_4758_32587# Y_uq174 VSS VSS sg13_lv_nmos ad=37.8f pd=0.6u as=0.1701p ps=1.65u w=0.42u l=0.13u
X6187 X_uq293 a_3535_34367# VDD VDD sg13_lv_pmos ad=0.42p pd=2.99u as=0.2114p ps=1.54u w=1.12u l=0.13u
X6188 VDD clk a_39755_68851# VDD sg13_lv_pmos ad=1.39265p pd=8.395u as=0.4088p ps=2.97u w=1.12u l=0.13u
X6189 a_39874_8375# Y_uq15 VSS VSS sg13_lv_nmos ad=0.187p pd=1.78u as=0.14875p ps=1.16u w=0.55u l=0.13u
X6190 VSS L_HI_uq6 a_3688_24581# VSS sg13_lv_nmos ad=0.1626p pd=1.415u as=60.89999f ps=0.71u w=0.42u l=0.13u
X6191 VDD a_79886_21524# a_79886_21758# VDD sg13_lv_pmos ad=1.59725p pd=10.05u as=0.2442p ps=2.06u w=0.66u l=0.13u
X6192 VDD clk a_29579_64315# VDD sg13_lv_pmos ad=1.4357p pd=8.83u as=0.4088p ps=2.97u w=1.12u l=0.13u
X6193 X_uq167 a_32382_10685# VSS VSS sg13_lv_nmos ad=0.2886p pd=2.26u as=0.14875p ps=1.16u w=0.74u l=0.13u
X6194 a_8869_32682# B_uq76 VDD VDD sg13_lv_pmos ad=0.2464p pd=1.56u as=0.3808p ps=2.92u w=1.12u l=0.13u
X6195 VSS a_47864_66570# A VSS sg13_lv_nmos ad=0.14875p pd=1.16u as=0.2886p ps=2.26u w=0.74u l=0.13u
X6196 VDD a_46786_6863# X_uq0 VDD sg13_lv_pmos ad=0.2114p pd=1.54u as=0.42p ps=2.99u w=1.12u l=0.13u
X6197 a_8075_40255# S VSS VSS sg13_lv_nmos ad=0.1428p pd=1.52u as=79.8f ps=0.8u w=0.42u l=0.13u
X6198 a_38651_66217# a_37809_65867# a_37392_65860# VDD sg13_lv_pmos ad=0.2048p pd=1.63u as=0.34p ps=2.68u w=1u l=0.13u
X6199 VSS a_36440_64308# q[11] VSS sg13_lv_nmos ad=0.14875p pd=1.16u as=0.2886p ps=2.26u w=0.74u l=0.13u
X6200 a_5849_41193# a_5847_41975# a_5809_43188# VSS sg13_lv_nmos ad=0.3473p pd=2.71u as=0.12665p ps=1.145u w=0.74u l=0.13u
X6201 a_4681_21848# clk VSS VSS sg13_lv_nmos ad=0.2516p pd=2.16u as=1.70717p ps=10.335u w=0.74u l=0.13u
X6202 X_uq249 a_8849_25435# VSS VSS sg13_lv_nmos ad=0.2886p pd=2.26u as=0.14875p ps=1.16u w=0.74u l=0.13u
X6203 X_uq174 a_77215_18457# VSS VSS sg13_lv_nmos ad=0.2886p pd=2.26u as=0.14875p ps=1.16u w=0.74u l=0.13u
X6204 a_80729_22643# L_HI VSS VSS sg13_lv_nmos ad=60.89999f pd=0.71u as=0.1626p ps=1.415u w=0.42u l=0.13u
X6205 a_46690_9887# A_uq65 VSS VSS sg13_lv_nmos ad=0.187p pd=1.78u as=0.14875p ps=1.16u w=0.55u l=0.13u
X6206 D_uq27 D_uq23 VSS VSS sg13_lv_nmos ad=0.1694p pd=1.21u as=0.2618p ps=2.22u w=0.77u l=0.13u
X6207 VDD A_uq75 a_42660_9149# VDD sg13_lv_pmos ad=0.2226p pd=1.535u as=0.1596p ps=1.22u w=0.84u l=0.13u
X6208 a_42592_8709# A_uq75 Y_uq2 VDD sg13_lv_pmos ad=0.1176p pd=1.33u as=0.3808p ps=2.92u w=1.12u l=0.13u
X6209 VDD clk a_79286_28224# VDD sg13_lv_pmos ad=1.59725p pd=10.05u as=0.4088p ps=2.97u w=1.12u l=0.13u
X6210 a_4299_33212# clk VDD VDD sg13_lv_pmos ad=0.4088p pd=2.97u as=1.25632p ps=8.01u w=1.12u l=0.13u
X6211 VSS a_50936_63546# q[24] VSS sg13_lv_nmos ad=0.14875p pd=1.16u as=0.2886p ps=2.26u w=0.74u l=0.13u
X6212 VSS B_uq89 a_6215_38548# VSS sg13_lv_nmos ad=0.14505p pd=1.15u as=0.1406p ps=1.12u w=0.74u l=0.13u
X6213 C_uq67 X_uq420 VSS VSS sg13_lv_nmos ad=0.1406p pd=1.12u as=0.2516p ps=2.16u w=0.74u l=0.13u
X6214 a_10806_33275# a_10385_33469# a_10661_32879# VSS sg13_lv_nmos ad=37.8f pd=0.6u as=0.1428p ps=1.52u w=0.42u l=0.13u
X6215 VDD X_uq286 a_8869_33953# VDD sg13_lv_pmos ad=0.2128p pd=1.5u as=0.3808p ps=2.92u w=1.12u l=0.13u
X6216 VDD a_79155_21054# a_80178_20740# VDD sg13_lv_pmos ad=0.1563p pd=1.22u as=63f ps=0.72u w=0.42u l=0.13u
X6217 a_41937_68880# X_uq447 VDD VDD sg13_lv_pmos ad=0.2464p pd=1.56u as=0.3808p ps=2.92u w=1.12u l=0.13u
X6218 a_30875_67729# a_30033_67379# a_30781_67729# VSS sg13_lv_nmos ad=0.12665p pd=1.145u as=0.1428p ps=1.52u w=0.42u l=0.13u
X6219 a_8116_31287# a_8086_31722# a_8107_31019# VSS sg13_lv_nmos ad=79.8f pd=0.8u as=0.1296p ps=1.52u w=0.42u l=0.13u
X6220 a_31473_65893# a_31473_65893# VSS VSS sg13_lv_nmos ad=0.111p pd=1.34u as=1.8643p ps=11.96u w=0.3u l=0.13u
X6221 VDD Q_uq14 a_7321_34574# VDD sg13_lv_pmos ad=0.2856p pd=2.36u as=0.1596p ps=1.22u w=0.84u l=0.13u
X6222 a_8116_41079# a_8086_41514# a_8498_41454# VDD sg13_lv_pmos ad=79.8f pd=0.8u as=63f ps=0.72u w=0.42u l=0.13u
X6223 VDD SLN[7] a_33150_10685# VDD sg13_lv_pmos ad=0.2114p pd=1.54u as=0.2856p ps=2.36u w=0.84u l=0.13u
X6224 VDD VSS VDD VDD sg13_lv_pmos ad=0.34p pd=2.68u as=0 ps=0 w=1u l=1u
X6225 a_76651_28601# Y_uq152 VSS VSS sg13_lv_nmos ad=0.1406p pd=1.12u as=0.1406p ps=1.12u w=0.74u l=0.13u
X6226 VSS Y_uq293 a_36436_63620# VSS sg13_lv_nmos ad=0.14875p pd=1.16u as=0.187p ps=1.78u w=0.55u l=0.13u
X6227 a_5410_25593# a_5211_25730# VSS VSS sg13_lv_nmos ad=0.27427p pd=2.28u as=2.05957p ps=13.455u w=0.795u l=0.13u
X6228 VSS a_40017_67379# a_40119_67379# VSS sg13_lv_nmos ad=2.08687p pd=13.23u as=0.2516p ps=2.16u w=0.74u l=0.13u
X6229 a_76645_23253# B1 a_76747_23253# VDD sg13_lv_pmos ad=0.3808p pd=2.92u as=0.2128p ps=1.5u w=1.12u l=0.13u
X6230 VSS L_HI_uq5 a_5608_24893# VSS sg13_lv_nmos ad=0.1626p pd=1.415u as=60.89999f ps=0.71u w=0.42u l=0.13u
X6231 VSS a_3535_31126# Q_uq11 VSS sg13_lv_nmos ad=0.1406p pd=1.12u as=0.2516p ps=2.16u w=0.74u l=0.13u
X6232 X_uq148 a_40062_10685# VSS VSS sg13_lv_nmos ad=0.2886p pd=2.26u as=0.14875p ps=1.16u w=0.74u l=0.13u
X6233 VSS B_uq77 C_uq30 VSS sg13_lv_nmos ad=0.2516p pd=2.16u as=0.1406p ps=1.12u w=0.74u l=0.13u
X6234 D_uq41 a_28866_65162# VSS VSS sg13_lv_nmos ad=0.2516p pd=2.16u as=0.1426p ps=1.16u w=0.74u l=0.13u
X6235 VDD a_30203_66217# a_30870_65856# VDD sg13_lv_pmos ad=0.2128p pd=1.5u as=0.3864p ps=2.93u w=1.12u l=0.13u
X6236 VSS a_49112_63546# q[23] VSS sg13_lv_nmos ad=0.14875p pd=1.16u as=0.2886p ps=2.26u w=0.74u l=0.13u
X6237 D_uq34 X_uq445 VSS VSS sg13_lv_nmos ad=0.1694p pd=1.21u as=0.2618p ps=2.22u w=0.77u l=0.13u
X6238 a_46306_9137# A_uq38 VDD VDD sg13_lv_pmos ad=0.2856p pd=2.36u as=0.2114p ps=1.54u w=0.84u l=0.13u
X6239 VDD a_41794_7625# X_uq46 VDD sg13_lv_pmos ad=0.2114p pd=1.54u as=0.42p ps=2.99u w=1.12u l=0.13u
X6240 VDD A_uq75 a_44388_10301# VDD sg13_lv_pmos ad=0.2226p pd=1.535u as=0.1596p ps=1.22u w=0.84u l=0.13u
X6241 VSS a_31996_65314# a_31645_65171# VSS sg13_lv_nmos ad=79.8f pd=0.8u as=0.1428p ps=1.52u w=0.42u l=0.13u
X6242 a_29973_67415# a_29616_67372# VDD VDD sg13_lv_pmos ad=63f pd=0.72u as=0.1563p ps=1.22u w=0.42u l=0.13u
X6243 VSS a_39106_7625# X_uq53 VSS sg13_lv_nmos ad=0.14875p pd=1.16u as=0.2886p ps=2.26u w=0.74u l=0.13u
X6244 a_46522_64782# a_46264_64782# VSS VSS sg13_lv_nmos ad=0.1428p pd=1.52u as=79.8f ps=0.8u w=0.42u l=0.13u
X6245 a_45932_64631# a_46051_64308# VDD VDD sg13_lv_pmos ad=0.3864p pd=2.93u as=0.2128p ps=1.5u w=1.12u l=0.13u
X6246 a_37942_64312# a_38385_64355# a_38325_64391# VDD sg13_lv_pmos ad=79.8f pd=0.8u as=63f ps=0.72u w=0.42u l=0.13u
X6247 VSS a_44603_66217# a_45270_65856# VSS sg13_lv_nmos ad=0.1406p pd=1.12u as=0.2516p ps=2.16u w=0.74u l=0.13u
X6248 VDD a_40642_6863# X_uq15 VDD sg13_lv_pmos ad=0.2114p pd=1.54u as=0.42p ps=2.99u w=1.12u l=0.13u
X6249 a_3535_31228# a_3546_31883# a_3886_31699# VDD sg13_lv_pmos ad=0.2048p pd=1.63u as=93.45f ps=0.865u w=0.42u l=0.13u
X6250 a_8075_40255# S VDD VDD sg13_lv_pmos ad=0.1428p pd=1.52u as=0.1523p ps=1.38u w=0.42u l=0.13u
X6251 VDD Y_uq286 a_46148_66610# VDD sg13_lv_pmos ad=0.1523p pd=1.38u as=0.1428p ps=1.52u w=0.42u l=0.13u
X6252 a_78625_24690# a_79068_24446# a_79008_24858# VDD sg13_lv_pmos ad=79.8f pd=0.8u as=63f ps=0.72u w=0.42u l=0.13u
X6253 VSS B_uq79 D_uq16 VSS sg13_lv_nmos ad=0.2618p pd=2.22u as=0.1694p ps=1.21u w=0.77u l=0.13u
X6254 VDD a_52582_68086# a_52301_68308# VDD sg13_lv_pmos ad=0.1523p pd=1.38u as=0.34p ps=2.68u w=1u l=0.5u
X6255 VSS a_44602_68307# D_uq58 VSS sg13_lv_nmos ad=0.1426p pd=1.16u as=0.2516p ps=2.16u w=0.74u l=0.13u
X6256 VSS a_51292_68338# a_50941_68195# VSS sg13_lv_nmos ad=79.8f pd=0.8u as=0.1428p ps=1.52u w=0.42u l=0.13u
X6257 VSS a_51201_66764# a_50280_66570# VSS sg13_lv_nmos ad=0.1626p pd=1.415u as=0.2516p ps=2.16u w=0.74u l=0.13u
X6258 VDD X_uq251 a_76154_20693# VDD sg13_lv_pmos ad=0.3808p pd=2.92u as=0.2464p ps=1.56u w=1.12u l=0.13u
X6259 VSS X_uq406 C_uq57 VSS sg13_lv_nmos ad=0.2516p pd=2.16u as=0.1406p ps=1.12u w=0.74u l=0.13u
X6260 a_39624_69241# a_39755_68851# a_39043_68844# VDD sg13_lv_pmos ad=0.34p pd=2.68u as=0.2048p ps=1.63u w=1u l=0.13u
X6261 a_10078_21061# A_N VSS VSS sg13_lv_nmos ad=0.187p pd=1.78u as=0.18575p ps=1.26u w=0.55u l=0.13u
X6262 a_4301_32335# a_4299_33212# a_4380_32906# VSS sg13_lv_nmos ad=79.8f pd=0.8u as=0.1296p ps=1.52u w=0.42u l=0.13u
X6263 a_43632_66281# a_43863_65867# a_43318_65824# VSS sg13_lv_nmos ad=0.2373p pd=1.97u as=79.8f ps=0.8u w=0.42u l=0.13u
X6264 a_46402_7625# X_uq72 VSS VSS sg13_lv_nmos ad=0.187p pd=1.78u as=0.14875p ps=1.16u w=0.55u l=0.13u
X6265 a_49276_69850# a_49019_69707# a_49438_69630# VSS sg13_lv_nmos ad=0.1428p pd=1.52u as=37.8f ps=0.6u w=0.42u l=0.13u
X6266 a_51971_65485# D_uq36 a_52718_65094# VSS sg13_lv_nmos ad=0.1428p pd=1.52u as=60.89999f ps=0.71u w=0.42u l=0.13u
X6267 a_40258_7625# A_uq80 VSS VSS sg13_lv_nmos ad=0.187p pd=1.78u as=0.14875p ps=1.16u w=0.55u l=0.13u
X6268 Y_uq212 Y_uq211 VSS VSS sg13_lv_nmos ad=0.1406p pd=1.12u as=0.2516p ps=2.16u w=0.74u l=0.13u
X6269 VDD a_43354_65283# D_uq43 VDD sg13_lv_pmos ad=0.2254p pd=1.53u as=0.4256p ps=3u w=1.12u l=0.13u
X6270 VDD a_79026_27533# C_uq29 VDD sg13_lv_pmos ad=0.3808p pd=2.92u as=0.2128p ps=1.5u w=1.12u l=0.13u
X6271 a_9665_35055# D_uq30 a_9665_34953# VSS sg13_lv_nmos ad=0.1216p pd=1.02u as=0.1216p ps=1.02u w=0.64u l=0.13u
X6272 a_47753_68880# C_uq68 D_uq60 VDD sg13_lv_pmos ad=0.2128p pd=1.5u as=0.3808p ps=2.92u w=1.12u l=0.13u
X6273 a_79434_25577# A2_uq1 VSS VSS sg13_lv_nmos ad=0.1406p pd=1.12u as=0.2516p ps=2.16u w=0.74u l=0.13u
X6274 Y_uq277 Q_uq47 VSS VSS sg13_lv_nmos ad=0.1406p pd=1.12u as=0.2516p ps=2.16u w=0.74u l=0.13u
X6275 a_5942_21869# L_HI_uq1 VSS VSS sg13_lv_nmos ad=37.8f pd=0.6u as=79.8f ps=0.8u w=0.42u l=0.13u
X6276 VDD a_34108_69850# a_34053_69945# VDD sg13_lv_pmos ad=1.6733p pd=10.405u as=93.45f ps=0.865u w=0.42u l=0.13u
X6277 a_12341_19647# C_uq4 Y_uq39 VDD sg13_lv_pmos ad=0.1176p pd=1.33u as=0.3808p ps=2.92u w=1.12u l=0.13u
X6278 VDD a_34715_64705# a_34972_64586# VDD sg13_lv_pmos ad=1.4745p pd=9.07u as=79.8f ps=0.8u w=0.42u l=0.13u
X6279 a_51292_68338# a_51035_68195# a_51454_68118# VSS sg13_lv_nmos ad=0.1428p pd=1.52u as=37.8f ps=0.6u w=0.42u l=0.13u
X6280 a_37454_9489# X_uq162 VSS VSS sg13_lv_nmos ad=0.1045p pd=0.93u as=0.1469p ps=1.155u w=0.55u l=0.13u
X6281 X_uq144 a_41214_10685# VDD VDD sg13_lv_pmos ad=0.42p pd=2.99u as=0.2114p ps=1.54u w=1.12u l=0.13u
X6282 X_uq16 a_40158_6937# VDD VDD sg13_lv_pmos ad=0.42p pd=2.99u as=0.2114p ps=1.54u w=1.12u l=0.13u
X6283 VSS B_uq84 a_6215_37087# VSS sg13_lv_nmos ad=0.2516p pd=2.16u as=0.1406p ps=1.12u w=0.74u l=0.13u
X6284 a_5608_23381# D_uq6 a_5514_23381# VSS sg13_lv_nmos ad=60.89999f pd=0.71u as=0.1428p ps=1.52u w=0.42u l=0.13u
X6285 X_uq199 a_6956_20395# VSS VSS sg13_lv_nmos ad=0.2886p pd=2.26u as=0.14875p ps=1.16u w=0.74u l=0.13u
X6286 a_9632_40617# a_9594_41669# a_9628_40311# VSS sg13_lv_nmos ad=0.2373p pd=1.97u as=79.8f ps=0.8u w=0.42u l=0.13u
X6287 Y_uq314 a_28378_67424# VSS VSS sg13_lv_nmos ad=0.1406p pd=1.12u as=0.17255p ps=1.25u w=0.74u l=0.13u
X6288 VSS X_uq319 Y_uq169 VSS sg13_lv_nmos ad=0.2516p pd=2.16u as=0.2516p ps=2.16u w=0.74u l=0.13u
X6289 a_30768_65107# a_30999_65216# a_30454_65317# VSS sg13_lv_nmos ad=0.2373p pd=1.97u as=79.8f ps=0.8u w=0.42u l=0.13u
X6290 VDD X_uq436 a_29039_67368# VDD sg13_lv_pmos ad=0.3808p pd=2.92u as=0.2464p ps=1.56u w=1.12u l=0.13u
X6291 a_38534_10301# B_uq26 VSS VSS sg13_lv_nmos ad=0.1045p pd=0.93u as=0.187p ps=1.78u w=0.55u l=0.13u
X6292 VDD a_5208_21083# a_5166_21119# VDD sg13_lv_pmos ad=0.2618p pd=1.63u as=0.1176p ps=1.33u w=1.12u l=0.13u
X6293 VSS Y_uq264 a_40468_63620# VSS sg13_lv_nmos ad=0.14875p pd=1.16u as=0.187p ps=1.78u w=0.55u l=0.13u
X6294 VDD B_uq67 a_76534_26717# VDD sg13_lv_pmos ad=0.3808p pd=2.92u as=0.2744p ps=1.61u w=1.12u l=0.13u
X6295 VSS a_42178_7625# X_uq45 VSS sg13_lv_nmos ad=0.14875p pd=1.16u as=0.2886p ps=2.26u w=0.74u l=0.13u
X6296 VDD a_47265_67415# a_46344_67729# VDD sg13_lv_pmos ad=0.36237p pd=2.605u as=0.34p ps=2.68u w=1u l=0.13u
X6297 a_9619_42007# Y_uq228 VSS VSS sg13_lv_nmos ad=37.8f pd=0.6u as=79.8f ps=0.8u w=0.42u l=0.13u
X6298 VDD a_43516_64586# a_43461_64467# VDD sg13_lv_pmos ad=1.4745p pd=9.07u as=93.45f ps=0.865u w=0.42u l=0.13u
X6299 a_34876_68338# L_HI_uq30 VDD VDD sg13_lv_pmos ad=79.8f pd=0.8u as=1.42837p ps=8.61u w=0.42u l=0.13u
X6300 a_30107_69707# a_29265_69609# a_30013_69707# VSS sg13_lv_nmos ad=0.12665p pd=1.145u as=0.1428p ps=1.52u w=0.42u l=0.13u
X6301 VSS X_uq399 a_44602_63624# VSS sg13_lv_nmos ad=0.17255p pd=1.25u as=0.187p ps=1.78u w=0.55u l=0.13u
X6302 a_41884_66098# L_HI_uq14 VDD VDD sg13_lv_pmos ad=79.8f pd=0.8u as=1.41367p ps=8.85u w=0.42u l=0.13u
X6303 a_9583_39287# a_9583_39451# a_9619_39415# VSS sg13_lv_nmos ad=0.1428p pd=1.52u as=37.8f ps=0.6u w=0.42u l=0.13u
X6304 a_43198_69630# L_HI_uq36 VSS VSS sg13_lv_nmos ad=37.8f pd=0.6u as=79.8f ps=0.8u w=0.42u l=0.13u
X6305 C_uq18 B_uq65 VSS VSS sg13_lv_nmos ad=0.1406p pd=1.12u as=0.2516p ps=2.16u w=0.74u l=0.13u
X6306 VSS din[19] a_75295_22205# VSS sg13_lv_nmos ad=0.14875p pd=1.16u as=0.187p ps=1.78u w=0.55u l=0.13u
X6307 a_4681_38712# B_uq88 VSS VSS sg13_lv_nmos ad=0.1406p pd=1.12u as=0.2516p ps=2.16u w=0.74u l=0.13u
X6308 a_30480_65412# a_30999_65216# a_31739_65171# VSS sg13_lv_nmos ad=0.3473p pd=2.71u as=0.12665p ps=1.145u w=0.74u l=0.13u
X6309 D_uq60 Y_uq332 VSS VSS sg13_lv_nmos ad=0.1694p pd=1.21u as=0.1463p ps=1.15u w=0.77u l=0.13u
X6310 B_uq22 a_39678_10685# VSS VSS sg13_lv_nmos ad=0.2886p pd=2.26u as=0.14875p ps=1.16u w=0.74u l=0.13u
X6311 VSS Y_uq243 Y_uq258 VSS sg13_lv_nmos ad=0.1463p pd=1.15u as=0.1694p ps=1.21u w=0.77u l=0.13u
X6312 VDD VSS VDD VDD sg13_lv_pmos ad=0.34p pd=2.68u as=0 ps=0 w=1u l=1u
X6313 WL_REF a_7321_43295# VSS VSS sg13_lv_nmos ad=0.2886p pd=2.26u as=0.14875p ps=1.16u w=0.74u l=0.13u
X6314 VSS L_HI_uq13 a_45936_66294# VSS sg13_lv_nmos ad=0.1626p pd=1.415u as=60.89999f ps=0.71u w=0.42u l=0.13u
X6315 VDD X_uq431 a_41428_68880# VDD sg13_lv_pmos ad=0.2114p pd=1.54u as=0.2856p ps=2.36u w=0.84u l=0.13u
X6316 a_46786_6863# Y_uq17 VDD VDD sg13_lv_pmos ad=0.2856p pd=2.36u as=0.2114p ps=1.54u w=0.84u l=0.13u
X6317 a_50640_67372# a_51159_67379# a_51899_67729# VSS sg13_lv_nmos ad=0.3473p pd=2.71u as=0.12665p ps=1.145u w=0.74u l=0.13u
X6318 a_49622_64344# Q_uq52 Y_uq242 VDD sg13_lv_pmos ad=0.1176p pd=1.33u as=0.3808p ps=2.92u w=1.12u l=0.13u
X6319 VSS Y_uq267 D_uq44 VSS sg13_lv_nmos ad=0.1463p pd=1.15u as=0.1694p ps=1.21u w=0.77u l=0.13u
X6320 a_34246_65062# Q_uq47 VDD VDD sg13_lv_pmos ad=0.1428p pd=1.52u as=0.1523p ps=1.38u w=0.42u l=0.13u
X6321 D_uq59 Y_uq329 VSS VSS sg13_lv_nmos ad=0.1694p pd=1.21u as=0.1463p ps=1.15u w=0.77u l=0.13u
X6322 B_uq24 a_38142_10685# VSS VSS sg13_lv_nmos ad=0.2886p pd=2.26u as=0.14875p ps=1.16u w=0.74u l=0.13u
X6323 L_HI_uq36 a_41034_69882# VDD VDD sg13_lv_pmos ad=0.3927p pd=2.99u as=1.6733p ps=10.405u w=1.155u l=0.13u
X6324 a_28918_65824# a_29361_65867# a_29301_65903# VDD sg13_lv_pmos ad=79.8f pd=0.8u as=63f ps=0.72u w=0.42u l=0.13u
X6325 VDD a_6559_42743# a_6910_42654# VDD sg13_lv_pmos ad=2.4956p pd=16.32u as=93.45f ps=0.865u w=0.42u l=0.13u
X6326 a_5096_35083# Y_uq189 VSS VSS sg13_lv_nmos ad=37.8f pd=0.6u as=0.1701p ps=1.65u w=0.42u l=0.13u
X6327 a_31739_65171# a_30897_65073# a_30480_65412# VDD sg13_lv_pmos ad=0.2048p pd=1.63u as=0.34p ps=2.68u w=1u l=0.13u
X6328 a_39418_68307# a_39533_68308# VDD VDD sg13_lv_pmos ad=0.34p pd=2.68u as=0.2254p ps=1.53u w=1u l=0.5u
X6329 a_12149_22671# C_uq8 Y_uq95 VDD sg13_lv_pmos ad=0.1176p pd=1.33u as=0.3808p ps=2.92u w=1.12u l=0.13u
X6330 a_37618_66281# L_HI_uq20 VSS VSS sg13_lv_nmos ad=37.8f pd=0.6u as=0.1701p ps=1.65u w=0.42u l=0.13u
X6331 VDD Y_uq219 a_8869_34699# VDD sg13_lv_pmos ad=0.19p pd=1.38u as=0.2125p ps=1.425u w=1u l=0.13u
X6332 VSS Y_uq32 a_8561_17875# VSS sg13_lv_nmos ad=0.14875p pd=1.16u as=0.187p ps=1.78u w=0.55u l=0.13u
X6333 a_3580_35319# a_3550_35754# a_3962_35694# VDD sg13_lv_pmos ad=79.8f pd=0.8u as=63f ps=0.72u w=0.42u l=0.13u
X6334 VSS Q_uq52 Y_uq357 VSS sg13_lv_nmos ad=0.2516p pd=2.16u as=0.2516p ps=2.16u w=0.74u l=0.13u
X6335 a_76534_27133# B1_uq7 VSS VSS sg13_lv_nmos ad=0.13875p pd=1.115u as=0.2553p ps=2.17u w=0.74u l=0.13u
X6336 VDD X_uq446 a_49018_66648# VDD sg13_lv_pmos ad=0.2618p pd=1.63u as=0.2856p ps=2.36u w=0.84u l=0.13u
X6337 VDD L_HI_uq16 a_30454_65317# VDD sg13_lv_pmos ad=0.1563p pd=1.22u as=0.147p ps=1.54u w=0.42u l=0.13u
X6338 S_uq0 a_7321_31295# VDD VDD sg13_lv_pmos ad=0.42p pd=2.99u as=0.2114p ps=1.54u w=1.12u l=0.13u
X6339 VDD Q_uq35 Y_uq254 VDD sg13_lv_pmos ad=0.3808p pd=2.92u as=0.3808p ps=2.92u w=1.12u l=0.13u
X6340 VDD a_51320_69594# A_uq19 VDD sg13_lv_pmos ad=0.2114p pd=1.54u as=0.42p ps=2.99u w=1.12u l=0.13u
X6341 X_uq89 a_34302_8449# VDD VDD sg13_lv_pmos ad=0.42p pd=2.99u as=0.2114p ps=1.54u w=1.12u l=0.13u
X6342 a_7357_36139# X_uq312 VDD VDD sg13_lv_pmos ad=0.34p pd=2.68u as=0.19p ps=1.38u w=1u l=0.13u
X6343 a_8071_42477# a_8082_42437# a_8071_42811# VSS sg13_lv_nmos ad=0.3473p pd=2.71u as=0.12665p ps=1.145u w=0.74u l=0.13u
X6344 a_4456_33822# a_4335_33143# a_4297_34356# VDD sg13_lv_pmos ad=93.45f pd=0.865u as=0.2048p ps=1.63u w=0.42u l=0.13u
X6345 VSS VDD VSS VSS sg13_lv_nmos ad=79.8f pd=0.8u as=0 ps=-0 w=0.42u l=1u
X6346 X_uq447 a_41428_68880# VDD VDD sg13_lv_pmos ad=0.42p pd=2.99u as=0.2114p ps=1.54u w=1.12u l=0.13u
X6347 VDD Y_uq31 a_9713_17875# VDD sg13_lv_pmos ad=0.2114p pd=1.54u as=0.2856p ps=2.36u w=0.84u l=0.13u
X6348 a_7321_41297# Q_uq23 VDD VDD sg13_lv_pmos ad=0.2856p pd=2.36u as=0.2114p ps=1.54u w=0.84u l=0.13u
X6349 a_6604_31479# a_6574_31914# a_6986_31854# VDD sg13_lv_pmos ad=79.8f pd=0.8u as=63f ps=0.72u w=0.42u l=0.13u
X6350 VDD a_34690_7625# B_uq13 VDD sg13_lv_pmos ad=0.2114p pd=1.54u as=0.42p ps=2.99u w=1.12u l=0.13u
X6351 a_45634_8375# q[30] VSS VSS sg13_lv_nmos ad=0.187p pd=1.78u as=0.14875p ps=1.16u w=0.55u l=0.13u
X6352 a_4891_22631# Y_uq93 a_4777_22631# VDD sg13_lv_pmos ad=0.2128p pd=1.5u as=0.2464p ps=1.56u w=1.12u l=0.13u
X6353 VDD Q_uq43 Y_uq335 VDD sg13_lv_pmos ad=0.3808p pd=2.92u as=0.3808p ps=2.92u w=1.12u l=0.13u
X6354 D_uq46 C_uq56 a_28419_64344# VDD sg13_lv_pmos ad=0.3808p pd=2.92u as=0.2128p ps=1.5u w=1.12u l=0.13u
X6355 VDD a_49580_66781# Q_uq52 VDD sg13_lv_pmos ad=0.2128p pd=1.5u as=0.3808p ps=2.92u w=1.12u l=0.13u
X6356 a_46306_9137# A_uq38 VSS VSS sg13_lv_nmos ad=0.187p pd=1.78u as=0.14875p ps=1.16u w=0.55u l=0.13u
X6357 VSS B_uq50 C_uq13 VSS sg13_lv_nmos ad=0.2516p pd=2.16u as=0.1406p ps=1.12u w=0.74u l=0.13u
X6358 a_28658_66294# D_uq46 VDD VDD sg13_lv_pmos ad=79.8f pd=0.8u as=0.1428p ps=1.52u w=0.42u l=0.13u
X6359 a_6641_34510# B_uq77 VSS VSS sg13_lv_nmos ad=0.1216p pd=1.02u as=0.1331p ps=1.12u w=0.64u l=0.13u
X6360 C1 C_uq23 a_75630_19181# VDD sg13_lv_pmos ad=0.3808p pd=2.92u as=0.2128p ps=1.5u w=1.12u l=0.13u
X6361 VDD a_50854_69851# L_HI_uq33 VDD sg13_lv_pmos ad=1.6733p pd=10.405u as=0.3927p ps=2.99u w=1.155u l=0.13u
X6362 a_52006_63550# Q_uq40 VSS VSS sg13_lv_nmos ad=0.1428p pd=1.52u as=79.8f ps=0.8u w=0.42u l=0.13u
X6363 VDD a_8833_42996# a_8833_43098# VDD sg13_lv_pmos ad=0.2128p pd=1.5u as=0.3864p ps=2.93u w=1.12u l=0.13u
X6364 a_45932_64631# a_46051_64308# VSS VSS sg13_lv_nmos ad=0.2516p pd=2.16u as=0.1406p ps=1.12u w=0.74u l=0.13u
X6365 a_7742_21837# Q_uq0 VSS VSS sg13_lv_nmos ad=0.1428p pd=1.52u as=79.8f ps=0.8u w=0.42u l=0.13u
X6366 VDD X_uq435 a_33071_67368# VDD sg13_lv_pmos ad=0.3808p pd=2.92u as=0.2464p ps=1.56u w=1.12u l=0.13u
X6367 X_uq150 a_39294_10685# VDD VDD sg13_lv_pmos ad=0.42p pd=2.99u as=0.2114p ps=1.54u w=1.12u l=0.13u
X6368 a_51034_65409# a_50776_65094# VDD VDD sg13_lv_pmos ad=93.45f pd=0.865u as=1.41367p ps=8.85u w=0.42u l=0.13u
X6369 C_uq8 a_10343_22419# a_10669_22381# VSS sg13_lv_nmos ad=0.3404p pd=2.4u as=0.1406p ps=1.12u w=0.74u l=0.13u
X6370 a_10345_31516# a_10383_32686# a_10385_33469# VSS sg13_lv_nmos ad=0.12665p pd=1.145u as=0.3473p ps=2.71u w=0.74u l=0.13u
X6371 VDD a_30682_66795# X_uq404 VDD sg13_lv_pmos ad=0.2254p pd=1.53u as=0.4256p ps=3u w=1.12u l=0.13u
X6372 VDD Q_uq25 a_7292_38117# VDD sg13_lv_pmos ad=0.1596p pd=1.22u as=0.1596p ps=1.22u w=0.84u l=0.13u
X6373 a_36240_69948# a_36214_69853# VDD VDD sg13_lv_pmos ad=0.34p pd=2.68u as=0.36237p ps=2.605u w=1u l=0.13u
X6374 a_35458_7625# A_uq6 VDD VDD sg13_lv_pmos ad=0.2856p pd=2.36u as=0.2114p ps=1.54u w=0.84u l=0.13u
X6375 a_46416_66281# a_46128_65860# a_46354_66281# VSS sg13_lv_nmos ad=0.1428p pd=1.52u as=37.8f ps=0.6u w=0.42u l=0.13u
X6376 a_5051_42266# X_uq324 VSS VSS sg13_lv_nmos ad=0.187p pd=1.78u as=0.14505p ps=1.15u w=0.55u l=0.13u
X6377 a_40176_66294# D_uq48 a_40082_66294# VSS sg13_lv_nmos ad=60.89999f pd=0.71u as=0.1428p ps=1.52u w=0.42u l=0.13u
X6378 VSS X_uq429 a_37498_68936# VSS sg13_lv_nmos ad=0.17255p pd=1.25u as=0.187p ps=1.78u w=0.55u l=0.13u
X6379 VDD Y_uq174 a_4301_32335# VDD sg13_lv_pmos ad=0.1563p pd=1.22u as=0.147p ps=1.54u w=0.42u l=0.13u
X6380 VDD a_34766_10067# A_uq92 VDD sg13_lv_pmos ad=0.2226p pd=1.535u as=0.3976p ps=2.95u w=1.12u l=0.13u
X6381 B_uq38 a_77604_21489# VDD VDD sg13_lv_pmos ad=0.3808p pd=2.92u as=0.1918p ps=1.5u w=1.12u l=0.13u
X6382 a_40642_6863# Y_uq20 VDD VDD sg13_lv_pmos ad=0.2856p pd=2.36u as=0.2114p ps=1.54u w=0.84u l=0.13u
X6383 VDD a_37786_65283# D_uq39 VDD sg13_lv_pmos ad=0.2254p pd=1.53u as=0.4256p ps=3u w=1.12u l=0.13u
X6384 a_50162_64782# D_uq37 VDD VDD sg13_lv_pmos ad=79.8f pd=0.8u as=0.1428p ps=1.52u w=0.42u l=0.13u
X6385 a_75979_23253# Y_uq83 VDD VDD sg13_lv_pmos ad=0.2128p pd=1.5u as=0.3808p ps=2.92u w=1.12u l=0.13u
.ends

.subckt SoC6169 VDD analog_PAD clk_PAD input_PAD[0] input_PAD[1] input_PAD[2] input_PAD[3]
+ input_PAD[4] output_PAD rst_n_PAD IOVDD VSS
Xsg13cmos5l_decap_8_808 VSS VDD sg13cmos5l_decap_8
Xsg13cmos5l_decap_8_819 VSS VDD sg13cmos5l_decap_8
Xsg13cmos5l_decap_8_1080 VSS VDD sg13cmos5l_decap_8
Xsg13cmos5l_decap_8_1091 VSS VDD sg13cmos5l_decap_8
Xsg13cmos5l_decap_8_2709 VSS VDD sg13cmos5l_decap_8
Xsg13cmos5l_decap_4_61 VSS VDD sg13cmos5l_decap_4
Xsg13cmos5l_decap_4_50 VSS VDD sg13cmos5l_decap_4
Xsg13cmos5l_decap_4_94 VSS VDD sg13cmos5l_decap_4
Xsg13cmos5l_decap_4_83 VSS VDD sg13cmos5l_decap_4
Xsg13cmos5l_decap_4_72 VSS VDD sg13cmos5l_decap_4
Xsg13cmos5l_decap_8_616 VSS VDD sg13cmos5l_decap_8
Xsg13cmos5l_decap_8_605 VSS VDD sg13cmos5l_decap_8
Xsg13cmos5l_decap_8_627 VSS VDD sg13cmos5l_decap_8
Xsg13cmos5l_decap_8_649 VSS VDD sg13cmos5l_decap_8
Xsg13cmos5l_decap_8_638 VSS VDD sg13cmos5l_decap_8
Xsg13cmos5l_decap_8_3207 VSS VDD sg13cmos5l_decap_8
Xsg13cmos5l_decap_8_3229 VSS VDD sg13cmos5l_decap_8
Xsg13cmos5l_decap_8_3218 VSS VDD sg13cmos5l_decap_8
Xsg13cmos5l_decap_8_2517 VSS VDD sg13cmos5l_decap_8
Xsg13cmos5l_decap_8_2506 VSS VDD sg13cmos5l_decap_8
Xsg13cmos5l_decap_8_2528 VSS VDD sg13cmos5l_decap_8
Xsg13cmos5l_decap_8_2539 VSS VDD sg13cmos5l_decap_8
Xsg13cmos5l_decap_8_1816 VSS VDD sg13cmos5l_decap_8
Xsg13cmos5l_decap_8_1805 VSS VDD sg13cmos5l_decap_8
Xsg13cmos5l_IOPadAnalog_0 sg13cmos5l_IOPadAnalog_0/padres VDD VSS IOVDD IOVDD IOVDD
+ VSS analog_PAD sg13cmos5l_IOPadAnalog
Xsg13cmos5l_decap_8_1849 VSS VDD sg13cmos5l_decap_8
Xsg13cmos5l_decap_8_1838 VSS VDD sg13cmos5l_decap_8
Xsg13cmos5l_decap_8_1827 VSS VDD sg13cmos5l_decap_8
Xsg13cmos5l_decap_4_118 VSS VDD sg13cmos5l_decap_4
Xsg13cmos5l_decap_4_107 VSS VDD sg13cmos5l_decap_4
Xsg13cmos5l_decap_8_402 VSS VDD sg13cmos5l_decap_8
Xsg13cmos5l_decap_8_446 VSS VDD sg13cmos5l_decap_8
Xsg13cmos5l_decap_8_413 VSS VDD sg13cmos5l_decap_8
Xsg13cmos5l_decap_8_435 VSS VDD sg13cmos5l_decap_8
Xsg13cmos5l_decap_8_424 VSS VDD sg13cmos5l_decap_8
Xsg13cmos5l_decap_8_457 VSS VDD sg13cmos5l_decap_8
Xsg13cmos5l_decap_8_468 VSS VDD sg13cmos5l_decap_8
Xsg13cmos5l_decap_8_479 VSS VDD sg13cmos5l_decap_8
Xsg13cmos5l_decap_8_3004 VSS VDD sg13cmos5l_decap_8
Xsg13cmos5l_decap_8_3015 VSS VDD sg13cmos5l_decap_8
Xsg13cmos5l_decap_8_3026 VSS VDD sg13cmos5l_decap_8
Xsg13cmos5l_decap_8_3037 VSS VDD sg13cmos5l_decap_8
Xsg13cmos5l_decap_8_2303 VSS VDD sg13cmos5l_decap_8
Xsg13cmos5l_decap_8_3048 VSS VDD sg13cmos5l_decap_8
Xsg13cmos5l_decap_8_3059 VSS VDD sg13cmos5l_decap_8
Xsg13cmos5l_decap_8_2325 VSS VDD sg13cmos5l_decap_8
Xsg13cmos5l_decap_8_2336 VSS VDD sg13cmos5l_decap_8
Xsg13cmos5l_decap_8_2314 VSS VDD sg13cmos5l_decap_8
Xsg13cmos5l_decap_8_2347 VSS VDD sg13cmos5l_decap_8
Xsg13cmos5l_decap_8_2369 VSS VDD sg13cmos5l_decap_8
Xsg13cmos5l_decap_8_2358 VSS VDD sg13cmos5l_decap_8
Xsg13cmos5l_decap_8_1624 VSS VDD sg13cmos5l_decap_8
Xsg13cmos5l_decap_8_1613 VSS VDD sg13cmos5l_decap_8
Xsg13cmos5l_decap_8_1602 VSS VDD sg13cmos5l_decap_8
Xsg13cmos5l_decap_8_1668 VSS VDD sg13cmos5l_decap_8
Xsg13cmos5l_decap_8_1635 VSS VDD sg13cmos5l_decap_8
Xsg13cmos5l_decap_8_1646 VSS VDD sg13cmos5l_decap_8
Xsg13cmos5l_decap_8_1657 VSS VDD sg13cmos5l_decap_8
Xsg13cmos5l_decap_8_1679 VSS VDD sg13cmos5l_decap_8
Xsg13cmos5l_decap_8_991 VSS VDD sg13cmos5l_decap_8
Xsg13cmos5l_decap_8_980 VSS VDD sg13cmos5l_decap_8
Xsg13cmos5l_decap_8_3560 VSS VDD sg13cmos5l_decap_8
Xsg13cmos5l_decap_8_3571 VSS VDD sg13cmos5l_decap_8
Xsg13cmos5l_decap_8_2892 VSS VDD sg13cmos5l_decap_8
Xsg13cmos5l_decap_8_2881 VSS VDD sg13cmos5l_decap_8
Xsg13cmos5l_decap_8_2870 VSS VDD sg13cmos5l_decap_8
Xsg13cmos5l_decap_8_210 VSS VDD sg13cmos5l_decap_8
Xsg13cmos5l_decap_8_221 VSS VDD sg13cmos5l_decap_8
Xsg13cmos5l_decap_8_232 VSS VDD sg13cmos5l_decap_8
Xsg13cmos5l_decap_8_243 VSS VDD sg13cmos5l_decap_8
Xsg13cmos5l_decap_8_254 VSS VDD sg13cmos5l_decap_8
Xsg13cmos5l_decap_8_287 VSS VDD sg13cmos5l_decap_8
Xsg13cmos5l_decap_8_265 VSS VDD sg13cmos5l_decap_8
Xsg13cmos5l_decap_8_276 VSS VDD sg13cmos5l_decap_8
Xsg13cmos5l_decap_8_298 VSS VDD sg13cmos5l_decap_8
Xsg13cmos5l_decap_8_2100 VSS VDD sg13cmos5l_decap_8
Xsg13cmos5l_decap_8_2111 VSS VDD sg13cmos5l_decap_8
Xsg13cmos5l_IOPadIn_1 input_PAD[1] sg13cmos5l_IOPadIn_1/p2c VDD VSS IOVDD IOVDD sg13cmos5l_IOPadIn
Xsg13cmos5l_decap_8_2133 VSS VDD sg13cmos5l_decap_8
Xsg13cmos5l_decap_8_2144 VSS VDD sg13cmos5l_decap_8
Xsg13cmos5l_decap_8_2122 VSS VDD sg13cmos5l_decap_8
Xsg13cmos5l_decap_8_2166 VSS VDD sg13cmos5l_decap_8
Xsg13cmos5l_decap_8_2155 VSS VDD sg13cmos5l_decap_8
Xsg13cmos5l_decap_8_2177 VSS VDD sg13cmos5l_decap_8
Xsg13cmos5l_decap_8_1443 VSS VDD sg13cmos5l_decap_8
Xsg13cmos5l_decap_8_1432 VSS VDD sg13cmos5l_decap_8
Xsg13cmos5l_decap_8_1410 VSS VDD sg13cmos5l_decap_8
Xsg13cmos5l_decap_8_1421 VSS VDD sg13cmos5l_decap_8
Xsg13cmos5l_decap_8_2199 VSS VDD sg13cmos5l_decap_8
Xsg13cmos5l_decap_8_2188 VSS VDD sg13cmos5l_decap_8
Xsg13cmos5l_decap_8_1476 VSS VDD sg13cmos5l_decap_8
Xsg13cmos5l_decap_8_1454 VSS VDD sg13cmos5l_decap_8
Xsg13cmos5l_decap_8_1465 VSS VDD sg13cmos5l_decap_8
Xsg13cmos5l_decap_8_1498 VSS VDD sg13cmos5l_decap_8
Xsg13cmos5l_decap_8_1487 VSS VDD sg13cmos5l_decap_8
Xsg13cmos5l_decap_8_3390 VSS VDD sg13cmos5l_decap_8
Xsg13cmos5l_decap_8_1240 VSS VDD sg13cmos5l_decap_8
Xsg13cmos5l_decap_8_1251 VSS VDD sg13cmos5l_decap_8
Xsg13cmos5l_decap_8_1284 VSS VDD sg13cmos5l_decap_8
Xsg13cmos5l_decap_8_1262 VSS VDD sg13cmos5l_decap_8
Xsg13cmos5l_decap_8_1273 VSS VDD sg13cmos5l_decap_8
Xsg13cmos5l_decap_8_1295 VSS VDD sg13cmos5l_decap_8
Xsg13cmos5l_decap_8_809 VSS VDD sg13cmos5l_decap_8
Xsg13cmos5l_decap_8_1081 VSS VDD sg13cmos5l_decap_8
Xsg13cmos5l_decap_8_1070 VSS VDD sg13cmos5l_decap_8
Xsg13cmos5l_decap_8_1092 VSS VDD sg13cmos5l_decap_8
Xsg13cmos5l_decap_4_40 VSS VDD sg13cmos5l_decap_4
Xsg13cmos5l_decap_4_51 VSS VDD sg13cmos5l_decap_4
Xsg13cmos5l_decap_4_95 VSS VDD sg13cmos5l_decap_4
Xsg13cmos5l_decap_4_84 VSS VDD sg13cmos5l_decap_4
Xsg13cmos5l_decap_4_73 VSS VDD sg13cmos5l_decap_4
Xsg13cmos5l_decap_4_62 VSS VDD sg13cmos5l_decap_4
Xsg13cmos5l_decap_8_617 VSS VDD sg13cmos5l_decap_8
Xsg13cmos5l_decap_8_628 VSS VDD sg13cmos5l_decap_8
Xsg13cmos5l_decap_8_606 VSS VDD sg13cmos5l_decap_8
Xsg13cmos5l_decap_8_639 VSS VDD sg13cmos5l_decap_8
Xsg13cmos5l_decap_8_3219 VSS VDD sg13cmos5l_decap_8
Xsg13cmos5l_decap_8_3208 VSS VDD sg13cmos5l_decap_8
Xsg13cmos5l_decap_8_2507 VSS VDD sg13cmos5l_decap_8
Xsg13cmos5l_decap_8_2518 VSS VDD sg13cmos5l_decap_8
Xsg13cmos5l_decap_8_2529 VSS VDD sg13cmos5l_decap_8
Xsg13cmos5l_decap_8_1817 VSS VDD sg13cmos5l_decap_8
Xsg13cmos5l_decap_8_1806 VSS VDD sg13cmos5l_decap_8
Xsg13cmos5l_decap_8_1828 VSS VDD sg13cmos5l_decap_8
Xsg13cmos5l_decap_8_1839 VSS VDD sg13cmos5l_decap_8
Xsg13cmos5l_decap_4_119 VSS VDD sg13cmos5l_decap_4
Xsg13cmos5l_decap_4_108 VSS VDD sg13cmos5l_decap_4
Xsg13cmos5l_decap_8_403 VSS VDD sg13cmos5l_decap_8
Xsg13cmos5l_decap_8_425 VSS VDD sg13cmos5l_decap_8
Xsg13cmos5l_decap_8_414 VSS VDD sg13cmos5l_decap_8
Xsg13cmos5l_decap_8_436 VSS VDD sg13cmos5l_decap_8
Xsg13cmos5l_decap_8_469 VSS VDD sg13cmos5l_decap_8
Xsg13cmos5l_decap_8_458 VSS VDD sg13cmos5l_decap_8
Xsg13cmos5l_decap_8_447 VSS VDD sg13cmos5l_decap_8
Xsg13cmos5l_decap_8_3005 VSS VDD sg13cmos5l_decap_8
Xsg13cmos5l_decap_8_3016 VSS VDD sg13cmos5l_decap_8
Xsg13cmos5l_decap_8_3027 VSS VDD sg13cmos5l_decap_8
Xsg13cmos5l_decap_8_3038 VSS VDD sg13cmos5l_decap_8
Xsg13cmos5l_decap_8_3049 VSS VDD sg13cmos5l_decap_8
Xsg13cmos5l_decap_8_2326 VSS VDD sg13cmos5l_decap_8
Xsg13cmos5l_decap_8_2304 VSS VDD sg13cmos5l_decap_8
Xsg13cmos5l_decap_8_2315 VSS VDD sg13cmos5l_decap_8
Xsg13cmos5l_decap_8_2348 VSS VDD sg13cmos5l_decap_8
Xsg13cmos5l_decap_8_2359 VSS VDD sg13cmos5l_decap_8
Xsg13cmos5l_decap_8_2337 VSS VDD sg13cmos5l_decap_8
Xsg13cmos5l_decap_8_1625 VSS VDD sg13cmos5l_decap_8
Xsg13cmos5l_decap_8_1603 VSS VDD sg13cmos5l_decap_8
Xsg13cmos5l_decap_8_1614 VSS VDD sg13cmos5l_decap_8
Xsg13cmos5l_decap_8_1636 VSS VDD sg13cmos5l_decap_8
Xsg13cmos5l_decap_8_1647 VSS VDD sg13cmos5l_decap_8
Xsg13cmos5l_decap_8_1658 VSS VDD sg13cmos5l_decap_8
Xsg13cmos5l_decap_8_1669 VSS VDD sg13cmos5l_decap_8
Xsg13cmos5l_decap_8_970 VSS VDD sg13cmos5l_decap_8
Xsg13cmos5l_decap_8_992 VSS VDD sg13cmos5l_decap_8
Xsg13cmos5l_decap_8_981 VSS VDD sg13cmos5l_decap_8
Xsg13cmos5l_decap_8_3550 VSS VDD sg13cmos5l_decap_8
Xsg13cmos5l_decap_8_3572 VSS VDD sg13cmos5l_decap_8
Xsg13cmos5l_decap_8_3561 VSS VDD sg13cmos5l_decap_8
Xsg13cmos5l_decap_8_2882 VSS VDD sg13cmos5l_decap_8
Xsg13cmos5l_decap_8_2871 VSS VDD sg13cmos5l_decap_8
Xsg13cmos5l_decap_8_2860 VSS VDD sg13cmos5l_decap_8
Xsg13cmos5l_decap_8_2893 VSS VDD sg13cmos5l_decap_8
Xsg13cmos5l_decap_8_211 VSS VDD sg13cmos5l_decap_8
Xsg13cmos5l_decap_8_200 VSS VDD sg13cmos5l_decap_8
Xsg13cmos5l_decap_8_233 VSS VDD sg13cmos5l_decap_8
Xsg13cmos5l_decap_8_244 VSS VDD sg13cmos5l_decap_8
Xsg13cmos5l_decap_8_222 VSS VDD sg13cmos5l_decap_8
Xsg13cmos5l_decap_8_288 VSS VDD sg13cmos5l_decap_8
Xsg13cmos5l_decap_8_255 VSS VDD sg13cmos5l_decap_8
Xsg13cmos5l_decap_8_277 VSS VDD sg13cmos5l_decap_8
Xsg13cmos5l_decap_8_266 VSS VDD sg13cmos5l_decap_8
Xsg13cmos5l_decap_8_299 VSS VDD sg13cmos5l_decap_8
Xsg13cmos5l_decap_8_2101 VSS VDD sg13cmos5l_decap_8
Xsg13cmos5l_IOPadIn_2 input_PAD[2] sg13cmos5l_IOPadIn_2/p2c VDD VSS IOVDD IOVDD sg13cmos5l_IOPadIn
Xsg13cmos5l_decap_8_2134 VSS VDD sg13cmos5l_decap_8
Xsg13cmos5l_decap_8_2145 VSS VDD sg13cmos5l_decap_8
Xsg13cmos5l_decap_8_2123 VSS VDD sg13cmos5l_decap_8
Xsg13cmos5l_decap_8_2112 VSS VDD sg13cmos5l_decap_8
Xsg13cmos5l_decap_8_1400 VSS VDD sg13cmos5l_decap_8
Xsg13cmos5l_decap_8_2167 VSS VDD sg13cmos5l_decap_8
Xsg13cmos5l_decap_8_2156 VSS VDD sg13cmos5l_decap_8
Xsg13cmos5l_decap_8_2178 VSS VDD sg13cmos5l_decap_8
Xsg13cmos5l_decap_8_1433 VSS VDD sg13cmos5l_decap_8
Xsg13cmos5l_decap_8_1422 VSS VDD sg13cmos5l_decap_8
Xsg13cmos5l_decap_8_1411 VSS VDD sg13cmos5l_decap_8
Xsg13cmos5l_decap_8_2189 VSS VDD sg13cmos5l_decap_8
Xsg13cmos5l_decap_8_1466 VSS VDD sg13cmos5l_decap_8
Xsg13cmos5l_decap_8_1444 VSS VDD sg13cmos5l_decap_8
Xsg13cmos5l_decap_8_1455 VSS VDD sg13cmos5l_decap_8
Xsg13cmos5l_decap_8_1499 VSS VDD sg13cmos5l_decap_8
Xsg13cmos5l_decap_8_1488 VSS VDD sg13cmos5l_decap_8
Xsg13cmos5l_decap_8_1477 VSS VDD sg13cmos5l_decap_8
Xsg13cmos5l_decap_8_3391 VSS VDD sg13cmos5l_decap_8
Xsg13cmos5l_decap_8_3380 VSS VDD sg13cmos5l_decap_8
Xsg13cmos5l_decap_8_2690 VSS VDD sg13cmos5l_decap_8
Xsg13cmos5l_decap_8_1230 VSS VDD sg13cmos5l_decap_8
Xsg13cmos5l_decap_8_1241 VSS VDD sg13cmos5l_decap_8
Xsg13cmos5l_decap_8_1285 VSS VDD sg13cmos5l_decap_8
Xsg13cmos5l_decap_8_1274 VSS VDD sg13cmos5l_decap_8
Xsg13cmos5l_decap_8_1252 VSS VDD sg13cmos5l_decap_8
Xsg13cmos5l_decap_8_1263 VSS VDD sg13cmos5l_decap_8
Xsg13cmos5l_decap_8_1296 VSS VDD sg13cmos5l_decap_8
Xsg13cmos5l_decap_8_1082 VSS VDD sg13cmos5l_decap_8
Xsg13cmos5l_decap_8_1060 VSS VDD sg13cmos5l_decap_8
Xsg13cmos5l_decap_8_1071 VSS VDD sg13cmos5l_decap_8
Xsg13cmos5l_decap_8_1093 VSS VDD sg13cmos5l_decap_8
Xsg13cmos5l_decap_4_30 VSS VDD sg13cmos5l_decap_4
Xsg13cmos5l_decap_4_41 VSS VDD sg13cmos5l_decap_4
Xsg13cmos5l_decap_4_52 VSS VDD sg13cmos5l_decap_4
Xsg13cmos5l_decap_4_85 VSS VDD sg13cmos5l_decap_4
Xsg13cmos5l_decap_4_74 VSS VDD sg13cmos5l_decap_4
Xsg13cmos5l_decap_4_63 VSS VDD sg13cmos5l_decap_4
Xsg13cmos5l_decap_4_96 VSS VDD sg13cmos5l_decap_4
Xsg13cmos5l_decap_8_618 VSS VDD sg13cmos5l_decap_8
Xsg13cmos5l_decap_8_607 VSS VDD sg13cmos5l_decap_8
Xsg13cmos5l_decap_8_629 VSS VDD sg13cmos5l_decap_8
Xsg13cmos5l_decap_8_3209 VSS VDD sg13cmos5l_decap_8
Xsg13cmos5l_decap_8_2508 VSS VDD sg13cmos5l_decap_8
Xsg13cmos5l_decap_8_2519 VSS VDD sg13cmos5l_decap_8
Xsg13cmos5l_decap_8_1807 VSS VDD sg13cmos5l_decap_8
Xsg13cmos5l_decap_8_1829 VSS VDD sg13cmos5l_decap_8
Xsg13cmos5l_decap_8_1818 VSS VDD sg13cmos5l_decap_8
Xsg13cmos5l_decap_4_109 VSS VDD sg13cmos5l_decap_4
Xsg13cmos5l_decap_8_415 VSS VDD sg13cmos5l_decap_8
Xsg13cmos5l_decap_8_426 VSS VDD sg13cmos5l_decap_8
Xsg13cmos5l_decap_8_437 VSS VDD sg13cmos5l_decap_8
Xsg13cmos5l_decap_8_404 VSS VDD sg13cmos5l_decap_8
Xsg13cmos5l_decap_8_459 VSS VDD sg13cmos5l_decap_8
Xsg13cmos5l_decap_8_448 VSS VDD sg13cmos5l_decap_8
Xsg13cmos5l_decap_8_3006 VSS VDD sg13cmos5l_decap_8
Xsg13cmos5l_decap_8_3017 VSS VDD sg13cmos5l_decap_8
Xsg13cmos5l_decap_8_3028 VSS VDD sg13cmos5l_decap_8
Xsg13cmos5l_decap_8_3039 VSS VDD sg13cmos5l_decap_8
Xsg13cmos5l_decap_8_2327 VSS VDD sg13cmos5l_decap_8
Xsg13cmos5l_decap_8_2305 VSS VDD sg13cmos5l_decap_8
Xsg13cmos5l_decap_8_2316 VSS VDD sg13cmos5l_decap_8
Xsg13cmos5l_decap_8_2349 VSS VDD sg13cmos5l_decap_8
Xsg13cmos5l_decap_8_2338 VSS VDD sg13cmos5l_decap_8
Xsg13cmos5l_decap_8_1615 VSS VDD sg13cmos5l_decap_8
Xsg13cmos5l_decap_8_1604 VSS VDD sg13cmos5l_decap_8
Xsg13cmos5l_decap_8_1626 VSS VDD sg13cmos5l_decap_8
Xsg13cmos5l_decap_8_1637 VSS VDD sg13cmos5l_decap_8
Xsg13cmos5l_decap_8_1659 VSS VDD sg13cmos5l_decap_8
Xsg13cmos5l_decap_8_1648 VSS VDD sg13cmos5l_decap_8
Xsg13cmos5l_decap_8_971 VSS VDD sg13cmos5l_decap_8
Xsg13cmos5l_decap_8_960 VSS VDD sg13cmos5l_decap_8
Xsg13cmos5l_decap_8_982 VSS VDD sg13cmos5l_decap_8
Xsg13cmos5l_decap_8_993 VSS VDD sg13cmos5l_decap_8
Xsg13cmos5l_decap_8_3540 VSS VDD sg13cmos5l_decap_8
Xsg13cmos5l_decap_8_3551 VSS VDD sg13cmos5l_decap_8
Xsg13cmos5l_decap_8_3573 VSS VDD sg13cmos5l_decap_8
Xsg13cmos5l_decap_8_3562 VSS VDD sg13cmos5l_decap_8
Xsg13cmos5l_decap_8_2883 VSS VDD sg13cmos5l_decap_8
Xsg13cmos5l_decap_8_2872 VSS VDD sg13cmos5l_decap_8
Xsg13cmos5l_decap_8_2861 VSS VDD sg13cmos5l_decap_8
Xsg13cmos5l_decap_8_2850 VSS VDD sg13cmos5l_decap_8
Xsg13cmos5l_decap_8_2894 VSS VDD sg13cmos5l_decap_8
Xsg13cmos5l_decap_8_201 VSS VDD sg13cmos5l_decap_8
Xsg13cmos5l_decap_8_212 VSS VDD sg13cmos5l_decap_8
Xsg13cmos5l_decap_8_234 VSS VDD sg13cmos5l_decap_8
Xsg13cmos5l_decap_8_245 VSS VDD sg13cmos5l_decap_8
Xsg13cmos5l_decap_8_223 VSS VDD sg13cmos5l_decap_8
Xsg13cmos5l_decap_8_256 VSS VDD sg13cmos5l_decap_8
Xsg13cmos5l_decap_8_267 VSS VDD sg13cmos5l_decap_8
Xsg13cmos5l_decap_8_278 VSS VDD sg13cmos5l_decap_8
Xsg13cmos5l_decap_8_289 VSS VDD sg13cmos5l_decap_8
Xsg13cmos5l_IOPadIn_3 input_PAD[4] sg13cmos5l_IOPadIn_3/p2c VDD VSS IOVDD IOVDD sg13cmos5l_IOPadIn
Xsg13cmos5l_decap_8_2102 VSS VDD sg13cmos5l_decap_8
Xsg13cmos5l_decap_8_2135 VSS VDD sg13cmos5l_decap_8
Xsg13cmos5l_decap_8_2124 VSS VDD sg13cmos5l_decap_8
Xsg13cmos5l_decap_8_2113 VSS VDD sg13cmos5l_decap_8
Xsg13cmos5l_decap_8_2157 VSS VDD sg13cmos5l_decap_8
Xsg13cmos5l_decap_8_2168 VSS VDD sg13cmos5l_decap_8
Xsg13cmos5l_decap_8_2146 VSS VDD sg13cmos5l_decap_8
Xsg13cmos5l_decap_8_1401 VSS VDD sg13cmos5l_decap_8
Xsg13cmos5l_decap_8_1434 VSS VDD sg13cmos5l_decap_8
Xsg13cmos5l_decap_8_1423 VSS VDD sg13cmos5l_decap_8
Xsg13cmos5l_decap_8_1412 VSS VDD sg13cmos5l_decap_8
Xsg13cmos5l_decap_8_2179 VSS VDD sg13cmos5l_decap_8
Xsg13cmos5l_decap_8_1467 VSS VDD sg13cmos5l_decap_8
Xsg13cmos5l_decap_8_1445 VSS VDD sg13cmos5l_decap_8
Xsg13cmos5l_decap_8_1456 VSS VDD sg13cmos5l_decap_8
Xsg13cmos5l_decap_8_1489 VSS VDD sg13cmos5l_decap_8
Xsg13cmos5l_decap_8_1478 VSS VDD sg13cmos5l_decap_8
Xsg13cmos5l_decap_8_790 VSS VDD sg13cmos5l_decap_8
Xsg13cmos5l_decap_8_3392 VSS VDD sg13cmos5l_decap_8
Xsg13cmos5l_decap_8_3381 VSS VDD sg13cmos5l_decap_8
Xsg13cmos5l_decap_8_3370 VSS VDD sg13cmos5l_decap_8
Xsg13cmos5l_decap_8_2680 VSS VDD sg13cmos5l_decap_8
Xsg13cmos5l_decap_8_2691 VSS VDD sg13cmos5l_decap_8
Xsg13cmos5l_decap_8_1990 VSS VDD sg13cmos5l_decap_8
Xsg13cmos5l_decap_8_1242 VSS VDD sg13cmos5l_decap_8
Xsg13cmos5l_decap_8_1220 VSS VDD sg13cmos5l_decap_8
Xsg13cmos5l_decap_8_1231 VSS VDD sg13cmos5l_decap_8
Xsg13cmos5l_decap_8_1275 VSS VDD sg13cmos5l_decap_8
Xsg13cmos5l_decap_8_1253 VSS VDD sg13cmos5l_decap_8
Xsg13cmos5l_decap_8_1264 VSS VDD sg13cmos5l_decap_8
Xsg13cmos5l_decap_8_1286 VSS VDD sg13cmos5l_decap_8
Xsg13cmos5l_decap_8_1297 VSS VDD sg13cmos5l_decap_8
Xsg13cmos5l_decap_8_1050 VSS VDD sg13cmos5l_decap_8
Xsg13cmos5l_decap_8_1083 VSS VDD sg13cmos5l_decap_8
Xsg13cmos5l_decap_8_1072 VSS VDD sg13cmos5l_decap_8
Xsg13cmos5l_decap_8_1061 VSS VDD sg13cmos5l_decap_8
Xsg13cmos5l_decap_8_1094 VSS VDD sg13cmos5l_decap_8
Xsg13cmos5l_decap_4_20 VSS VDD sg13cmos5l_decap_4
Xsg13cmos5l_decap_4_31 VSS VDD sg13cmos5l_decap_4
Xsg13cmos5l_decap_4_42 VSS VDD sg13cmos5l_decap_4
Xsg13cmos5l_decap_4_86 VSS VDD sg13cmos5l_decap_4
Xsg13cmos5l_decap_4_75 VSS VDD sg13cmos5l_decap_4
Xsg13cmos5l_decap_4_64 VSS VDD sg13cmos5l_decap_4
Xsg13cmos5l_decap_4_53 VSS VDD sg13cmos5l_decap_4
Xsg13cmos5l_decap_4_97 VSS VDD sg13cmos5l_decap_4
Xsg13cmos5l_decap_8_619 VSS VDD sg13cmos5l_decap_8
Xsg13cmos5l_decap_8_608 VSS VDD sg13cmos5l_decap_8
Xsg13cmos5l_decap_8_2509 VSS VDD sg13cmos5l_decap_8
Xsg13cmos5l_decap_8_1808 VSS VDD sg13cmos5l_decap_8
Xsg13cmos5l_decap_8_1819 VSS VDD sg13cmos5l_decap_8
Xsg13cmos5l_decap_8_427 VSS VDD sg13cmos5l_decap_8
Xsg13cmos5l_decap_8_416 VSS VDD sg13cmos5l_decap_8
Xsg13cmos5l_decap_8_405 VSS VDD sg13cmos5l_decap_8
Xsg13cmos5l_decap_8_449 VSS VDD sg13cmos5l_decap_8
Xsg13cmos5l_decap_8_438 VSS VDD sg13cmos5l_decap_8
Xsg13cmos5l_decap_8_3007 VSS VDD sg13cmos5l_decap_8
Xsg13cmos5l_decap_8_3018 VSS VDD sg13cmos5l_decap_8
Xsg13cmos5l_decap_8_3029 VSS VDD sg13cmos5l_decap_8
Xsg13cmos5l_decap_8_2317 VSS VDD sg13cmos5l_decap_8
Xsg13cmos5l_decap_8_2306 VSS VDD sg13cmos5l_decap_8
Xsg13cmos5l_decap_8_2339 VSS VDD sg13cmos5l_decap_8
Xsg13cmos5l_decap_8_2328 VSS VDD sg13cmos5l_decap_8
Xsg13cmos5l_decap_8_1616 VSS VDD sg13cmos5l_decap_8
Xsg13cmos5l_decap_8_1605 VSS VDD sg13cmos5l_decap_8
Xsg13cmos5l_decap_8_1627 VSS VDD sg13cmos5l_decap_8
Xsg13cmos5l_decap_8_1638 VSS VDD sg13cmos5l_decap_8
Xsg13cmos5l_decap_8_1649 VSS VDD sg13cmos5l_decap_8
Xsg13cmos5l_decap_8_950 VSS VDD sg13cmos5l_decap_8
Xsg13cmos5l_decap_8_972 VSS VDD sg13cmos5l_decap_8
Xsg13cmos5l_decap_8_961 VSS VDD sg13cmos5l_decap_8
Xsg13cmos5l_decap_8_983 VSS VDD sg13cmos5l_decap_8
Xsg13cmos5l_decap_8_994 VSS VDD sg13cmos5l_decap_8
Xsg13cmos5l_decap_8_3530 VSS VDD sg13cmos5l_decap_8
Xsg13cmos5l_decap_8_3541 VSS VDD sg13cmos5l_decap_8
Xsg13cmos5l_decap_8_3563 VSS VDD sg13cmos5l_decap_8
Xsg13cmos5l_decap_8_3574 VSS VDD sg13cmos5l_decap_8
Xsg13cmos5l_decap_8_2840 VSS VDD sg13cmos5l_decap_8
Xsg13cmos5l_decap_8_3552 VSS VDD sg13cmos5l_decap_8
Xsg13cmos5l_decap_8_2873 VSS VDD sg13cmos5l_decap_8
Xsg13cmos5l_decap_8_2862 VSS VDD sg13cmos5l_decap_8
Xsg13cmos5l_decap_8_2851 VSS VDD sg13cmos5l_decap_8
Xsg13cmos5l_decap_8_2884 VSS VDD sg13cmos5l_decap_8
Xsg13cmos5l_decap_8_2895 VSS VDD sg13cmos5l_decap_8
Xsg13cmos5l_decap_8_202 VSS VDD sg13cmos5l_decap_8
Xsg13cmos5l_decap_8_235 VSS VDD sg13cmos5l_decap_8
Xsg13cmos5l_decap_8_213 VSS VDD sg13cmos5l_decap_8
Xsg13cmos5l_decap_8_224 VSS VDD sg13cmos5l_decap_8
Xsg13cmos5l_decap_8_257 VSS VDD sg13cmos5l_decap_8
Xsg13cmos5l_decap_8_246 VSS VDD sg13cmos5l_decap_8
Xsg13cmos5l_decap_8_279 VSS VDD sg13cmos5l_decap_8
Xsg13cmos5l_decap_8_268 VSS VDD sg13cmos5l_decap_8
Xsg13cmos5l_IOPadIn_4 clk_PAD sg13cmos5l_IOPadIn_4/p2c VDD VSS IOVDD IOVDD sg13cmos5l_IOPadIn
Xsg13cmos5l_decap_8_2103 VSS VDD sg13cmos5l_decap_8
Xsg13cmos5l_decap_8_2136 VSS VDD sg13cmos5l_decap_8
Xsg13cmos5l_decap_8_2125 VSS VDD sg13cmos5l_decap_8
Xsg13cmos5l_decap_8_2114 VSS VDD sg13cmos5l_decap_8
Xsg13cmos5l_decap_8_2147 VSS VDD sg13cmos5l_decap_8
Xsg13cmos5l_decap_8_2169 VSS VDD sg13cmos5l_decap_8
Xsg13cmos5l_decap_8_2158 VSS VDD sg13cmos5l_decap_8
Xsg13cmos5l_decap_8_1402 VSS VDD sg13cmos5l_decap_8
Xsg13cmos5l_decap_8_1413 VSS VDD sg13cmos5l_decap_8
Xsg13cmos5l_decap_8_1424 VSS VDD sg13cmos5l_decap_8
Xsg13cmos5l_decap_8_1446 VSS VDD sg13cmos5l_decap_8
Xsg13cmos5l_decap_8_1435 VSS VDD sg13cmos5l_decap_8
Xsg13cmos5l_decap_8_1457 VSS VDD sg13cmos5l_decap_8
Xsg13cmos5l_decap_8_1479 VSS VDD sg13cmos5l_decap_8
Xsg13cmos5l_decap_8_1468 VSS VDD sg13cmos5l_decap_8
Xsg13cmos5l_decap_8_780 VSS VDD sg13cmos5l_decap_8
Xsg13cmos5l_decap_8_791 VSS VDD sg13cmos5l_decap_8
Xsg13cmos5l_decap_8_3360 VSS VDD sg13cmos5l_decap_8
Xsg13cmos5l_decap_8_3393 VSS VDD sg13cmos5l_decap_8
Xsg13cmos5l_decap_8_3382 VSS VDD sg13cmos5l_decap_8
Xsg13cmos5l_decap_8_3371 VSS VDD sg13cmos5l_decap_8
Xsg13cmos5l_decap_8_2681 VSS VDD sg13cmos5l_decap_8
Xsg13cmos5l_decap_8_2670 VSS VDD sg13cmos5l_decap_8
Xsg13cmos5l_decap_8_2692 VSS VDD sg13cmos5l_decap_8
Xsg13cmos5l_decap_8_1980 VSS VDD sg13cmos5l_decap_8
Xsg13cmos5l_decap_8_1991 VSS VDD sg13cmos5l_decap_8
Xsg13cmos5l_decap_8_1221 VSS VDD sg13cmos5l_decap_8
Xsg13cmos5l_decap_8_1210 VSS VDD sg13cmos5l_decap_8
Xsg13cmos5l_decap_8_1232 VSS VDD sg13cmos5l_decap_8
Xsg13cmos5l_decap_8_1276 VSS VDD sg13cmos5l_decap_8
Xsg13cmos5l_decap_8_1243 VSS VDD sg13cmos5l_decap_8
Xsg13cmos5l_decap_8_1254 VSS VDD sg13cmos5l_decap_8
Xsg13cmos5l_decap_8_1265 VSS VDD sg13cmos5l_decap_8
Xsg13cmos5l_decap_8_1287 VSS VDD sg13cmos5l_decap_8
Xsg13cmos5l_decap_8_1298 VSS VDD sg13cmos5l_decap_8
Xsg13cmos5l_decap_8_3190 VSS VDD sg13cmos5l_decap_8
Xsg13cmos5l_decap_8_1040 VSS VDD sg13cmos5l_decap_8
Xsg13cmos5l_decap_8_1073 VSS VDD sg13cmos5l_decap_8
Xsg13cmos5l_decap_8_1062 VSS VDD sg13cmos5l_decap_8
Xsg13cmos5l_decap_8_1051 VSS VDD sg13cmos5l_decap_8
Xsg13cmos5l_decap_8_1084 VSS VDD sg13cmos5l_decap_8
Xsg13cmos5l_decap_8_1095 VSS VDD sg13cmos5l_decap_8
Xsg13cmos5l_decap_4_10 VSS VDD sg13cmos5l_decap_4
Xsg13cmos5l_decap_4_21 VSS VDD sg13cmos5l_decap_4
Xsg13cmos5l_decap_4_32 VSS VDD sg13cmos5l_decap_4
Xsg13cmos5l_decap_4_43 VSS VDD sg13cmos5l_decap_4
Xsg13cmos5l_decap_4_76 VSS VDD sg13cmos5l_decap_4
Xsg13cmos5l_decap_4_65 VSS VDD sg13cmos5l_decap_4
Xsg13cmos5l_decap_4_54 VSS VDD sg13cmos5l_decap_4
Xsg13cmos5l_decap_4_98 VSS VDD sg13cmos5l_decap_4
Xsg13cmos5l_decap_4_87 VSS VDD sg13cmos5l_decap_4
Xsg13cmos5l_decap_8_609 VSS VDD sg13cmos5l_decap_8
Xsg13cmos5l_decap_8_1809 VSS VDD sg13cmos5l_decap_8
Xsg13cmos5l_decap_8_417 VSS VDD sg13cmos5l_decap_8
Xsg13cmos5l_decap_8_406 VSS VDD sg13cmos5l_decap_8
Xsg13cmos5l_decap_8_428 VSS VDD sg13cmos5l_decap_8
Xsg13cmos5l_decap_8_439 VSS VDD sg13cmos5l_decap_8
Xsg13cmos5l_IOPadOut30mA_0 output_PAD COMPLETE_PROYECT_FIG_0/dout VSS IOVDD VDD IOVDD
+ VSS IOVDD sg13cmos5l_IOPadOut30mA
Xsg13cmos5l_decap_8_3008 VSS VDD sg13cmos5l_decap_8
Xsg13cmos5l_decap_8_3019 VSS VDD sg13cmos5l_decap_8
Xsg13cmos5l_decap_8_2318 VSS VDD sg13cmos5l_decap_8
Xsg13cmos5l_decap_8_2307 VSS VDD sg13cmos5l_decap_8
Xsg13cmos5l_decap_8_2329 VSS VDD sg13cmos5l_decap_8
Xsg13cmos5l_decap_8_1606 VSS VDD sg13cmos5l_decap_8
Xsg13cmos5l_decap_8_1628 VSS VDD sg13cmos5l_decap_8
Xsg13cmos5l_decap_8_1617 VSS VDD sg13cmos5l_decap_8
Xsg13cmos5l_decap_8_1639 VSS VDD sg13cmos5l_decap_8
Xsg13cmos5l_decap_8_940 VSS VDD sg13cmos5l_decap_8
Xsg13cmos5l_decap_8_962 VSS VDD sg13cmos5l_decap_8
Xsg13cmos5l_decap_8_951 VSS VDD sg13cmos5l_decap_8
Xsg13cmos5l_decap_8_973 VSS VDD sg13cmos5l_decap_8
Xsg13cmos5l_decap_8_984 VSS VDD sg13cmos5l_decap_8
Xsg13cmos5l_decap_8_995 VSS VDD sg13cmos5l_decap_8
Xsg13cmos5l_decap_8_3531 VSS VDD sg13cmos5l_decap_8
Xsg13cmos5l_decap_8_3520 VSS VDD sg13cmos5l_decap_8
Xsg13cmos5l_decap_8_3542 VSS VDD sg13cmos5l_decap_8
Xsg13cmos5l_decap_8_2830 VSS VDD sg13cmos5l_decap_8
Xsg13cmos5l_decap_8_3553 VSS VDD sg13cmos5l_decap_8
Xsg13cmos5l_decap_8_3564 VSS VDD sg13cmos5l_decap_8
Xsg13cmos5l_decap_8_3575 VSS VDD sg13cmos5l_decap_8
Xsg13cmos5l_decap_8_2863 VSS VDD sg13cmos5l_decap_8
Xsg13cmos5l_decap_8_2874 VSS VDD sg13cmos5l_decap_8
Xsg13cmos5l_decap_8_2852 VSS VDD sg13cmos5l_decap_8
Xsg13cmos5l_decap_8_2841 VSS VDD sg13cmos5l_decap_8
Xsg13cmos5l_decap_8_2896 VSS VDD sg13cmos5l_decap_8
Xsg13cmos5l_decap_8_2885 VSS VDD sg13cmos5l_decap_8
Xsg13cmos5l_decap_8_203 VSS VDD sg13cmos5l_decap_8
Xsg13cmos5l_decap_8_236 VSS VDD sg13cmos5l_decap_8
Xsg13cmos5l_decap_8_214 VSS VDD sg13cmos5l_decap_8
Xsg13cmos5l_decap_8_225 VSS VDD sg13cmos5l_decap_8
Xsg13cmos5l_decap_8_258 VSS VDD sg13cmos5l_decap_8
Xsg13cmos5l_decap_8_247 VSS VDD sg13cmos5l_decap_8
Xsg13cmos5l_decap_8_269 VSS VDD sg13cmos5l_decap_8
Xsg13cmos5l_IOPadIn_5 rst_n_PAD sg13cmos5l_IOPadIn_5/p2c VDD VSS IOVDD IOVDD sg13cmos5l_IOPadIn
Xsg13cmos5l_decap_8_2115 VSS VDD sg13cmos5l_decap_8
Xsg13cmos5l_decap_8_2126 VSS VDD sg13cmos5l_decap_8
Xsg13cmos5l_decap_8_2104 VSS VDD sg13cmos5l_decap_8
Xsg13cmos5l_decap_8_2148 VSS VDD sg13cmos5l_decap_8
Xsg13cmos5l_decap_8_2137 VSS VDD sg13cmos5l_decap_8
Xsg13cmos5l_decap_8_2159 VSS VDD sg13cmos5l_decap_8
Xsg13cmos5l_decap_8_1403 VSS VDD sg13cmos5l_decap_8
Xsg13cmos5l_decap_8_1425 VSS VDD sg13cmos5l_decap_8
Xsg13cmos5l_decap_8_1414 VSS VDD sg13cmos5l_decap_8
Xsg13cmos5l_decap_8_1447 VSS VDD sg13cmos5l_decap_8
Xsg13cmos5l_decap_8_1436 VSS VDD sg13cmos5l_decap_8
Xsg13cmos5l_decap_8_1458 VSS VDD sg13cmos5l_decap_8
Xsg13cmos5l_decap_8_1469 VSS VDD sg13cmos5l_decap_8
Xsg13cmos5l_decap_8_781 VSS VDD sg13cmos5l_decap_8
Xsg13cmos5l_decap_8_770 VSS VDD sg13cmos5l_decap_8
Xsg13cmos5l_decap_8_792 VSS VDD sg13cmos5l_decap_8
Xsg13cmos5l_IOPadVss_0 VSS IOVDD VDD IOVDD sg13cmos5l_IOPadVss
Xsg13cmos5l_decap_8_3350 VSS VDD sg13cmos5l_decap_8
Xsg13cmos5l_decap_8_3383 VSS VDD sg13cmos5l_decap_8
Xsg13cmos5l_decap_8_3372 VSS VDD sg13cmos5l_decap_8
Xsg13cmos5l_decap_8_3361 VSS VDD sg13cmos5l_decap_8
Xsg13cmos5l_decap_8_2682 VSS VDD sg13cmos5l_decap_8
Xsg13cmos5l_decap_8_3394 VSS VDD sg13cmos5l_decap_8
Xsg13cmos5l_decap_8_2660 VSS VDD sg13cmos5l_decap_8
Xsg13cmos5l_decap_8_2671 VSS VDD sg13cmos5l_decap_8
Xsg13cmos5l_decap_8_2693 VSS VDD sg13cmos5l_decap_8
Xsg13cmos5l_decap_8_1970 VSS VDD sg13cmos5l_decap_8
Xsg13cmos5l_decap_8_1981 VSS VDD sg13cmos5l_decap_8
Xsg13cmos5l_decap_8_1992 VSS VDD sg13cmos5l_decap_8
Xsg13cmos5l_decap_8_1211 VSS VDD sg13cmos5l_decap_8
Xsg13cmos5l_decap_8_1222 VSS VDD sg13cmos5l_decap_8
Xsg13cmos5l_decap_8_1233 VSS VDD sg13cmos5l_decap_8
Xsg13cmos5l_decap_8_1200 VSS VDD sg13cmos5l_decap_8
Xsg13cmos5l_decap_8_1255 VSS VDD sg13cmos5l_decap_8
Xsg13cmos5l_decap_8_1266 VSS VDD sg13cmos5l_decap_8
Xsg13cmos5l_decap_8_1244 VSS VDD sg13cmos5l_decap_8
Xsg13cmos5l_decap_8_1288 VSS VDD sg13cmos5l_decap_8
Xsg13cmos5l_decap_8_1299 VSS VDD sg13cmos5l_decap_8
Xsg13cmos5l_decap_8_1277 VSS VDD sg13cmos5l_decap_8
Xsg13cmos5l_decap_8_3191 VSS VDD sg13cmos5l_decap_8
Xsg13cmos5l_decap_8_3180 VSS VDD sg13cmos5l_decap_8
Xsg13cmos5l_decap_8_2490 VSS VDD sg13cmos5l_decap_8
Xsg13cmos5l_decap_8_1030 VSS VDD sg13cmos5l_decap_8
Xsg13cmos5l_decap_8_1041 VSS VDD sg13cmos5l_decap_8
Xsg13cmos5l_decap_8_1063 VSS VDD sg13cmos5l_decap_8
Xsg13cmos5l_decap_8_1074 VSS VDD sg13cmos5l_decap_8
Xsg13cmos5l_decap_8_1052 VSS VDD sg13cmos5l_decap_8
Xsg13cmos5l_decap_8_1085 VSS VDD sg13cmos5l_decap_8
Xsg13cmos5l_decap_8_1096 VSS VDD sg13cmos5l_decap_8
Xsg13cmos5l_decap_4_11 VSS VDD sg13cmos5l_decap_4
Xsg13cmos5l_decap_4_22 VSS VDD sg13cmos5l_decap_4
Xsg13cmos5l_decap_4_33 VSS VDD sg13cmos5l_decap_4
Xsg13cmos5l_decap_4_77 VSS VDD sg13cmos5l_decap_4
Xsg13cmos5l_decap_4_66 VSS VDD sg13cmos5l_decap_4
Xsg13cmos5l_decap_4_44 VSS VDD sg13cmos5l_decap_4
Xsg13cmos5l_decap_4_55 VSS VDD sg13cmos5l_decap_4
Xsg13cmos5l_decap_4_88 VSS VDD sg13cmos5l_decap_4
Xsg13cmos5l_decap_4_99 VSS VDD sg13cmos5l_decap_4
Xsg13cmos5l_decap_8_407 VSS VDD sg13cmos5l_decap_8
Xsg13cmos5l_decap_8_418 VSS VDD sg13cmos5l_decap_8
Xsg13cmos5l_decap_8_429 VSS VDD sg13cmos5l_decap_8
Xsg13cmos5l_decap_8_3009 VSS VDD sg13cmos5l_decap_8
Xsg13cmos5l_decap_8_2308 VSS VDD sg13cmos5l_decap_8
Xsg13cmos5l_decap_8_2319 VSS VDD sg13cmos5l_decap_8
Xsg13cmos5l_decap_8_1607 VSS VDD sg13cmos5l_decap_8
Xsg13cmos5l_decap_8_1618 VSS VDD sg13cmos5l_decap_8
Xsg13cmos5l_decap_8_1629 VSS VDD sg13cmos5l_decap_8
Xsg13cmos5l_decap_8_941 VSS VDD sg13cmos5l_decap_8
Xsg13cmos5l_decap_8_930 VSS VDD sg13cmos5l_decap_8
Xsg13cmos5l_decap_8_963 VSS VDD sg13cmos5l_decap_8
Xsg13cmos5l_decap_8_952 VSS VDD sg13cmos5l_decap_8
Xsg13cmos5l_decap_8_974 VSS VDD sg13cmos5l_decap_8
Xsg13cmos5l_decap_8_996 VSS VDD sg13cmos5l_decap_8
Xsg13cmos5l_decap_8_985 VSS VDD sg13cmos5l_decap_8
Xsg13cmos5l_decap_8_3510 VSS VDD sg13cmos5l_decap_8
Xsg13cmos5l_decap_8_3532 VSS VDD sg13cmos5l_decap_8
Xsg13cmos5l_decap_8_3521 VSS VDD sg13cmos5l_decap_8
Xsg13cmos5l_decap_8_3543 VSS VDD sg13cmos5l_decap_8
Xsg13cmos5l_decap_8_3565 VSS VDD sg13cmos5l_decap_8
Xsg13cmos5l_decap_8_2831 VSS VDD sg13cmos5l_decap_8
Xsg13cmos5l_decap_8_2820 VSS VDD sg13cmos5l_decap_8
Xsg13cmos5l_decap_8_3554 VSS VDD sg13cmos5l_decap_8
Xsg13cmos5l_decap_8_3576 VSS VDD sg13cmos5l_decap_8
Xsg13cmos5l_decap_8_2864 VSS VDD sg13cmos5l_decap_8
Xsg13cmos5l_decap_8_2853 VSS VDD sg13cmos5l_decap_8
Xsg13cmos5l_decap_8_2842 VSS VDD sg13cmos5l_decap_8
Xsg13cmos5l_decap_8_2897 VSS VDD sg13cmos5l_decap_8
Xsg13cmos5l_decap_8_2886 VSS VDD sg13cmos5l_decap_8
Xsg13cmos5l_decap_8_2875 VSS VDD sg13cmos5l_decap_8
Xsg13cmos5l_decap_8_204 VSS VDD sg13cmos5l_decap_8
Xsg13cmos5l_decap_8_215 VSS VDD sg13cmos5l_decap_8
Xsg13cmos5l_decap_8_226 VSS VDD sg13cmos5l_decap_8
Xsg13cmos5l_decap_8_259 VSS VDD sg13cmos5l_decap_8
Xsg13cmos5l_decap_8_248 VSS VDD sg13cmos5l_decap_8
Xsg13cmos5l_decap_8_237 VSS VDD sg13cmos5l_decap_8
Xsg13cmos5l_IOPadIn_6 input_PAD[0] sg13cmos5l_IOPadIn_6/p2c VDD VSS IOVDD IOVDD sg13cmos5l_IOPadIn
Xsg13cmos5l_decap_8_2127 VSS VDD sg13cmos5l_decap_8
Xsg13cmos5l_decap_8_2105 VSS VDD sg13cmos5l_decap_8
Xsg13cmos5l_decap_8_2116 VSS VDD sg13cmos5l_decap_8
Xsg13cmos5l_decap_8_2149 VSS VDD sg13cmos5l_decap_8
Xsg13cmos5l_decap_8_2138 VSS VDD sg13cmos5l_decap_8
Xsg13cmos5l_decap_8_1404 VSS VDD sg13cmos5l_decap_8
Xsg13cmos5l_decap_8_1415 VSS VDD sg13cmos5l_decap_8
Xsg13cmos5l_decap_8_1437 VSS VDD sg13cmos5l_decap_8
Xsg13cmos5l_decap_8_1448 VSS VDD sg13cmos5l_decap_8
Xsg13cmos5l_decap_8_1426 VSS VDD sg13cmos5l_decap_8
Xsg13cmos5l_decap_8_1459 VSS VDD sg13cmos5l_decap_8
Xsg13cmos5l_decap_8_782 VSS VDD sg13cmos5l_decap_8
Xsg13cmos5l_decap_8_760 VSS VDD sg13cmos5l_decap_8
Xsg13cmos5l_decap_8_771 VSS VDD sg13cmos5l_decap_8
Xsg13cmos5l_decap_8_793 VSS VDD sg13cmos5l_decap_8
Xsg13cmos5l_IOPadVss_1 VSS IOVDD VDD IOVDD sg13cmos5l_IOPadVss
Xsg13cmos5l_decap_8_3351 VSS VDD sg13cmos5l_decap_8
Xsg13cmos5l_decap_8_3340 VSS VDD sg13cmos5l_decap_8
Xsg13cmos5l_decap_8_3384 VSS VDD sg13cmos5l_decap_8
Xsg13cmos5l_decap_8_3362 VSS VDD sg13cmos5l_decap_8
Xsg13cmos5l_decap_8_3373 VSS VDD sg13cmos5l_decap_8
Xsg13cmos5l_decap_8_3395 VSS VDD sg13cmos5l_decap_8
Xsg13cmos5l_decap_8_2650 VSS VDD sg13cmos5l_decap_8
Xsg13cmos5l_decap_8_2661 VSS VDD sg13cmos5l_decap_8
Xsg13cmos5l_decap_8_2672 VSS VDD sg13cmos5l_decap_8
Xsg13cmos5l_decap_8_2683 VSS VDD sg13cmos5l_decap_8
Xsg13cmos5l_decap_8_2694 VSS VDD sg13cmos5l_decap_8
Xsg13cmos5l_decap_8_1971 VSS VDD sg13cmos5l_decap_8
Xsg13cmos5l_decap_8_1960 VSS VDD sg13cmos5l_decap_8
Xsg13cmos5l_decap_8_1982 VSS VDD sg13cmos5l_decap_8
Xsg13cmos5l_decap_8_1993 VSS VDD sg13cmos5l_decap_8
Xsg13cmos5l_decap_8_1201 VSS VDD sg13cmos5l_decap_8
Xsg13cmos5l_decap_8_1212 VSS VDD sg13cmos5l_decap_8
Xsg13cmos5l_decap_8_1223 VSS VDD sg13cmos5l_decap_8
Xsg13cmos5l_decap_8_1256 VSS VDD sg13cmos5l_decap_8
Xsg13cmos5l_decap_8_1245 VSS VDD sg13cmos5l_decap_8
Xsg13cmos5l_decap_8_1234 VSS VDD sg13cmos5l_decap_8
Xsg13cmos5l_decap_8_1267 VSS VDD sg13cmos5l_decap_8
Xsg13cmos5l_decap_8_1278 VSS VDD sg13cmos5l_decap_8
Xsg13cmos5l_decap_8_1289 VSS VDD sg13cmos5l_decap_8
Xsg13cmos5l_decap_8_590 VSS VDD sg13cmos5l_decap_8
Xsg13cmos5l_decap_8_3192 VSS VDD sg13cmos5l_decap_8
Xsg13cmos5l_decap_8_3181 VSS VDD sg13cmos5l_decap_8
Xsg13cmos5l_decap_8_3170 VSS VDD sg13cmos5l_decap_8
Xsg13cmos5l_decap_8_2491 VSS VDD sg13cmos5l_decap_8
Xsg13cmos5l_decap_8_2480 VSS VDD sg13cmos5l_decap_8
Xsg13cmos5l_decap_8_1790 VSS VDD sg13cmos5l_decap_8
Xsg13cmos5l_decap_8_1031 VSS VDD sg13cmos5l_decap_8
Xsg13cmos5l_decap_8_1020 VSS VDD sg13cmos5l_decap_8
Xsg13cmos5l_decap_8_1064 VSS VDD sg13cmos5l_decap_8
Xsg13cmos5l_decap_8_1053 VSS VDD sg13cmos5l_decap_8
Xsg13cmos5l_decap_8_1075 VSS VDD sg13cmos5l_decap_8
Xsg13cmos5l_decap_8_1042 VSS VDD sg13cmos5l_decap_8
Xsg13cmos5l_decap_8_1086 VSS VDD sg13cmos5l_decap_8
Xsg13cmos5l_decap_8_1097 VSS VDD sg13cmos5l_decap_8
Xsg13cmos5l_decap_4_12 VSS VDD sg13cmos5l_decap_4
Xsg13cmos5l_decap_4_23 VSS VDD sg13cmos5l_decap_4
Xsg13cmos5l_decap_4_34 VSS VDD sg13cmos5l_decap_4
Xsg13cmos5l_decap_4_67 VSS VDD sg13cmos5l_decap_4
Xsg13cmos5l_decap_4_45 VSS VDD sg13cmos5l_decap_4
Xsg13cmos5l_decap_4_56 VSS VDD sg13cmos5l_decap_4
Xsg13cmos5l_decap_4_89 VSS VDD sg13cmos5l_decap_4
Xsg13cmos5l_decap_4_78 VSS VDD sg13cmos5l_decap_4
Xsg13cmos5l_decap_8_408 VSS VDD sg13cmos5l_decap_8
Xsg13cmos5l_decap_8_419 VSS VDD sg13cmos5l_decap_8
Xsg13cmos5l_decap_8_2309 VSS VDD sg13cmos5l_decap_8
Xsg13cmos5l_decap_8_1619 VSS VDD sg13cmos5l_decap_8
Xsg13cmos5l_decap_8_1608 VSS VDD sg13cmos5l_decap_8
Xsg13cmos5l_decap_8_920 VSS VDD sg13cmos5l_decap_8
Xsg13cmos5l_decap_8_931 VSS VDD sg13cmos5l_decap_8
Xsg13cmos5l_decap_8_953 VSS VDD sg13cmos5l_decap_8
Xsg13cmos5l_decap_8_964 VSS VDD sg13cmos5l_decap_8
Xsg13cmos5l_decap_8_942 VSS VDD sg13cmos5l_decap_8
Xsg13cmos5l_decap_8_975 VSS VDD sg13cmos5l_decap_8
Xsg13cmos5l_decap_8_997 VSS VDD sg13cmos5l_decap_8
Xsg13cmos5l_decap_8_986 VSS VDD sg13cmos5l_decap_8
Xsg13cmos5l_decap_8_3500 VSS VDD sg13cmos5l_decap_8
Xsg13cmos5l_decap_8_3511 VSS VDD sg13cmos5l_decap_8
Xsg13cmos5l_decap_8_3522 VSS VDD sg13cmos5l_decap_8
Xsg13cmos5l_decap_8_3533 VSS VDD sg13cmos5l_decap_8
Xsg13cmos5l_decap_8_3544 VSS VDD sg13cmos5l_decap_8
Xsg13cmos5l_decap_8_2821 VSS VDD sg13cmos5l_decap_8
Xsg13cmos5l_decap_8_2810 VSS VDD sg13cmos5l_decap_8
Xsg13cmos5l_decap_8_3555 VSS VDD sg13cmos5l_decap_8
Xsg13cmos5l_decap_8_3566 VSS VDD sg13cmos5l_decap_8
Xsg13cmos5l_decap_8_2865 VSS VDD sg13cmos5l_decap_8
Xsg13cmos5l_decap_8_2854 VSS VDD sg13cmos5l_decap_8
Xsg13cmos5l_decap_8_2832 VSS VDD sg13cmos5l_decap_8
Xsg13cmos5l_decap_8_2843 VSS VDD sg13cmos5l_decap_8
Xsg13cmos5l_decap_8_2887 VSS VDD sg13cmos5l_decap_8
Xsg13cmos5l_decap_8_2898 VSS VDD sg13cmos5l_decap_8
Xsg13cmos5l_decap_8_2876 VSS VDD sg13cmos5l_decap_8
Xsg13cmos5l_decap_8_216 VSS VDD sg13cmos5l_decap_8
Xsg13cmos5l_decap_8_205 VSS VDD sg13cmos5l_decap_8
Xsg13cmos5l_decap_8_227 VSS VDD sg13cmos5l_decap_8
Xsg13cmos5l_decap_8_238 VSS VDD sg13cmos5l_decap_8
Xsg13cmos5l_decap_8_249 VSS VDD sg13cmos5l_decap_8
Xsg13cmos5l_decap_8_2106 VSS VDD sg13cmos5l_decap_8
Xsg13cmos5l_decap_8_2117 VSS VDD sg13cmos5l_decap_8
Xsg13cmos5l_decap_8_2128 VSS VDD sg13cmos5l_decap_8
Xsg13cmos5l_decap_8_2139 VSS VDD sg13cmos5l_decap_8
Xsg13cmos5l_decap_8_1405 VSS VDD sg13cmos5l_decap_8
Xsg13cmos5l_decap_8_1416 VSS VDD sg13cmos5l_decap_8
Xsg13cmos5l_decap_8_1438 VSS VDD sg13cmos5l_decap_8
Xsg13cmos5l_decap_8_1449 VSS VDD sg13cmos5l_decap_8
Xsg13cmos5l_decap_8_1427 VSS VDD sg13cmos5l_decap_8
Xsg13cmos5l_decap_8_750 VSS VDD sg13cmos5l_decap_8
Xsg13cmos5l_decap_8_761 VSS VDD sg13cmos5l_decap_8
Xsg13cmos5l_decap_8_783 VSS VDD sg13cmos5l_decap_8
Xsg13cmos5l_decap_8_772 VSS VDD sg13cmos5l_decap_8
Xsg13cmos5l_decap_8_794 VSS VDD sg13cmos5l_decap_8
Xsg13cmos5l_decap_8_3341 VSS VDD sg13cmos5l_decap_8
Xsg13cmos5l_decap_8_3330 VSS VDD sg13cmos5l_decap_8
Xsg13cmos5l_decap_8_2640 VSS VDD sg13cmos5l_decap_8
Xsg13cmos5l_decap_8_3374 VSS VDD sg13cmos5l_decap_8
Xsg13cmos5l_decap_8_3352 VSS VDD sg13cmos5l_decap_8
Xsg13cmos5l_decap_8_3363 VSS VDD sg13cmos5l_decap_8
Xsg13cmos5l_decap_8_3396 VSS VDD sg13cmos5l_decap_8
Xsg13cmos5l_decap_8_3385 VSS VDD sg13cmos5l_decap_8
Xsg13cmos5l_decap_8_2651 VSS VDD sg13cmos5l_decap_8
Xsg13cmos5l_decap_8_2662 VSS VDD sg13cmos5l_decap_8
Xsg13cmos5l_decap_8_2673 VSS VDD sg13cmos5l_decap_8
Xsg13cmos5l_decap_8_2684 VSS VDD sg13cmos5l_decap_8
Xsg13cmos5l_decap_8_2695 VSS VDD sg13cmos5l_decap_8
Xsg13cmos5l_decap_8_1961 VSS VDD sg13cmos5l_decap_8
Xsg13cmos5l_decap_8_1950 VSS VDD sg13cmos5l_decap_8
Xsg13cmos5l_decap_8_1972 VSS VDD sg13cmos5l_decap_8
Xsg13cmos5l_decap_8_1983 VSS VDD sg13cmos5l_decap_8
Xsg13cmos5l_decap_8_1994 VSS VDD sg13cmos5l_decap_8
Xsg13cmos5l_decap_8_1213 VSS VDD sg13cmos5l_decap_8
Xsg13cmos5l_decap_8_1202 VSS VDD sg13cmos5l_decap_8
Xsg13cmos5l_decap_8_1224 VSS VDD sg13cmos5l_decap_8
Xsg13cmos5l_decap_8_1257 VSS VDD sg13cmos5l_decap_8
Xsg13cmos5l_decap_8_1246 VSS VDD sg13cmos5l_decap_8
Xsg13cmos5l_decap_8_1235 VSS VDD sg13cmos5l_decap_8
Xsg13cmos5l_decap_8_1279 VSS VDD sg13cmos5l_decap_8
Xsg13cmos5l_decap_8_1268 VSS VDD sg13cmos5l_decap_8
Xsg13cmos5l_decap_8_580 VSS VDD sg13cmos5l_decap_8
Xsg13cmos5l_decap_8_591 VSS VDD sg13cmos5l_decap_8
Xsg13cmos5l_decap_8_3160 VSS VDD sg13cmos5l_decap_8
Xsg13cmos5l_decap_8_3182 VSS VDD sg13cmos5l_decap_8
Xsg13cmos5l_decap_8_3193 VSS VDD sg13cmos5l_decap_8
Xsg13cmos5l_decap_8_3171 VSS VDD sg13cmos5l_decap_8
Xsg13cmos5l_decap_8_2470 VSS VDD sg13cmos5l_decap_8
Xsg13cmos5l_decap_8_2481 VSS VDD sg13cmos5l_decap_8
Xsg13cmos5l_decap_8_2492 VSS VDD sg13cmos5l_decap_8
Xsg13cmos5l_decap_8_1780 VSS VDD sg13cmos5l_decap_8
Xsg13cmos5l_decap_8_1791 VSS VDD sg13cmos5l_decap_8
Xsg13cmos5l_decap_8_1032 VSS VDD sg13cmos5l_decap_8
Xsg13cmos5l_decap_8_1021 VSS VDD sg13cmos5l_decap_8
Xsg13cmos5l_decap_8_1010 VSS VDD sg13cmos5l_decap_8
Xsg13cmos5l_decap_8_1065 VSS VDD sg13cmos5l_decap_8
Xsg13cmos5l_decap_8_1054 VSS VDD sg13cmos5l_decap_8
Xsg13cmos5l_decap_8_1043 VSS VDD sg13cmos5l_decap_8
Xsg13cmos5l_decap_8_1076 VSS VDD sg13cmos5l_decap_8
Xsg13cmos5l_decap_8_1087 VSS VDD sg13cmos5l_decap_8
Xsg13cmos5l_decap_8_1098 VSS VDD sg13cmos5l_decap_8
Xsg13cmos5l_decap_4_13 VSS VDD sg13cmos5l_decap_4
Xsg13cmos5l_decap_4_24 VSS VDD sg13cmos5l_decap_4
Xsg13cmos5l_decap_4_68 VSS VDD sg13cmos5l_decap_4
Xsg13cmos5l_decap_4_35 VSS VDD sg13cmos5l_decap_4
Xsg13cmos5l_decap_4_46 VSS VDD sg13cmos5l_decap_4
Xsg13cmos5l_decap_4_57 VSS VDD sg13cmos5l_decap_4
Xsg13cmos5l_decap_4_79 VSS VDD sg13cmos5l_decap_4
Xsg13cmos5l_IOPadVdd_0 VSS IOVDD IOVDD VSS IOVDD VDD sg13cmos5l_IOPadVdd
Xsg13cmos5l_decap_8_409 VSS VDD sg13cmos5l_decap_8
Xsg13cmos5l_decap_8_1609 VSS VDD sg13cmos5l_decap_8
Xsg13cmos5l_decap_8_910 VSS VDD sg13cmos5l_decap_8
Xsg13cmos5l_decap_8_932 VSS VDD sg13cmos5l_decap_8
Xsg13cmos5l_decap_8_921 VSS VDD sg13cmos5l_decap_8
Xsg13cmos5l_decap_8_965 VSS VDD sg13cmos5l_decap_8
Xsg13cmos5l_decap_8_943 VSS VDD sg13cmos5l_decap_8
Xsg13cmos5l_decap_8_954 VSS VDD sg13cmos5l_decap_8
Xsg13cmos5l_decap_8_976 VSS VDD sg13cmos5l_decap_8
Xsg13cmos5l_decap_8_998 VSS VDD sg13cmos5l_decap_8
Xsg13cmos5l_decap_8_987 VSS VDD sg13cmos5l_decap_8
Xsg13cmos5l_decap_8_3501 VSS VDD sg13cmos5l_decap_8
Xsg13cmos5l_decap_8_3512 VSS VDD sg13cmos5l_decap_8
Xsg13cmos5l_decap_8_3523 VSS VDD sg13cmos5l_decap_8
Xsg13cmos5l_decap_8_3534 VSS VDD sg13cmos5l_decap_8
Xsg13cmos5l_decap_8_3545 VSS VDD sg13cmos5l_decap_8
Xsg13cmos5l_decap_8_2800 VSS VDD sg13cmos5l_decap_8
Xsg13cmos5l_decap_8_2822 VSS VDD sg13cmos5l_decap_8
Xsg13cmos5l_decap_8_2811 VSS VDD sg13cmos5l_decap_8
Xsg13cmos5l_decap_8_3556 VSS VDD sg13cmos5l_decap_8
Xsg13cmos5l_decap_8_3567 VSS VDD sg13cmos5l_decap_8
Xsg13cmos5l_decap_8_2855 VSS VDD sg13cmos5l_decap_8
Xsg13cmos5l_decap_8_2844 VSS VDD sg13cmos5l_decap_8
Xsg13cmos5l_decap_8_2833 VSS VDD sg13cmos5l_decap_8
Xsg13cmos5l_decap_8_2888 VSS VDD sg13cmos5l_decap_8
Xsg13cmos5l_decap_8_2877 VSS VDD sg13cmos5l_decap_8
Xsg13cmos5l_decap_8_2866 VSS VDD sg13cmos5l_decap_8
Xsg13cmos5l_decap_8_2899 VSS VDD sg13cmos5l_decap_8
Xsg13cmos5l_decap_8_217 VSS VDD sg13cmos5l_decap_8
Xsg13cmos5l_decap_8_206 VSS VDD sg13cmos5l_decap_8
Xsg13cmos5l_decap_8_239 VSS VDD sg13cmos5l_decap_8
Xsg13cmos5l_decap_8_228 VSS VDD sg13cmos5l_decap_8
Xsg13cmos5l_decap_8_2107 VSS VDD sg13cmos5l_decap_8
Xsg13cmos5l_decap_8_2118 VSS VDD sg13cmos5l_decap_8
Xsg13cmos5l_decap_8_2129 VSS VDD sg13cmos5l_decap_8
Xsg13cmos5l_decap_8_1406 VSS VDD sg13cmos5l_decap_8
Xsg13cmos5l_decap_8_1428 VSS VDD sg13cmos5l_decap_8
Xsg13cmos5l_decap_8_1439 VSS VDD sg13cmos5l_decap_8
Xsg13cmos5l_decap_8_1417 VSS VDD sg13cmos5l_decap_8
Xsg13cmos5l_decap_8_740 VSS VDD sg13cmos5l_decap_8
Xsg13cmos5l_decap_8_751 VSS VDD sg13cmos5l_decap_8
Xsg13cmos5l_decap_8_762 VSS VDD sg13cmos5l_decap_8
Xsg13cmos5l_decap_8_773 VSS VDD sg13cmos5l_decap_8
Xsg13cmos5l_decap_8_784 VSS VDD sg13cmos5l_decap_8
Xsg13cmos5l_decap_8_795 VSS VDD sg13cmos5l_decap_8
Xsg13cmos5l_decap_8_3331 VSS VDD sg13cmos5l_decap_8
Xsg13cmos5l_decap_8_3342 VSS VDD sg13cmos5l_decap_8
Xsg13cmos5l_decap_8_3320 VSS VDD sg13cmos5l_decap_8
Xsg13cmos5l_decap_8_3353 VSS VDD sg13cmos5l_decap_8
Xsg13cmos5l_decap_8_3375 VSS VDD sg13cmos5l_decap_8
Xsg13cmos5l_decap_8_3364 VSS VDD sg13cmos5l_decap_8
Xsg13cmos5l_decap_8_2630 VSS VDD sg13cmos5l_decap_8
Xsg13cmos5l_decap_8_3386 VSS VDD sg13cmos5l_decap_8
Xsg13cmos5l_decap_8_3397 VSS VDD sg13cmos5l_decap_8
Xsg13cmos5l_decap_8_2652 VSS VDD sg13cmos5l_decap_8
Xsg13cmos5l_decap_8_2641 VSS VDD sg13cmos5l_decap_8
Xsg13cmos5l_decap_8_2663 VSS VDD sg13cmos5l_decap_8
Xsg13cmos5l_decap_8_2685 VSS VDD sg13cmos5l_decap_8
Xsg13cmos5l_decap_8_2696 VSS VDD sg13cmos5l_decap_8
Xsg13cmos5l_decap_8_2674 VSS VDD sg13cmos5l_decap_8
Xsg13cmos5l_decap_8_1962 VSS VDD sg13cmos5l_decap_8
Xsg13cmos5l_decap_8_1940 VSS VDD sg13cmos5l_decap_8
Xsg13cmos5l_decap_8_1951 VSS VDD sg13cmos5l_decap_8
Xsg13cmos5l_decap_8_1973 VSS VDD sg13cmos5l_decap_8
Xsg13cmos5l_decap_8_1984 VSS VDD sg13cmos5l_decap_8
Xsg13cmos5l_decap_8_1995 VSS VDD sg13cmos5l_decap_8
Xsg13cmos5l_decap_8_1203 VSS VDD sg13cmos5l_decap_8
Xsg13cmos5l_decap_8_1214 VSS VDD sg13cmos5l_decap_8
Xsg13cmos5l_decap_8_1236 VSS VDD sg13cmos5l_decap_8
Xsg13cmos5l_decap_8_1225 VSS VDD sg13cmos5l_decap_8
Xsg13cmos5l_decap_8_1247 VSS VDD sg13cmos5l_decap_8
Xsg13cmos5l_decap_8_1258 VSS VDD sg13cmos5l_decap_8
Xsg13cmos5l_decap_8_1269 VSS VDD sg13cmos5l_decap_8
Xsg13cmos5l_decap_8_581 VSS VDD sg13cmos5l_decap_8
Xsg13cmos5l_decap_8_570 VSS VDD sg13cmos5l_decap_8
Xsg13cmos5l_decap_8_592 VSS VDD sg13cmos5l_decap_8
Xsg13cmos5l_decap_8_3150 VSS VDD sg13cmos5l_decap_8
Xsg13cmos5l_decap_8_3183 VSS VDD sg13cmos5l_decap_8
Xsg13cmos5l_decap_8_3161 VSS VDD sg13cmos5l_decap_8
Xsg13cmos5l_decap_8_3172 VSS VDD sg13cmos5l_decap_8
Xsg13cmos5l_decap_8_3194 VSS VDD sg13cmos5l_decap_8
Xsg13cmos5l_decap_8_2460 VSS VDD sg13cmos5l_decap_8
Xsg13cmos5l_decap_8_2471 VSS VDD sg13cmos5l_decap_8
Xsg13cmos5l_decap_8_2482 VSS VDD sg13cmos5l_decap_8
Xsg13cmos5l_decap_8_2493 VSS VDD sg13cmos5l_decap_8
Xsg13cmos5l_decap_8_1770 VSS VDD sg13cmos5l_decap_8
Xsg13cmos5l_decap_8_1781 VSS VDD sg13cmos5l_decap_8
Xsg13cmos5l_decap_8_1792 VSS VDD sg13cmos5l_decap_8
Xsg13cmos5l_decap_8_1011 VSS VDD sg13cmos5l_decap_8
Xsg13cmos5l_decap_8_1022 VSS VDD sg13cmos5l_decap_8
Xsg13cmos5l_decap_8_1000 VSS VDD sg13cmos5l_decap_8
Xsg13cmos5l_decap_8_1055 VSS VDD sg13cmos5l_decap_8
Xsg13cmos5l_decap_8_1066 VSS VDD sg13cmos5l_decap_8
Xsg13cmos5l_decap_8_1033 VSS VDD sg13cmos5l_decap_8
Xsg13cmos5l_decap_8_1044 VSS VDD sg13cmos5l_decap_8
Xsg13cmos5l_decap_8_1077 VSS VDD sg13cmos5l_decap_8
Xsg13cmos5l_decap_8_1099 VSS VDD sg13cmos5l_decap_8
Xsg13cmos5l_decap_8_1088 VSS VDD sg13cmos5l_decap_8
Xsg13cmos5l_decap_8_2290 VSS VDD sg13cmos5l_decap_8
Xsg13cmos5l_decap_4_14 VSS VDD sg13cmos5l_decap_4
Xsg13cmos5l_decap_4_25 VSS VDD sg13cmos5l_decap_4
Xsg13cmos5l_decap_4_36 VSS VDD sg13cmos5l_decap_4
Xsg13cmos5l_decap_4_58 VSS VDD sg13cmos5l_decap_4
Xsg13cmos5l_decap_4_47 VSS VDD sg13cmos5l_decap_4
Xsg13cmos5l_decap_4_69 VSS VDD sg13cmos5l_decap_4
Xsg13cmos5l_IOPadVdd_1 VSS IOVDD IOVDD VSS IOVDD VDD sg13cmos5l_IOPadVdd
Xsg13cmos5l_decap_8_900 VSS VDD sg13cmos5l_decap_8
Xsg13cmos5l_decap_8_922 VSS VDD sg13cmos5l_decap_8
Xsg13cmos5l_decap_8_911 VSS VDD sg13cmos5l_decap_8
Xsg13cmos5l_decap_8_955 VSS VDD sg13cmos5l_decap_8
Xsg13cmos5l_decap_8_944 VSS VDD sg13cmos5l_decap_8
Xsg13cmos5l_decap_8_933 VSS VDD sg13cmos5l_decap_8
Xsg13cmos5l_decap_8_966 VSS VDD sg13cmos5l_decap_8
Xsg13cmos5l_decap_8_977 VSS VDD sg13cmos5l_decap_8
Xsg13cmos5l_decap_8_988 VSS VDD sg13cmos5l_decap_8
Xsg13cmos5l_decap_8_999 VSS VDD sg13cmos5l_decap_8
Xsg13cmos5l_decap_8_3502 VSS VDD sg13cmos5l_decap_8
Xsg13cmos5l_decap_8_3513 VSS VDD sg13cmos5l_decap_8
Xsg13cmos5l_decap_8_3524 VSS VDD sg13cmos5l_decap_8
Xsg13cmos5l_decap_8_3535 VSS VDD sg13cmos5l_decap_8
Xsg13cmos5l_decap_8_3546 VSS VDD sg13cmos5l_decap_8
Xsg13cmos5l_decap_8_2801 VSS VDD sg13cmos5l_decap_8
Xsg13cmos5l_decap_8_2812 VSS VDD sg13cmos5l_decap_8
Xsg13cmos5l_decap_8_3557 VSS VDD sg13cmos5l_decap_8
Xsg13cmos5l_decap_8_2856 VSS VDD sg13cmos5l_decap_8
Xsg13cmos5l_decap_8_2845 VSS VDD sg13cmos5l_decap_8
Xsg13cmos5l_decap_8_2834 VSS VDD sg13cmos5l_decap_8
Xsg13cmos5l_decap_8_2823 VSS VDD sg13cmos5l_decap_8
Xsg13cmos5l_decap_8_3568 VSS VDD sg13cmos5l_decap_8
Xsg13cmos5l_decap_8_2889 VSS VDD sg13cmos5l_decap_8
Xsg13cmos5l_decap_8_2878 VSS VDD sg13cmos5l_decap_8
Xsg13cmos5l_decap_8_2867 VSS VDD sg13cmos5l_decap_8
Xsg13cmos5l_decap_8_207 VSS VDD sg13cmos5l_decap_8
Xsg13cmos5l_decap_8_218 VSS VDD sg13cmos5l_decap_8
Xsg13cmos5l_decap_8_229 VSS VDD sg13cmos5l_decap_8
Xsg13cmos5l_decap_8_2108 VSS VDD sg13cmos5l_decap_8
Xsg13cmos5l_decap_8_2119 VSS VDD sg13cmos5l_decap_8
Xsg13cmos5l_decap_8_1407 VSS VDD sg13cmos5l_decap_8
Xsg13cmos5l_decap_8_1429 VSS VDD sg13cmos5l_decap_8
Xsg13cmos5l_decap_8_1418 VSS VDD sg13cmos5l_decap_8
Xsg13cmos5l_decap_8_730 VSS VDD sg13cmos5l_decap_8
Xsg13cmos5l_decap_8_741 VSS VDD sg13cmos5l_decap_8
Xsg13cmos5l_decap_8_752 VSS VDD sg13cmos5l_decap_8
Xsg13cmos5l_decap_8_763 VSS VDD sg13cmos5l_decap_8
Xsg13cmos5l_decap_8_774 VSS VDD sg13cmos5l_decap_8
Xsg13cmos5l_decap_8_785 VSS VDD sg13cmos5l_decap_8
Xsg13cmos5l_decap_8_796 VSS VDD sg13cmos5l_decap_8
Xsg13cmos5l_decap_8_3332 VSS VDD sg13cmos5l_decap_8
Xsg13cmos5l_decap_8_3310 VSS VDD sg13cmos5l_decap_8
Xsg13cmos5l_decap_8_3321 VSS VDD sg13cmos5l_decap_8
Xsg13cmos5l_decap_8_3343 VSS VDD sg13cmos5l_decap_8
Xsg13cmos5l_decap_8_3354 VSS VDD sg13cmos5l_decap_8
Xsg13cmos5l_decap_8_3365 VSS VDD sg13cmos5l_decap_8
Xsg13cmos5l_decap_8_2631 VSS VDD sg13cmos5l_decap_8
Xsg13cmos5l_decap_8_2620 VSS VDD sg13cmos5l_decap_8
Xsg13cmos5l_decap_8_3398 VSS VDD sg13cmos5l_decap_8
Xsg13cmos5l_decap_8_3387 VSS VDD sg13cmos5l_decap_8
Xsg13cmos5l_decap_8_3376 VSS VDD sg13cmos5l_decap_8
Xsg13cmos5l_decap_8_2642 VSS VDD sg13cmos5l_decap_8
Xsg13cmos5l_decap_8_2653 VSS VDD sg13cmos5l_decap_8
Xsg13cmos5l_decap_8_2664 VSS VDD sg13cmos5l_decap_8
Xsg13cmos5l_decap_8_2686 VSS VDD sg13cmos5l_decap_8
Xsg13cmos5l_decap_8_2697 VSS VDD sg13cmos5l_decap_8
Xsg13cmos5l_decap_8_2675 VSS VDD sg13cmos5l_decap_8
Xsg13cmos5l_decap_8_1952 VSS VDD sg13cmos5l_decap_8
Xsg13cmos5l_decap_8_1941 VSS VDD sg13cmos5l_decap_8
Xsg13cmos5l_decap_8_1930 VSS VDD sg13cmos5l_decap_8
Xsg13cmos5l_decap_8_1974 VSS VDD sg13cmos5l_decap_8
Xsg13cmos5l_decap_8_1985 VSS VDD sg13cmos5l_decap_8
Xsg13cmos5l_decap_8_1996 VSS VDD sg13cmos5l_decap_8
Xsg13cmos5l_decap_8_1963 VSS VDD sg13cmos5l_decap_8
Xsg13cmos5l_decap_8_1204 VSS VDD sg13cmos5l_decap_8
Xsg13cmos5l_decap_8_1215 VSS VDD sg13cmos5l_decap_8
Xsg13cmos5l_decap_8_1226 VSS VDD sg13cmos5l_decap_8
Xsg13cmos5l_decap_8_1237 VSS VDD sg13cmos5l_decap_8
Xsg13cmos5l_decap_8_1248 VSS VDD sg13cmos5l_decap_8
Xsg13cmos5l_decap_8_1259 VSS VDD sg13cmos5l_decap_8
Xsg13cmos5l_decap_8_582 VSS VDD sg13cmos5l_decap_8
Xsg13cmos5l_decap_8_560 VSS VDD sg13cmos5l_decap_8
Xsg13cmos5l_decap_8_571 VSS VDD sg13cmos5l_decap_8
Xsg13cmos5l_decap_8_593 VSS VDD sg13cmos5l_decap_8
Xsg13cmos5l_decap_8_3140 VSS VDD sg13cmos5l_decap_8
Xsg13cmos5l_decap_8_3162 VSS VDD sg13cmos5l_decap_8
Xsg13cmos5l_decap_8_3184 VSS VDD sg13cmos5l_decap_8
Xsg13cmos5l_decap_8_3151 VSS VDD sg13cmos5l_decap_8
Xsg13cmos5l_decap_8_3173 VSS VDD sg13cmos5l_decap_8
Xsg13cmos5l_decap_8_3195 VSS VDD sg13cmos5l_decap_8
Xsg13cmos5l_decap_8_2461 VSS VDD sg13cmos5l_decap_8
Xsg13cmos5l_decap_8_2450 VSS VDD sg13cmos5l_decap_8
Xsg13cmos5l_decap_8_2472 VSS VDD sg13cmos5l_decap_8
Xsg13cmos5l_decap_8_2494 VSS VDD sg13cmos5l_decap_8
Xsg13cmos5l_decap_8_2483 VSS VDD sg13cmos5l_decap_8
Xsg13cmos5l_decap_8_1760 VSS VDD sg13cmos5l_decap_8
Xsg13cmos5l_decap_8_1771 VSS VDD sg13cmos5l_decap_8
Xsg13cmos5l_decap_8_1793 VSS VDD sg13cmos5l_decap_8
Xsg13cmos5l_decap_8_1782 VSS VDD sg13cmos5l_decap_8
Xsg13cmos5l_decap_8_1001 VSS VDD sg13cmos5l_decap_8
Xsg13cmos5l_decap_8_1023 VSS VDD sg13cmos5l_decap_8
Xsg13cmos5l_decap_8_1012 VSS VDD sg13cmos5l_decap_8
Xsg13cmos5l_decap_8_1056 VSS VDD sg13cmos5l_decap_8
Xsg13cmos5l_decap_8_1034 VSS VDD sg13cmos5l_decap_8
Xsg13cmos5l_decap_8_1045 VSS VDD sg13cmos5l_decap_8
Xsg13cmos5l_decap_8_1078 VSS VDD sg13cmos5l_decap_8
Xsg13cmos5l_decap_8_1067 VSS VDD sg13cmos5l_decap_8
Xsg13cmos5l_decap_8_1089 VSS VDD sg13cmos5l_decap_8
Xsg13cmos5l_decap_8_390 VSS VDD sg13cmos5l_decap_8
Xsg13cmos5l_decap_8_90 VSS VDD sg13cmos5l_decap_8
Xsg13cmos5l_decap_8_2280 VSS VDD sg13cmos5l_decap_8
Xsg13cmos5l_decap_8_2291 VSS VDD sg13cmos5l_decap_8
Xsg13cmos5l_decap_8_1590 VSS VDD sg13cmos5l_decap_8
Xsg13cmos5l_decap_4_15 VSS VDD sg13cmos5l_decap_4
Xsg13cmos5l_decap_4_59 VSS VDD sg13cmos5l_decap_4
Xsg13cmos5l_decap_4_26 VSS VDD sg13cmos5l_decap_4
Xsg13cmos5l_decap_4_37 VSS VDD sg13cmos5l_decap_4
Xsg13cmos5l_decap_4_48 VSS VDD sg13cmos5l_decap_4
Xsg13cmos5l_IOPadVdd_2 VSS IOVDD IOVDD VSS IOVDD VDD sg13cmos5l_IOPadVdd
Xsg13cmos5l_decap_8_901 VSS VDD sg13cmos5l_decap_8
Xsg13cmos5l_decap_8_923 VSS VDD sg13cmos5l_decap_8
Xsg13cmos5l_decap_8_912 VSS VDD sg13cmos5l_decap_8
Xsg13cmos5l_decap_8_945 VSS VDD sg13cmos5l_decap_8
Xsg13cmos5l_decap_8_956 VSS VDD sg13cmos5l_decap_8
Xsg13cmos5l_decap_8_934 VSS VDD sg13cmos5l_decap_8
Xsg13cmos5l_decap_8_967 VSS VDD sg13cmos5l_decap_8
Xsg13cmos5l_decap_8_989 VSS VDD sg13cmos5l_decap_8
Xsg13cmos5l_decap_8_978 VSS VDD sg13cmos5l_decap_8
Xsg13cmos5l_decap_8_3503 VSS VDD sg13cmos5l_decap_8
Xsg13cmos5l_decap_8_3514 VSS VDD sg13cmos5l_decap_8
Xsg13cmos5l_decap_8_3536 VSS VDD sg13cmos5l_decap_8
Xsg13cmos5l_decap_8_3525 VSS VDD sg13cmos5l_decap_8
Xsg13cmos5l_decap_8_3547 VSS VDD sg13cmos5l_decap_8
Xsg13cmos5l_decap_8_2802 VSS VDD sg13cmos5l_decap_8
Xsg13cmos5l_decap_8_2813 VSS VDD sg13cmos5l_decap_8
Xsg13cmos5l_decap_8_3558 VSS VDD sg13cmos5l_decap_8
Xsg13cmos5l_decap_8_2846 VSS VDD sg13cmos5l_decap_8
Xsg13cmos5l_decap_8_2835 VSS VDD sg13cmos5l_decap_8
Xsg13cmos5l_decap_8_2824 VSS VDD sg13cmos5l_decap_8
Xsg13cmos5l_decap_8_3569 VSS VDD sg13cmos5l_decap_8
Xsg13cmos5l_decap_8_2879 VSS VDD sg13cmos5l_decap_8
Xsg13cmos5l_decap_8_2868 VSS VDD sg13cmos5l_decap_8
Xsg13cmos5l_decap_8_2857 VSS VDD sg13cmos5l_decap_8
Xsg13cmos5l_decap_8_208 VSS VDD sg13cmos5l_decap_8
Xsg13cmos5l_decap_8_219 VSS VDD sg13cmos5l_decap_8
Xsg13cmos5l_decap_8_2109 VSS VDD sg13cmos5l_decap_8
Xsg13cmos5l_decap_8_1408 VSS VDD sg13cmos5l_decap_8
Xsg13cmos5l_decap_8_1419 VSS VDD sg13cmos5l_decap_8
Xsg13cmos5l_decap_8_720 VSS VDD sg13cmos5l_decap_8
Xsg13cmos5l_decap_8_731 VSS VDD sg13cmos5l_decap_8
Xsg13cmos5l_decap_8_753 VSS VDD sg13cmos5l_decap_8
Xsg13cmos5l_decap_8_742 VSS VDD sg13cmos5l_decap_8
Xsg13cmos5l_decap_8_764 VSS VDD sg13cmos5l_decap_8
Xsg13cmos5l_decap_8_786 VSS VDD sg13cmos5l_decap_8
Xsg13cmos5l_decap_8_797 VSS VDD sg13cmos5l_decap_8
Xsg13cmos5l_decap_8_775 VSS VDD sg13cmos5l_decap_8
Xsg13cmos5l_decap_8_3300 VSS VDD sg13cmos5l_decap_8
Xsg13cmos5l_decap_8_3333 VSS VDD sg13cmos5l_decap_8
Xsg13cmos5l_decap_8_3311 VSS VDD sg13cmos5l_decap_8
Xsg13cmos5l_decap_8_3322 VSS VDD sg13cmos5l_decap_8
Xsg13cmos5l_decap_8_3344 VSS VDD sg13cmos5l_decap_8
Xsg13cmos5l_decap_8_3355 VSS VDD sg13cmos5l_decap_8
Xsg13cmos5l_decap_8_3366 VSS VDD sg13cmos5l_decap_8
Xsg13cmos5l_decap_8_2621 VSS VDD sg13cmos5l_decap_8
Xsg13cmos5l_decap_8_2610 VSS VDD sg13cmos5l_decap_8
Xsg13cmos5l_decap_8_3399 VSS VDD sg13cmos5l_decap_8
Xsg13cmos5l_decap_8_3388 VSS VDD sg13cmos5l_decap_8
Xsg13cmos5l_decap_8_3377 VSS VDD sg13cmos5l_decap_8
Xsg13cmos5l_decap_8_2654 VSS VDD sg13cmos5l_decap_8
Xsg13cmos5l_decap_8_2643 VSS VDD sg13cmos5l_decap_8
Xsg13cmos5l_decap_8_2632 VSS VDD sg13cmos5l_decap_8
Xsg13cmos5l_decap_8_1920 VSS VDD sg13cmos5l_decap_8
Xsg13cmos5l_decap_8_2687 VSS VDD sg13cmos5l_decap_8
Xsg13cmos5l_decap_8_2698 VSS VDD sg13cmos5l_decap_8
Xsg13cmos5l_decap_8_2665 VSS VDD sg13cmos5l_decap_8
Xsg13cmos5l_decap_8_2676 VSS VDD sg13cmos5l_decap_8
Xsg13cmos5l_decap_8_1953 VSS VDD sg13cmos5l_decap_8
Xsg13cmos5l_decap_8_1931 VSS VDD sg13cmos5l_decap_8
Xsg13cmos5l_decap_8_1942 VSS VDD sg13cmos5l_decap_8
Xsg13cmos5l_decap_8_1975 VSS VDD sg13cmos5l_decap_8
Xsg13cmos5l_decap_8_1986 VSS VDD sg13cmos5l_decap_8
Xsg13cmos5l_decap_8_1964 VSS VDD sg13cmos5l_decap_8
Xsg13cmos5l_decap_8_1997 VSS VDD sg13cmos5l_decap_8
Xsg13cmos5l_decap_8_1205 VSS VDD sg13cmos5l_decap_8
Xsg13cmos5l_decap_8_1238 VSS VDD sg13cmos5l_decap_8
Xsg13cmos5l_decap_8_1227 VSS VDD sg13cmos5l_decap_8
Xsg13cmos5l_decap_8_1249 VSS VDD sg13cmos5l_decap_8
Xsg13cmos5l_decap_8_1216 VSS VDD sg13cmos5l_decap_8
Xsg13cmos5l_decap_8_550 VSS VDD sg13cmos5l_decap_8
Xsg13cmos5l_decap_8_561 VSS VDD sg13cmos5l_decap_8
Xsg13cmos5l_decap_8_572 VSS VDD sg13cmos5l_decap_8
Xsg13cmos5l_decap_8_583 VSS VDD sg13cmos5l_decap_8
Xsg13cmos5l_decap_8_594 VSS VDD sg13cmos5l_decap_8
Xsg13cmos5l_decap_8_3130 VSS VDD sg13cmos5l_decap_8
Xsg13cmos5l_decap_8_3141 VSS VDD sg13cmos5l_decap_8
Xsg13cmos5l_decap_8_3174 VSS VDD sg13cmos5l_decap_8
Xsg13cmos5l_decap_8_3163 VSS VDD sg13cmos5l_decap_8
Xsg13cmos5l_decap_8_3152 VSS VDD sg13cmos5l_decap_8
Xsg13cmos5l_decap_8_3185 VSS VDD sg13cmos5l_decap_8
Xsg13cmos5l_decap_8_3196 VSS VDD sg13cmos5l_decap_8
Xsg13cmos5l_decap_8_2440 VSS VDD sg13cmos5l_decap_8
Xsg13cmos5l_decap_8_2451 VSS VDD sg13cmos5l_decap_8
Xsg13cmos5l_decap_8_2462 VSS VDD sg13cmos5l_decap_8
Xsg13cmos5l_decap_8_2473 VSS VDD sg13cmos5l_decap_8
Xsg13cmos5l_decap_8_2484 VSS VDD sg13cmos5l_decap_8
Xsg13cmos5l_decap_8_2495 VSS VDD sg13cmos5l_decap_8
Xsg13cmos5l_decap_8_1750 VSS VDD sg13cmos5l_decap_8
Xsg13cmos5l_decap_8_1761 VSS VDD sg13cmos5l_decap_8
Xsg13cmos5l_decap_8_1794 VSS VDD sg13cmos5l_decap_8
Xsg13cmos5l_decap_8_1783 VSS VDD sg13cmos5l_decap_8
Xsg13cmos5l_decap_8_1772 VSS VDD sg13cmos5l_decap_8
Xsg13cmos5l_decap_8_1002 VSS VDD sg13cmos5l_decap_8
Xsg13cmos5l_decap_8_1013 VSS VDD sg13cmos5l_decap_8
Xsg13cmos5l_decap_8_1057 VSS VDD sg13cmos5l_decap_8
Xsg13cmos5l_decap_8_1035 VSS VDD sg13cmos5l_decap_8
Xsg13cmos5l_decap_8_1046 VSS VDD sg13cmos5l_decap_8
Xsg13cmos5l_decap_8_1024 VSS VDD sg13cmos5l_decap_8
Xsg13cmos5l_decap_8_1068 VSS VDD sg13cmos5l_decap_8
Xsg13cmos5l_decap_8_1079 VSS VDD sg13cmos5l_decap_8
Xsg13cmos5l_decap_8_380 VSS VDD sg13cmos5l_decap_8
Xsg13cmos5l_decap_8_391 VSS VDD sg13cmos5l_decap_8
Xsg13cmos5l_decap_8_80 VSS VDD sg13cmos5l_decap_8
Xsg13cmos5l_decap_8_91 VSS VDD sg13cmos5l_decap_8
Xsg13cmos5l_decap_8_2270 VSS VDD sg13cmos5l_decap_8
Xsg13cmos5l_decap_8_2281 VSS VDD sg13cmos5l_decap_8
Xsg13cmos5l_decap_8_2292 VSS VDD sg13cmos5l_decap_8
Xsg13cmos5l_decap_8_1591 VSS VDD sg13cmos5l_decap_8
Xsg13cmos5l_decap_8_1580 VSS VDD sg13cmos5l_decap_8
Xsg13cmos5l_decap_4_16 VSS VDD sg13cmos5l_decap_4
Xsg13cmos5l_decap_4_27 VSS VDD sg13cmos5l_decap_4
Xsg13cmos5l_decap_4_38 VSS VDD sg13cmos5l_decap_4
Xsg13cmos5l_decap_4_49 VSS VDD sg13cmos5l_decap_4
Xsg13cmos5l_decap_8_902 VSS VDD sg13cmos5l_decap_8
Xsg13cmos5l_decap_8_913 VSS VDD sg13cmos5l_decap_8
Xsg13cmos5l_decap_8_946 VSS VDD sg13cmos5l_decap_8
Xsg13cmos5l_decap_8_924 VSS VDD sg13cmos5l_decap_8
Xsg13cmos5l_decap_8_935 VSS VDD sg13cmos5l_decap_8
Xsg13cmos5l_decap_8_968 VSS VDD sg13cmos5l_decap_8
Xsg13cmos5l_decap_8_957 VSS VDD sg13cmos5l_decap_8
Xsg13cmos5l_decap_8_979 VSS VDD sg13cmos5l_decap_8
Xsg13cmos5l_decap_8_3504 VSS VDD sg13cmos5l_decap_8
Xsg13cmos5l_decap_8_3515 VSS VDD sg13cmos5l_decap_8
Xsg13cmos5l_decap_8_3537 VSS VDD sg13cmos5l_decap_8
Xsg13cmos5l_decap_8_3526 VSS VDD sg13cmos5l_decap_8
Xsg13cmos5l_decap_8_2803 VSS VDD sg13cmos5l_decap_8
Xsg13cmos5l_decap_8_3548 VSS VDD sg13cmos5l_decap_8
Xsg13cmos5l_decap_8_2847 VSS VDD sg13cmos5l_decap_8
Xsg13cmos5l_decap_8_2836 VSS VDD sg13cmos5l_decap_8
Xsg13cmos5l_decap_8_2814 VSS VDD sg13cmos5l_decap_8
Xsg13cmos5l_decap_8_2825 VSS VDD sg13cmos5l_decap_8
Xsg13cmos5l_decap_8_3559 VSS VDD sg13cmos5l_decap_8
Xsg13cmos5l_decap_8_2869 VSS VDD sg13cmos5l_decap_8
Xsg13cmos5l_decap_8_2858 VSS VDD sg13cmos5l_decap_8
Xsg13cmos5l_decap_8_209 VSS VDD sg13cmos5l_decap_8
Xsg13cmos5l_decap_8_1409 VSS VDD sg13cmos5l_decap_8
Xsg13cmos5l_decap_8_710 VSS VDD sg13cmos5l_decap_8
Xsg13cmos5l_decap_8_721 VSS VDD sg13cmos5l_decap_8
Xsg13cmos5l_decap_8_743 VSS VDD sg13cmos5l_decap_8
Xsg13cmos5l_decap_8_754 VSS VDD sg13cmos5l_decap_8
Xsg13cmos5l_decap_8_732 VSS VDD sg13cmos5l_decap_8
Xsg13cmos5l_decap_8_765 VSS VDD sg13cmos5l_decap_8
Xsg13cmos5l_decap_8_787 VSS VDD sg13cmos5l_decap_8
Xsg13cmos5l_decap_8_776 VSS VDD sg13cmos5l_decap_8
Xsg13cmos5l_decap_8_798 VSS VDD sg13cmos5l_decap_8
Xsg13cmos5l_decap_8_3301 VSS VDD sg13cmos5l_decap_8
Xsg13cmos5l_decap_8_3312 VSS VDD sg13cmos5l_decap_8
Xsg13cmos5l_decap_8_3323 VSS VDD sg13cmos5l_decap_8
Xsg13cmos5l_decap_8_3345 VSS VDD sg13cmos5l_decap_8
Xsg13cmos5l_decap_8_3334 VSS VDD sg13cmos5l_decap_8
Xsg13cmos5l_decap_8_3356 VSS VDD sg13cmos5l_decap_8
Xsg13cmos5l_decap_8_2600 VSS VDD sg13cmos5l_decap_8
Xsg13cmos5l_decap_8_2622 VSS VDD sg13cmos5l_decap_8
Xsg13cmos5l_decap_8_2611 VSS VDD sg13cmos5l_decap_8
Xsg13cmos5l_decap_8_2644 VSS VDD sg13cmos5l_decap_8
Xsg13cmos5l_decap_8_3389 VSS VDD sg13cmos5l_decap_8
Xsg13cmos5l_decap_8_3378 VSS VDD sg13cmos5l_decap_8
Xsg13cmos5l_decap_8_3367 VSS VDD sg13cmos5l_decap_8
Xsg13cmos5l_decap_8_2655 VSS VDD sg13cmos5l_decap_8
Xsg13cmos5l_decap_8_2633 VSS VDD sg13cmos5l_decap_8
Xsg13cmos5l_decap_8_1910 VSS VDD sg13cmos5l_decap_8
Xsg13cmos5l_decap_8_2688 VSS VDD sg13cmos5l_decap_8
Xsg13cmos5l_decap_8_2666 VSS VDD sg13cmos5l_decap_8
Xsg13cmos5l_decap_8_2677 VSS VDD sg13cmos5l_decap_8
Xsg13cmos5l_decap_8_1921 VSS VDD sg13cmos5l_decap_8
Xsg13cmos5l_decap_8_1943 VSS VDD sg13cmos5l_decap_8
Xsg13cmos5l_decap_8_1932 VSS VDD sg13cmos5l_decap_8
Xsg13cmos5l_decap_8_2699 VSS VDD sg13cmos5l_decap_8
Xsg13cmos5l_decap_8_1976 VSS VDD sg13cmos5l_decap_8
Xsg13cmos5l_decap_8_1987 VSS VDD sg13cmos5l_decap_8
Xsg13cmos5l_decap_8_1954 VSS VDD sg13cmos5l_decap_8
Xsg13cmos5l_decap_8_1965 VSS VDD sg13cmos5l_decap_8
Xsg13cmos5l_decap_8_1998 VSS VDD sg13cmos5l_decap_8
Xsg13cmos5l_decap_8_1206 VSS VDD sg13cmos5l_decap_8
Xsg13cmos5l_decap_8_1217 VSS VDD sg13cmos5l_decap_8
Xsg13cmos5l_decap_8_1228 VSS VDD sg13cmos5l_decap_8
Xsg13cmos5l_decap_8_1239 VSS VDD sg13cmos5l_decap_8
Xsg13cmos5l_decap_8_540 VSS VDD sg13cmos5l_decap_8
Xsg13cmos5l_decap_8_551 VSS VDD sg13cmos5l_decap_8
Xsg13cmos5l_decap_8_562 VSS VDD sg13cmos5l_decap_8
Xsg13cmos5l_decap_8_573 VSS VDD sg13cmos5l_decap_8
Xsg13cmos5l_decap_8_584 VSS VDD sg13cmos5l_decap_8
Xsg13cmos5l_decap_8_595 VSS VDD sg13cmos5l_decap_8
Xsg13cmos5l_decap_8_3131 VSS VDD sg13cmos5l_decap_8
Xsg13cmos5l_decap_8_3120 VSS VDD sg13cmos5l_decap_8
Xsg13cmos5l_decap_8_3164 VSS VDD sg13cmos5l_decap_8
Xsg13cmos5l_decap_8_3142 VSS VDD sg13cmos5l_decap_8
Xsg13cmos5l_decap_8_3153 VSS VDD sg13cmos5l_decap_8
Xsg13cmos5l_decap_8_2430 VSS VDD sg13cmos5l_decap_8
Xsg13cmos5l_decap_8_3175 VSS VDD sg13cmos5l_decap_8
Xsg13cmos5l_decap_8_3197 VSS VDD sg13cmos5l_decap_8
Xsg13cmos5l_decap_8_3186 VSS VDD sg13cmos5l_decap_8
Xsg13cmos5l_decap_8_2441 VSS VDD sg13cmos5l_decap_8
Xsg13cmos5l_decap_8_2452 VSS VDD sg13cmos5l_decap_8
Xsg13cmos5l_decap_8_2463 VSS VDD sg13cmos5l_decap_8
Xsg13cmos5l_decap_8_2474 VSS VDD sg13cmos5l_decap_8
Xsg13cmos5l_decap_8_2485 VSS VDD sg13cmos5l_decap_8
Xsg13cmos5l_decap_8_2496 VSS VDD sg13cmos5l_decap_8
Xsg13cmos5l_decap_8_1740 VSS VDD sg13cmos5l_decap_8
Xsg13cmos5l_decap_8_1751 VSS VDD sg13cmos5l_decap_8
Xsg13cmos5l_decap_8_1762 VSS VDD sg13cmos5l_decap_8
Xsg13cmos5l_decap_8_1795 VSS VDD sg13cmos5l_decap_8
Xsg13cmos5l_decap_8_1784 VSS VDD sg13cmos5l_decap_8
Xsg13cmos5l_decap_8_1773 VSS VDD sg13cmos5l_decap_8
Xsg13cmos5l_decap_8_1003 VSS VDD sg13cmos5l_decap_8
Xsg13cmos5l_decap_8_1014 VSS VDD sg13cmos5l_decap_8
Xsg13cmos5l_decap_8_1047 VSS VDD sg13cmos5l_decap_8
Xsg13cmos5l_decap_8_1036 VSS VDD sg13cmos5l_decap_8
Xsg13cmos5l_decap_8_1025 VSS VDD sg13cmos5l_decap_8
Xsg13cmos5l_decap_8_1069 VSS VDD sg13cmos5l_decap_8
Xsg13cmos5l_decap_8_1058 VSS VDD sg13cmos5l_decap_8
Xsg13cmos5l_decap_8_381 VSS VDD sg13cmos5l_decap_8
Xsg13cmos5l_decap_8_370 VSS VDD sg13cmos5l_decap_8
Xsg13cmos5l_decap_8_392 VSS VDD sg13cmos5l_decap_8
Xsg13cmos5l_decap_8_70 VSS VDD sg13cmos5l_decap_8
Xsg13cmos5l_decap_8_81 VSS VDD sg13cmos5l_decap_8
Xsg13cmos5l_decap_8_92 VSS VDD sg13cmos5l_decap_8
Xsg13cmos5l_decap_8_2271 VSS VDD sg13cmos5l_decap_8
Xsg13cmos5l_decap_8_2260 VSS VDD sg13cmos5l_decap_8
Xsg13cmos5l_decap_8_2293 VSS VDD sg13cmos5l_decap_8
Xsg13cmos5l_decap_8_2282 VSS VDD sg13cmos5l_decap_8
Xsg13cmos5l_decap_8_1570 VSS VDD sg13cmos5l_decap_8
Xsg13cmos5l_decap_8_1592 VSS VDD sg13cmos5l_decap_8
Xsg13cmos5l_decap_8_1581 VSS VDD sg13cmos5l_decap_8
Xsg13cmos5l_decap_4_17 VSS VDD sg13cmos5l_decap_4
Xsg13cmos5l_decap_4_28 VSS VDD sg13cmos5l_decap_4
Xsg13cmos5l_decap_4_39 VSS VDD sg13cmos5l_decap_4
Xsg13cmos5l_decap_8_2090 VSS VDD sg13cmos5l_decap_8
Xsg13cmos5l_decap_8_903 VSS VDD sg13cmos5l_decap_8
Xsg13cmos5l_decap_8_914 VSS VDD sg13cmos5l_decap_8
Xsg13cmos5l_decap_8_936 VSS VDD sg13cmos5l_decap_8
Xsg13cmos5l_decap_8_947 VSS VDD sg13cmos5l_decap_8
Xsg13cmos5l_decap_8_925 VSS VDD sg13cmos5l_decap_8
Xsg13cmos5l_decap_8_969 VSS VDD sg13cmos5l_decap_8
Xsg13cmos5l_decap_8_958 VSS VDD sg13cmos5l_decap_8
Xsg13cmos5l_decap_8_3505 VSS VDD sg13cmos5l_decap_8
Xsg13cmos5l_decap_8_3516 VSS VDD sg13cmos5l_decap_8
Xsg13cmos5l_decap_8_3527 VSS VDD sg13cmos5l_decap_8
Xsg13cmos5l_decap_8_3538 VSS VDD sg13cmos5l_decap_8
Xsg13cmos5l_decap_8_3549 VSS VDD sg13cmos5l_decap_8
Xsg13cmos5l_decap_8_2804 VSS VDD sg13cmos5l_decap_8
Xsg13cmos5l_decap_8_2826 VSS VDD sg13cmos5l_decap_8
Xsg13cmos5l_decap_8_2837 VSS VDD sg13cmos5l_decap_8
Xsg13cmos5l_decap_8_2815 VSS VDD sg13cmos5l_decap_8
Xsg13cmos5l_decap_8_2859 VSS VDD sg13cmos5l_decap_8
Xsg13cmos5l_decap_8_2848 VSS VDD sg13cmos5l_decap_8
Xsg13cmos5l_decap_8_711 VSS VDD sg13cmos5l_decap_8
Xsg13cmos5l_decap_8_722 VSS VDD sg13cmos5l_decap_8
Xsg13cmos5l_decap_8_700 VSS VDD sg13cmos5l_decap_8
Xsg13cmos5l_decap_8_744 VSS VDD sg13cmos5l_decap_8
Xsg13cmos5l_decap_8_755 VSS VDD sg13cmos5l_decap_8
Xsg13cmos5l_decap_8_733 VSS VDD sg13cmos5l_decap_8
Xsg13cmos5l_decap_8_766 VSS VDD sg13cmos5l_decap_8
Xsg13cmos5l_decap_8_777 VSS VDD sg13cmos5l_decap_8
Xsg13cmos5l_decap_8_788 VSS VDD sg13cmos5l_decap_8
Xsg13cmos5l_decap_8_799 VSS VDD sg13cmos5l_decap_8
Xsg13cmos5l_decap_8_3302 VSS VDD sg13cmos5l_decap_8
Xsg13cmos5l_decap_8_3324 VSS VDD sg13cmos5l_decap_8
Xsg13cmos5l_decap_8_3313 VSS VDD sg13cmos5l_decap_8
Xsg13cmos5l_decap_8_3357 VSS VDD sg13cmos5l_decap_8
Xsg13cmos5l_decap_8_3335 VSS VDD sg13cmos5l_decap_8
Xsg13cmos5l_decap_8_3346 VSS VDD sg13cmos5l_decap_8
Xsg13cmos5l_decap_8_2601 VSS VDD sg13cmos5l_decap_8
Xsg13cmos5l_decap_8_2612 VSS VDD sg13cmos5l_decap_8
Xsg13cmos5l_decap_8_3379 VSS VDD sg13cmos5l_decap_8
Xsg13cmos5l_decap_8_3368 VSS VDD sg13cmos5l_decap_8
Xsg13cmos5l_decap_8_2645 VSS VDD sg13cmos5l_decap_8
Xsg13cmos5l_decap_8_2634 VSS VDD sg13cmos5l_decap_8
Xsg13cmos5l_decap_8_2623 VSS VDD sg13cmos5l_decap_8
Xsg13cmos5l_decap_8_1900 VSS VDD sg13cmos5l_decap_8
Xsg13cmos5l_decap_8_1911 VSS VDD sg13cmos5l_decap_8
Xsg13cmos5l_decap_8_2678 VSS VDD sg13cmos5l_decap_8
Xsg13cmos5l_decap_8_2689 VSS VDD sg13cmos5l_decap_8
Xsg13cmos5l_decap_8_2667 VSS VDD sg13cmos5l_decap_8
Xsg13cmos5l_decap_8_2656 VSS VDD sg13cmos5l_decap_8
Xsg13cmos5l_decap_8_1944 VSS VDD sg13cmos5l_decap_8
Xsg13cmos5l_decap_8_1922 VSS VDD sg13cmos5l_decap_8
Xsg13cmos5l_decap_8_1933 VSS VDD sg13cmos5l_decap_8
Xsg13cmos5l_decap_8_1977 VSS VDD sg13cmos5l_decap_8
Xsg13cmos5l_decap_8_1966 VSS VDD sg13cmos5l_decap_8
Xsg13cmos5l_decap_8_1955 VSS VDD sg13cmos5l_decap_8
Xsg13cmos5l_decap_8_1988 VSS VDD sg13cmos5l_decap_8
Xsg13cmos5l_decap_8_1999 VSS VDD sg13cmos5l_decap_8
Xsg13cmos5l_decap_8_1207 VSS VDD sg13cmos5l_decap_8
Xsg13cmos5l_decap_8_1218 VSS VDD sg13cmos5l_decap_8
Xsg13cmos5l_decap_8_1229 VSS VDD sg13cmos5l_decap_8
Xsg13cmos5l_decap_8_530 VSS VDD sg13cmos5l_decap_8
Xsg13cmos5l_decap_8_552 VSS VDD sg13cmos5l_decap_8
Xsg13cmos5l_decap_8_541 VSS VDD sg13cmos5l_decap_8
Xsg13cmos5l_decap_8_563 VSS VDD sg13cmos5l_decap_8
Xsg13cmos5l_decap_8_596 VSS VDD sg13cmos5l_decap_8
Xsg13cmos5l_decap_8_585 VSS VDD sg13cmos5l_decap_8
Xsg13cmos5l_decap_8_574 VSS VDD sg13cmos5l_decap_8
Xsg13cmos5l_decap_8_3121 VSS VDD sg13cmos5l_decap_8
Xsg13cmos5l_decap_8_3110 VSS VDD sg13cmos5l_decap_8
Xsg13cmos5l_decap_8_3132 VSS VDD sg13cmos5l_decap_8
Xsg13cmos5l_decap_8_3165 VSS VDD sg13cmos5l_decap_8
Xsg13cmos5l_decap_8_3143 VSS VDD sg13cmos5l_decap_8
Xsg13cmos5l_decap_8_3154 VSS VDD sg13cmos5l_decap_8
Xsg13cmos5l_decap_8_2420 VSS VDD sg13cmos5l_decap_8
Xsg13cmos5l_decap_8_3198 VSS VDD sg13cmos5l_decap_8
Xsg13cmos5l_decap_8_3187 VSS VDD sg13cmos5l_decap_8
Xsg13cmos5l_decap_8_2442 VSS VDD sg13cmos5l_decap_8
Xsg13cmos5l_decap_8_3176 VSS VDD sg13cmos5l_decap_8
Xsg13cmos5l_decap_8_2431 VSS VDD sg13cmos5l_decap_8
Xsg13cmos5l_decap_8_2453 VSS VDD sg13cmos5l_decap_8
Xsg13cmos5l_decap_8_2464 VSS VDD sg13cmos5l_decap_8
Xsg13cmos5l_decap_8_2475 VSS VDD sg13cmos5l_decap_8
Xsg13cmos5l_decap_8_2486 VSS VDD sg13cmos5l_decap_8
Xsg13cmos5l_decap_8_2497 VSS VDD sg13cmos5l_decap_8
Xsg13cmos5l_decap_8_1752 VSS VDD sg13cmos5l_decap_8
Xsg13cmos5l_decap_8_1741 VSS VDD sg13cmos5l_decap_8
Xsg13cmos5l_decap_8_1730 VSS VDD sg13cmos5l_decap_8
Xsg13cmos5l_decap_8_1785 VSS VDD sg13cmos5l_decap_8
Xsg13cmos5l_decap_8_1774 VSS VDD sg13cmos5l_decap_8
Xsg13cmos5l_decap_8_1763 VSS VDD sg13cmos5l_decap_8
Xsg13cmos5l_decap_8_1796 VSS VDD sg13cmos5l_decap_8
Xsg13cmos5l_decap_8_1004 VSS VDD sg13cmos5l_decap_8
Xsg13cmos5l_decap_8_1048 VSS VDD sg13cmos5l_decap_8
Xsg13cmos5l_decap_8_1026 VSS VDD sg13cmos5l_decap_8
Xsg13cmos5l_decap_8_1037 VSS VDD sg13cmos5l_decap_8
Xsg13cmos5l_decap_8_1015 VSS VDD sg13cmos5l_decap_8
Xsg13cmos5l_decap_8_1059 VSS VDD sg13cmos5l_decap_8
Xsg13cmos5l_decap_8_360 VSS VDD sg13cmos5l_decap_8
Xsg13cmos5l_decap_8_371 VSS VDD sg13cmos5l_decap_8
Xsg13cmos5l_decap_8_382 VSS VDD sg13cmos5l_decap_8
Xsg13cmos5l_decap_8_393 VSS VDD sg13cmos5l_decap_8
Xsg13cmos5l_decap_8_60 VSS VDD sg13cmos5l_decap_8
Xsg13cmos5l_decap_8_71 VSS VDD sg13cmos5l_decap_8
Xsg13cmos5l_decap_8_93 VSS VDD sg13cmos5l_decap_8
Xsg13cmos5l_decap_8_82 VSS VDD sg13cmos5l_decap_8
Xsg13cmos5l_decap_8_2261 VSS VDD sg13cmos5l_decap_8
Xsg13cmos5l_decap_8_2272 VSS VDD sg13cmos5l_decap_8
Xsg13cmos5l_decap_8_2250 VSS VDD sg13cmos5l_decap_8
Xsg13cmos5l_decap_8_2294 VSS VDD sg13cmos5l_decap_8
Xsg13cmos5l_decap_8_2283 VSS VDD sg13cmos5l_decap_8
Xsg13cmos5l_decap_8_1560 VSS VDD sg13cmos5l_decap_8
Xsg13cmos5l_decap_8_1571 VSS VDD sg13cmos5l_decap_8
Xsg13cmos5l_decap_8_1582 VSS VDD sg13cmos5l_decap_8
Xsg13cmos5l_decap_8_1593 VSS VDD sg13cmos5l_decap_8
Xsg13cmos5l_decap_4_18 VSS VDD sg13cmos5l_decap_4
Xsg13cmos5l_decap_4_29 VSS VDD sg13cmos5l_decap_4
Xsg13cmos5l_decap_8_190 VSS VDD sg13cmos5l_decap_8
Xsg13cmos5l_decap_8_2080 VSS VDD sg13cmos5l_decap_8
Xsg13cmos5l_decap_8_2091 VSS VDD sg13cmos5l_decap_8
Xsg13cmos5l_decap_8_1390 VSS VDD sg13cmos5l_decap_8
Xsg13cmos5l_decap_8_904 VSS VDD sg13cmos5l_decap_8
Xsg13cmos5l_decap_8_937 VSS VDD sg13cmos5l_decap_8
Xsg13cmos5l_decap_8_926 VSS VDD sg13cmos5l_decap_8
Xsg13cmos5l_decap_8_915 VSS VDD sg13cmos5l_decap_8
Xsg13cmos5l_decap_8_948 VSS VDD sg13cmos5l_decap_8
Xsg13cmos5l_decap_8_959 VSS VDD sg13cmos5l_decap_8
Xsg13cmos5l_decap_8_3506 VSS VDD sg13cmos5l_decap_8
Xsg13cmos5l_decap_8_3517 VSS VDD sg13cmos5l_decap_8
Xsg13cmos5l_decap_8_3528 VSS VDD sg13cmos5l_decap_8
Xsg13cmos5l_decap_8_3539 VSS VDD sg13cmos5l_decap_8
Xsg13cmos5l_decap_8_2805 VSS VDD sg13cmos5l_decap_8
Xsg13cmos5l_decap_8_2827 VSS VDD sg13cmos5l_decap_8
Xsg13cmos5l_decap_8_2838 VSS VDD sg13cmos5l_decap_8
Xsg13cmos5l_decap_8_2816 VSS VDD sg13cmos5l_decap_8
Xsg13cmos5l_decap_8_2849 VSS VDD sg13cmos5l_decap_8
Xsg13cmos5l_decap_8_712 VSS VDD sg13cmos5l_decap_8
Xsg13cmos5l_decap_8_701 VSS VDD sg13cmos5l_decap_8
Xsg13cmos5l_decap_8_723 VSS VDD sg13cmos5l_decap_8
Xsg13cmos5l_decap_8_756 VSS VDD sg13cmos5l_decap_8
Xsg13cmos5l_decap_8_745 VSS VDD sg13cmos5l_decap_8
Xsg13cmos5l_decap_8_734 VSS VDD sg13cmos5l_decap_8
Xsg13cmos5l_decap_8_767 VSS VDD sg13cmos5l_decap_8
Xsg13cmos5l_decap_8_778 VSS VDD sg13cmos5l_decap_8
Xsg13cmos5l_decap_8_789 VSS VDD sg13cmos5l_decap_8
Xsg13cmos5l_decap_8_3303 VSS VDD sg13cmos5l_decap_8
Xsg13cmos5l_decap_8_3314 VSS VDD sg13cmos5l_decap_8
Xsg13cmos5l_decap_8_3336 VSS VDD sg13cmos5l_decap_8
Xsg13cmos5l_decap_8_3325 VSS VDD sg13cmos5l_decap_8
Xsg13cmos5l_decap_8_3347 VSS VDD sg13cmos5l_decap_8
Xsg13cmos5l_decap_8_2602 VSS VDD sg13cmos5l_decap_8
Xsg13cmos5l_decap_8_2613 VSS VDD sg13cmos5l_decap_8
Xsg13cmos5l_decap_8_3358 VSS VDD sg13cmos5l_decap_8
Xsg13cmos5l_decap_8_3369 VSS VDD sg13cmos5l_decap_8
Xsg13cmos5l_decap_8_2646 VSS VDD sg13cmos5l_decap_8
Xsg13cmos5l_decap_8_2635 VSS VDD sg13cmos5l_decap_8
Xsg13cmos5l_decap_8_2624 VSS VDD sg13cmos5l_decap_8
Xsg13cmos5l_decap_8_1901 VSS VDD sg13cmos5l_decap_8
Xsg13cmos5l_decap_8_2679 VSS VDD sg13cmos5l_decap_8
Xsg13cmos5l_decap_8_2657 VSS VDD sg13cmos5l_decap_8
Xsg13cmos5l_decap_8_2668 VSS VDD sg13cmos5l_decap_8
Xsg13cmos5l_decap_8_1912 VSS VDD sg13cmos5l_decap_8
Xsg13cmos5l_decap_8_1923 VSS VDD sg13cmos5l_decap_8
Xsg13cmos5l_decap_8_1934 VSS VDD sg13cmos5l_decap_8
Xsg13cmos5l_decap_8_1978 VSS VDD sg13cmos5l_decap_8
Xsg13cmos5l_decap_8_1967 VSS VDD sg13cmos5l_decap_8
Xsg13cmos5l_decap_8_1956 VSS VDD sg13cmos5l_decap_8
Xsg13cmos5l_decap_8_1945 VSS VDD sg13cmos5l_decap_8
Xsg13cmos5l_decap_8_1989 VSS VDD sg13cmos5l_decap_8
Xsg13cmos5l_decap_8_1219 VSS VDD sg13cmos5l_decap_8
Xsg13cmos5l_decap_8_1208 VSS VDD sg13cmos5l_decap_8
Xsg13cmos5l_decap_8_531 VSS VDD sg13cmos5l_decap_8
Xsg13cmos5l_decap_8_520 VSS VDD sg13cmos5l_decap_8
Xsg13cmos5l_decap_8_553 VSS VDD sg13cmos5l_decap_8
Xsg13cmos5l_decap_8_542 VSS VDD sg13cmos5l_decap_8
Xsg13cmos5l_decap_8_564 VSS VDD sg13cmos5l_decap_8
Xsg13cmos5l_decap_8_586 VSS VDD sg13cmos5l_decap_8
Xsg13cmos5l_decap_8_597 VSS VDD sg13cmos5l_decap_8
Xsg13cmos5l_decap_8_575 VSS VDD sg13cmos5l_decap_8
Xsg13cmos5l_decap_8_3111 VSS VDD sg13cmos5l_decap_8
Xsg13cmos5l_decap_8_3122 VSS VDD sg13cmos5l_decap_8
Xsg13cmos5l_decap_8_3100 VSS VDD sg13cmos5l_decap_8
Xsg13cmos5l_decap_8_3155 VSS VDD sg13cmos5l_decap_8
Xsg13cmos5l_decap_8_3144 VSS VDD sg13cmos5l_decap_8
Xsg13cmos5l_decap_8_3166 VSS VDD sg13cmos5l_decap_8
Xsg13cmos5l_decap_8_3133 VSS VDD sg13cmos5l_decap_8
Xsg13cmos5l_decap_8_2410 VSS VDD sg13cmos5l_decap_8
Xsg13cmos5l_decap_8_2421 VSS VDD sg13cmos5l_decap_8
Xsg13cmos5l_decap_8_3199 VSS VDD sg13cmos5l_decap_8
Xsg13cmos5l_decap_8_3177 VSS VDD sg13cmos5l_decap_8
Xsg13cmos5l_decap_8_3188 VSS VDD sg13cmos5l_decap_8
Xsg13cmos5l_decap_8_2432 VSS VDD sg13cmos5l_decap_8
Xsg13cmos5l_decap_8_2443 VSS VDD sg13cmos5l_decap_8
Xsg13cmos5l_decap_8_2454 VSS VDD sg13cmos5l_decap_8
Xsg13cmos5l_decap_8_2465 VSS VDD sg13cmos5l_decap_8
Xsg13cmos5l_decap_8_2487 VSS VDD sg13cmos5l_decap_8
Xsg13cmos5l_decap_8_2476 VSS VDD sg13cmos5l_decap_8
Xsg13cmos5l_decap_8_1731 VSS VDD sg13cmos5l_decap_8
Xsg13cmos5l_decap_8_1753 VSS VDD sg13cmos5l_decap_8
Xsg13cmos5l_decap_8_1742 VSS VDD sg13cmos5l_decap_8
Xsg13cmos5l_decap_8_1720 VSS VDD sg13cmos5l_decap_8
Xsg13cmos5l_decap_8_2498 VSS VDD sg13cmos5l_decap_8
Xsg13cmos5l_decap_8_1786 VSS VDD sg13cmos5l_decap_8
Xsg13cmos5l_decap_8_1775 VSS VDD sg13cmos5l_decap_8
Xsg13cmos5l_decap_8_1764 VSS VDD sg13cmos5l_decap_8
Xsg13cmos5l_decap_8_1797 VSS VDD sg13cmos5l_decap_8
Xsg13cmos5l_decap_8_1005 VSS VDD sg13cmos5l_decap_8
Xsg13cmos5l_decap_8_1038 VSS VDD sg13cmos5l_decap_8
Xsg13cmos5l_decap_8_1016 VSS VDD sg13cmos5l_decap_8
Xsg13cmos5l_decap_8_1027 VSS VDD sg13cmos5l_decap_8
Xsg13cmos5l_decap_8_1049 VSS VDD sg13cmos5l_decap_8
Xsg13cmos5l_decap_8_361 VSS VDD sg13cmos5l_decap_8
Xsg13cmos5l_decap_8_350 VSS VDD sg13cmos5l_decap_8
Xsg13cmos5l_decap_8_372 VSS VDD sg13cmos5l_decap_8
Xsg13cmos5l_decap_8_394 VSS VDD sg13cmos5l_decap_8
Xsg13cmos5l_decap_8_383 VSS VDD sg13cmos5l_decap_8
Xsg13cmos5l_decap_8_50 VSS VDD sg13cmos5l_decap_8
Xsg13cmos5l_decap_8_61 VSS VDD sg13cmos5l_decap_8
Xsg13cmos5l_decap_8_83 VSS VDD sg13cmos5l_decap_8
Xsg13cmos5l_decap_8_72 VSS VDD sg13cmos5l_decap_8
Xsg13cmos5l_decap_8_94 VSS VDD sg13cmos5l_decap_8
Xsg13cmos5l_decap_8_2262 VSS VDD sg13cmos5l_decap_8
Xsg13cmos5l_decap_8_2240 VSS VDD sg13cmos5l_decap_8
Xsg13cmos5l_decap_8_2251 VSS VDD sg13cmos5l_decap_8
Xsg13cmos5l_decap_8_2284 VSS VDD sg13cmos5l_decap_8
Xsg13cmos5l_decap_8_2273 VSS VDD sg13cmos5l_decap_8
Xsg13cmos5l_decap_8_2295 VSS VDD sg13cmos5l_decap_8
Xsg13cmos5l_decap_8_1561 VSS VDD sg13cmos5l_decap_8
Xsg13cmos5l_decap_8_1550 VSS VDD sg13cmos5l_decap_8
Xsg13cmos5l_decap_8_1583 VSS VDD sg13cmos5l_decap_8
Xsg13cmos5l_decap_8_1572 VSS VDD sg13cmos5l_decap_8
Xsg13cmos5l_decap_8_1594 VSS VDD sg13cmos5l_decap_8
Xsg13cmos5l_decap_4_19 VSS VDD sg13cmos5l_decap_4
Xsg13cmos5l_decap_8_180 VSS VDD sg13cmos5l_decap_8
Xsg13cmos5l_decap_8_191 VSS VDD sg13cmos5l_decap_8
Xsg13cmos5l_decap_8_2070 VSS VDD sg13cmos5l_decap_8
Xsg13cmos5l_decap_8_2092 VSS VDD sg13cmos5l_decap_8
Xsg13cmos5l_decap_8_2081 VSS VDD sg13cmos5l_decap_8
Xsg13cmos5l_decap_8_1391 VSS VDD sg13cmos5l_decap_8
Xsg13cmos5l_decap_8_1380 VSS VDD sg13cmos5l_decap_8
Xsg13cmos5l_decap_8_905 VSS VDD sg13cmos5l_decap_8
Xsg13cmos5l_decap_8_938 VSS VDD sg13cmos5l_decap_8
Xsg13cmos5l_decap_8_916 VSS VDD sg13cmos5l_decap_8
Xsg13cmos5l_decap_8_927 VSS VDD sg13cmos5l_decap_8
Xsg13cmos5l_decap_8_949 VSS VDD sg13cmos5l_decap_8
Xsg13cmos5l_decap_8_3518 VSS VDD sg13cmos5l_decap_8
Xsg13cmos5l_decap_8_3507 VSS VDD sg13cmos5l_decap_8
Xsg13cmos5l_decap_8_3529 VSS VDD sg13cmos5l_decap_8
Xsg13cmos5l_decap_8_2806 VSS VDD sg13cmos5l_decap_8
Xsg13cmos5l_decap_8_2828 VSS VDD sg13cmos5l_decap_8
Xsg13cmos5l_decap_8_2817 VSS VDD sg13cmos5l_decap_8
Xsg13cmos5l_decap_8_2839 VSS VDD sg13cmos5l_decap_8
Xsg13cmos5l_decap_8_713 VSS VDD sg13cmos5l_decap_8
Xsg13cmos5l_decap_8_702 VSS VDD sg13cmos5l_decap_8
Xsg13cmos5l_decap_8_724 VSS VDD sg13cmos5l_decap_8
Xsg13cmos5l_decap_8_746 VSS VDD sg13cmos5l_decap_8
Xsg13cmos5l_decap_8_735 VSS VDD sg13cmos5l_decap_8
Xsg13cmos5l_decap_8_757 VSS VDD sg13cmos5l_decap_8
Xsg13cmos5l_decap_8_779 VSS VDD sg13cmos5l_decap_8
Xsg13cmos5l_decap_8_768 VSS VDD sg13cmos5l_decap_8
Xsg13cmos5l_decap_8_3304 VSS VDD sg13cmos5l_decap_8
Xsg13cmos5l_decap_8_3315 VSS VDD sg13cmos5l_decap_8
Xsg13cmos5l_decap_8_3348 VSS VDD sg13cmos5l_decap_8
Xsg13cmos5l_decap_8_3326 VSS VDD sg13cmos5l_decap_8
Xsg13cmos5l_decap_8_3337 VSS VDD sg13cmos5l_decap_8
Xsg13cmos5l_decap_8_2603 VSS VDD sg13cmos5l_decap_8
Xsg13cmos5l_decap_8_3359 VSS VDD sg13cmos5l_decap_8
Xsg13cmos5l_decap_8_2636 VSS VDD sg13cmos5l_decap_8
Xsg13cmos5l_decap_8_2625 VSS VDD sg13cmos5l_decap_8
Xsg13cmos5l_decap_8_2614 VSS VDD sg13cmos5l_decap_8
Xsg13cmos5l_decap_8_1902 VSS VDD sg13cmos5l_decap_8
Xsg13cmos5l_decap_8_2647 VSS VDD sg13cmos5l_decap_8
Xsg13cmos5l_decap_8_2658 VSS VDD sg13cmos5l_decap_8
Xsg13cmos5l_decap_8_2669 VSS VDD sg13cmos5l_decap_8
Xsg13cmos5l_decap_8_1924 VSS VDD sg13cmos5l_decap_8
Xsg13cmos5l_decap_8_1935 VSS VDD sg13cmos5l_decap_8
Xsg13cmos5l_decap_8_1913 VSS VDD sg13cmos5l_decap_8
Xsg13cmos5l_decap_8_1957 VSS VDD sg13cmos5l_decap_8
Xsg13cmos5l_decap_8_1968 VSS VDD sg13cmos5l_decap_8
Xsg13cmos5l_decap_8_1946 VSS VDD sg13cmos5l_decap_8
Xsg13cmos5l_decap_8_1979 VSS VDD sg13cmos5l_decap_8
Xsg13cmos5l_decap_8_1209 VSS VDD sg13cmos5l_decap_8
Xsg13cmos5l_decap_8_521 VSS VDD sg13cmos5l_decap_8
Xsg13cmos5l_decap_8_510 VSS VDD sg13cmos5l_decap_8
Xsg13cmos5l_decap_8_554 VSS VDD sg13cmos5l_decap_8
Xsg13cmos5l_decap_8_543 VSS VDD sg13cmos5l_decap_8
Xsg13cmos5l_decap_8_532 VSS VDD sg13cmos5l_decap_8
Xsg13cmos5l_decap_8_598 VSS VDD sg13cmos5l_decap_8
Xsg13cmos5l_decap_8_587 VSS VDD sg13cmos5l_decap_8
Xsg13cmos5l_decap_8_565 VSS VDD sg13cmos5l_decap_8
Xsg13cmos5l_decap_8_576 VSS VDD sg13cmos5l_decap_8
Xsg13cmos5l_decap_8_3123 VSS VDD sg13cmos5l_decap_8
Xsg13cmos5l_decap_8_3101 VSS VDD sg13cmos5l_decap_8
Xsg13cmos5l_decap_8_3112 VSS VDD sg13cmos5l_decap_8
Xsg13cmos5l_decap_8_3156 VSS VDD sg13cmos5l_decap_8
Xsg13cmos5l_decap_8_3134 VSS VDD sg13cmos5l_decap_8
Xsg13cmos5l_decap_8_3145 VSS VDD sg13cmos5l_decap_8
Xsg13cmos5l_decap_8_2411 VSS VDD sg13cmos5l_decap_8
Xsg13cmos5l_decap_8_2400 VSS VDD sg13cmos5l_decap_8
Xsg13cmos5l_decap_8_3178 VSS VDD sg13cmos5l_decap_8
Xsg13cmos5l_decap_8_3189 VSS VDD sg13cmos5l_decap_8
Xsg13cmos5l_decap_8_3167 VSS VDD sg13cmos5l_decap_8
Xsg13cmos5l_decap_8_2444 VSS VDD sg13cmos5l_decap_8
Xsg13cmos5l_decap_8_2433 VSS VDD sg13cmos5l_decap_8
Xsg13cmos5l_decap_8_2422 VSS VDD sg13cmos5l_decap_8
Xsg13cmos5l_decap_8_2455 VSS VDD sg13cmos5l_decap_8
Xsg13cmos5l_decap_8_1710 VSS VDD sg13cmos5l_decap_8
Xsg13cmos5l_decap_8_2466 VSS VDD sg13cmos5l_decap_8
Xsg13cmos5l_decap_8_2488 VSS VDD sg13cmos5l_decap_8
Xsg13cmos5l_decap_8_2477 VSS VDD sg13cmos5l_decap_8
Xsg13cmos5l_decap_8_1743 VSS VDD sg13cmos5l_decap_8
Xsg13cmos5l_decap_8_1732 VSS VDD sg13cmos5l_decap_8
Xsg13cmos5l_decap_8_1721 VSS VDD sg13cmos5l_decap_8
Xsg13cmos5l_decap_8_2499 VSS VDD sg13cmos5l_decap_8
Xsg13cmos5l_decap_8_1754 VSS VDD sg13cmos5l_decap_8
Xsg13cmos5l_decap_8_1776 VSS VDD sg13cmos5l_decap_8
Xsg13cmos5l_decap_8_1765 VSS VDD sg13cmos5l_decap_8
Xsg13cmos5l_decap_8_1798 VSS VDD sg13cmos5l_decap_8
Xsg13cmos5l_decap_8_1787 VSS VDD sg13cmos5l_decap_8
Xsg13cmos5l_decap_8_1039 VSS VDD sg13cmos5l_decap_8
Xsg13cmos5l_decap_8_1028 VSS VDD sg13cmos5l_decap_8
Xsg13cmos5l_decap_8_1006 VSS VDD sg13cmos5l_decap_8
Xsg13cmos5l_decap_8_1017 VSS VDD sg13cmos5l_decap_8
Xsg13cmos5l_decap_8_351 VSS VDD sg13cmos5l_decap_8
Xsg13cmos5l_decap_8_362 VSS VDD sg13cmos5l_decap_8
Xsg13cmos5l_decap_8_340 VSS VDD sg13cmos5l_decap_8
Xsg13cmos5l_decap_8_373 VSS VDD sg13cmos5l_decap_8
Xsg13cmos5l_decap_8_395 VSS VDD sg13cmos5l_decap_8
Xsg13cmos5l_decap_8_384 VSS VDD sg13cmos5l_decap_8
Xsg13cmos5l_decap_8_40 VSS VDD sg13cmos5l_decap_8
Xsg13cmos5l_decap_8_51 VSS VDD sg13cmos5l_decap_8
Xsg13cmos5l_decap_8_62 VSS VDD sg13cmos5l_decap_8
Xsg13cmos5l_decap_8_84 VSS VDD sg13cmos5l_decap_8
Xsg13cmos5l_decap_8_73 VSS VDD sg13cmos5l_decap_8
Xsg13cmos5l_decap_8_95 VSS VDD sg13cmos5l_decap_8
Xsg13cmos5l_decap_8_2263 VSS VDD sg13cmos5l_decap_8
Xsg13cmos5l_decap_8_2252 VSS VDD sg13cmos5l_decap_8
Xsg13cmos5l_decap_8_2230 VSS VDD sg13cmos5l_decap_8
Xsg13cmos5l_decap_8_2241 VSS VDD sg13cmos5l_decap_8
Xsg13cmos5l_decap_8_2296 VSS VDD sg13cmos5l_decap_8
Xsg13cmos5l_decap_8_2285 VSS VDD sg13cmos5l_decap_8
Xsg13cmos5l_decap_8_2274 VSS VDD sg13cmos5l_decap_8
Xsg13cmos5l_decap_8_1540 VSS VDD sg13cmos5l_decap_8
Xsg13cmos5l_decap_8_1551 VSS VDD sg13cmos5l_decap_8
Xsg13cmos5l_decap_8_1562 VSS VDD sg13cmos5l_decap_8
Xsg13cmos5l_decap_8_1573 VSS VDD sg13cmos5l_decap_8
Xsg13cmos5l_decap_8_1584 VSS VDD sg13cmos5l_decap_8
Xsg13cmos5l_decap_8_1595 VSS VDD sg13cmos5l_decap_8
Xsg13cmos5l_decap_8_181 VSS VDD sg13cmos5l_decap_8
Xsg13cmos5l_decap_8_170 VSS VDD sg13cmos5l_decap_8
Xsg13cmos5l_decap_8_192 VSS VDD sg13cmos5l_decap_8
Xsg13cmos5l_decap_8_2060 VSS VDD sg13cmos5l_decap_8
Xsg13cmos5l_decap_8_2071 VSS VDD sg13cmos5l_decap_8
Xsg13cmos5l_decap_8_2093 VSS VDD sg13cmos5l_decap_8
Xsg13cmos5l_decap_8_2082 VSS VDD sg13cmos5l_decap_8
Xsg13cmos5l_decap_8_1392 VSS VDD sg13cmos5l_decap_8
Xsg13cmos5l_decap_8_1381 VSS VDD sg13cmos5l_decap_8
Xsg13cmos5l_decap_8_1370 VSS VDD sg13cmos5l_decap_8
Xsg13cmos5l_decap_8_917 VSS VDD sg13cmos5l_decap_8
Xsg13cmos5l_decap_8_928 VSS VDD sg13cmos5l_decap_8
Xsg13cmos5l_decap_8_906 VSS VDD sg13cmos5l_decap_8
Xsg13cmos5l_decap_8_939 VSS VDD sg13cmos5l_decap_8
Xsg13cmos5l_decap_8_3508 VSS VDD sg13cmos5l_decap_8
Xsg13cmos5l_decap_8_3519 VSS VDD sg13cmos5l_decap_8
Xsg13cmos5l_decap_8_2807 VSS VDD sg13cmos5l_decap_8
Xsg13cmos5l_decap_8_2829 VSS VDD sg13cmos5l_decap_8
Xsg13cmos5l_decap_8_2818 VSS VDD sg13cmos5l_decap_8
Xsg13cmos5l_decap_8_703 VSS VDD sg13cmos5l_decap_8
Xsg13cmos5l_decap_8_714 VSS VDD sg13cmos5l_decap_8
Xsg13cmos5l_decap_8_725 VSS VDD sg13cmos5l_decap_8
Xsg13cmos5l_decap_8_747 VSS VDD sg13cmos5l_decap_8
Xsg13cmos5l_decap_8_736 VSS VDD sg13cmos5l_decap_8
Xsg13cmos5l_decap_8_758 VSS VDD sg13cmos5l_decap_8
Xsg13cmos5l_decap_8_769 VSS VDD sg13cmos5l_decap_8
Xsg13cmos5l_decap_8_3305 VSS VDD sg13cmos5l_decap_8
Xsg13cmos5l_decap_8_3338 VSS VDD sg13cmos5l_decap_8
Xsg13cmos5l_decap_8_3327 VSS VDD sg13cmos5l_decap_8
Xsg13cmos5l_decap_8_3316 VSS VDD sg13cmos5l_decap_8
Xsg13cmos5l_decap_8_2604 VSS VDD sg13cmos5l_decap_8
Xsg13cmos5l_decap_8_3349 VSS VDD sg13cmos5l_decap_8
Xsg13cmos5l_decap_8_2637 VSS VDD sg13cmos5l_decap_8
Xsg13cmos5l_decap_8_2626 VSS VDD sg13cmos5l_decap_8
Xsg13cmos5l_decap_8_2615 VSS VDD sg13cmos5l_decap_8
Xsg13cmos5l_decap_8_2648 VSS VDD sg13cmos5l_decap_8
Xsg13cmos5l_decap_8_2659 VSS VDD sg13cmos5l_decap_8
Xsg13cmos5l_decap_8_1903 VSS VDD sg13cmos5l_decap_8
Xsg13cmos5l_decap_8_1914 VSS VDD sg13cmos5l_decap_8
Xsg13cmos5l_decap_8_1925 VSS VDD sg13cmos5l_decap_8
Xsg13cmos5l_decap_8_1969 VSS VDD sg13cmos5l_decap_8
Xsg13cmos5l_decap_8_1958 VSS VDD sg13cmos5l_decap_8
Xsg13cmos5l_decap_8_1947 VSS VDD sg13cmos5l_decap_8
Xsg13cmos5l_decap_8_1936 VSS VDD sg13cmos5l_decap_8
Xsg13cmos5l_decap_8_522 VSS VDD sg13cmos5l_decap_8
Xsg13cmos5l_decap_8_500 VSS VDD sg13cmos5l_decap_8
Xsg13cmos5l_decap_8_511 VSS VDD sg13cmos5l_decap_8
Xsg13cmos5l_decap_8_544 VSS VDD sg13cmos5l_decap_8
Xsg13cmos5l_decap_8_555 VSS VDD sg13cmos5l_decap_8
Xsg13cmos5l_decap_8_533 VSS VDD sg13cmos5l_decap_8
Xsg13cmos5l_decap_8_588 VSS VDD sg13cmos5l_decap_8
Xsg13cmos5l_decap_8_566 VSS VDD sg13cmos5l_decap_8
Xsg13cmos5l_decap_8_577 VSS VDD sg13cmos5l_decap_8
Xsg13cmos5l_decap_8_599 VSS VDD sg13cmos5l_decap_8
Xsg13cmos5l_decap_8_3113 VSS VDD sg13cmos5l_decap_8
Xsg13cmos5l_decap_8_3102 VSS VDD sg13cmos5l_decap_8
Xsg13cmos5l_decap_8_3124 VSS VDD sg13cmos5l_decap_8
Xsg13cmos5l_decap_8_3157 VSS VDD sg13cmos5l_decap_8
Xsg13cmos5l_decap_8_3146 VSS VDD sg13cmos5l_decap_8
Xsg13cmos5l_decap_8_3135 VSS VDD sg13cmos5l_decap_8
Xsg13cmos5l_decap_8_2412 VSS VDD sg13cmos5l_decap_8
Xsg13cmos5l_decap_8_2401 VSS VDD sg13cmos5l_decap_8
Xsg13cmos5l_decap_8_3179 VSS VDD sg13cmos5l_decap_8
Xsg13cmos5l_decap_8_3168 VSS VDD sg13cmos5l_decap_8
Xsg13cmos5l_decap_8_2434 VSS VDD sg13cmos5l_decap_8
Xsg13cmos5l_decap_8_2445 VSS VDD sg13cmos5l_decap_8
Xsg13cmos5l_decap_8_2423 VSS VDD sg13cmos5l_decap_8
Xsg13cmos5l_decap_8_1700 VSS VDD sg13cmos5l_decap_8
Xsg13cmos5l_decap_8_2456 VSS VDD sg13cmos5l_decap_8
Xsg13cmos5l_decap_8_2467 VSS VDD sg13cmos5l_decap_8
Xsg13cmos5l_decap_8_2478 VSS VDD sg13cmos5l_decap_8
Xsg13cmos5l_decap_8_1744 VSS VDD sg13cmos5l_decap_8
Xsg13cmos5l_decap_8_1711 VSS VDD sg13cmos5l_decap_8
Xsg13cmos5l_decap_8_1733 VSS VDD sg13cmos5l_decap_8
Xsg13cmos5l_decap_8_1722 VSS VDD sg13cmos5l_decap_8
Xsg13cmos5l_decap_8_2489 VSS VDD sg13cmos5l_decap_8
Xsg13cmos5l_decap_8_1777 VSS VDD sg13cmos5l_decap_8
Xsg13cmos5l_decap_8_1755 VSS VDD sg13cmos5l_decap_8
Xsg13cmos5l_decap_8_1766 VSS VDD sg13cmos5l_decap_8
Xsg13cmos5l_decap_8_1788 VSS VDD sg13cmos5l_decap_8
Xsg13cmos5l_decap_8_1799 VSS VDD sg13cmos5l_decap_8
Xsg13cmos5l_decap_8_2990 VSS VDD sg13cmos5l_decap_8
Xsg13cmos5l_decap_8_1007 VSS VDD sg13cmos5l_decap_8
Xsg13cmos5l_decap_8_1018 VSS VDD sg13cmos5l_decap_8
Xsg13cmos5l_decap_8_1029 VSS VDD sg13cmos5l_decap_8
Xsg13cmos5l_decap_8_330 VSS VDD sg13cmos5l_decap_8
Xsg13cmos5l_decap_8_341 VSS VDD sg13cmos5l_decap_8
Xsg13cmos5l_decap_8_363 VSS VDD sg13cmos5l_decap_8
Xsg13cmos5l_decap_8_352 VSS VDD sg13cmos5l_decap_8
Xsg13cmos5l_decap_8_396 VSS VDD sg13cmos5l_decap_8
Xsg13cmos5l_decap_8_374 VSS VDD sg13cmos5l_decap_8
Xsg13cmos5l_decap_8_385 VSS VDD sg13cmos5l_decap_8
Xsg13cmos5l_decap_8_30 VSS VDD sg13cmos5l_decap_8
Xsg13cmos5l_decap_8_41 VSS VDD sg13cmos5l_decap_8
Xsg13cmos5l_decap_8_52 VSS VDD sg13cmos5l_decap_8
Xsg13cmos5l_decap_8_63 VSS VDD sg13cmos5l_decap_8
Xsg13cmos5l_decap_8_85 VSS VDD sg13cmos5l_decap_8
Xsg13cmos5l_decap_8_74 VSS VDD sg13cmos5l_decap_8
Xsg13cmos5l_decap_8_96 VSS VDD sg13cmos5l_decap_8
Xsg13cmos5l_decap_8_2220 VSS VDD sg13cmos5l_decap_8
Xsg13cmos5l_decap_8_2253 VSS VDD sg13cmos5l_decap_8
Xsg13cmos5l_decap_8_2231 VSS VDD sg13cmos5l_decap_8
Xsg13cmos5l_decap_8_2242 VSS VDD sg13cmos5l_decap_8
Xsg13cmos5l_decap_8_2264 VSS VDD sg13cmos5l_decap_8
Xsg13cmos5l_decap_8_2297 VSS VDD sg13cmos5l_decap_8
Xsg13cmos5l_decap_8_2286 VSS VDD sg13cmos5l_decap_8
Xsg13cmos5l_decap_8_2275 VSS VDD sg13cmos5l_decap_8
Xsg13cmos5l_decap_8_1552 VSS VDD sg13cmos5l_decap_8
Xsg13cmos5l_decap_8_1530 VSS VDD sg13cmos5l_decap_8
Xsg13cmos5l_decap_8_1541 VSS VDD sg13cmos5l_decap_8
Xsg13cmos5l_decap_8_1563 VSS VDD sg13cmos5l_decap_8
Xsg13cmos5l_decap_8_1574 VSS VDD sg13cmos5l_decap_8
Xsg13cmos5l_decap_8_1585 VSS VDD sg13cmos5l_decap_8
Xsg13cmos5l_decap_8_1596 VSS VDD sg13cmos5l_decap_8
Xsg13cmos5l_decap_8_160 VSS VDD sg13cmos5l_decap_8
Xsg13cmos5l_decap_8_171 VSS VDD sg13cmos5l_decap_8
Xsg13cmos5l_decap_8_182 VSS VDD sg13cmos5l_decap_8
Xsg13cmos5l_decap_8_193 VSS VDD sg13cmos5l_decap_8
Xsg13cmos5l_decap_8_2061 VSS VDD sg13cmos5l_decap_8
Xsg13cmos5l_decap_8_2050 VSS VDD sg13cmos5l_decap_8
Xsg13cmos5l_decap_8_2083 VSS VDD sg13cmos5l_decap_8
Xsg13cmos5l_decap_8_2094 VSS VDD sg13cmos5l_decap_8
Xsg13cmos5l_decap_8_2072 VSS VDD sg13cmos5l_decap_8
Xsg13cmos5l_decap_8_1360 VSS VDD sg13cmos5l_decap_8
Xsg13cmos5l_decap_8_1393 VSS VDD sg13cmos5l_decap_8
Xsg13cmos5l_decap_8_1382 VSS VDD sg13cmos5l_decap_8
Xsg13cmos5l_decap_8_1371 VSS VDD sg13cmos5l_decap_8
Xsg13cmos5l_decap_8_929 VSS VDD sg13cmos5l_decap_8
Xsg13cmos5l_decap_8_918 VSS VDD sg13cmos5l_decap_8
Xsg13cmos5l_decap_8_907 VSS VDD sg13cmos5l_decap_8
Xsg13cmos5l_decap_8_1190 VSS VDD sg13cmos5l_decap_8
Xsg13cmos5l_decap_8_3509 VSS VDD sg13cmos5l_decap_8
Xsg13cmos5l_decap_8_2808 VSS VDD sg13cmos5l_decap_8
Xsg13cmos5l_decap_8_2819 VSS VDD sg13cmos5l_decap_8
Xsg13cmos5l_decap_8_704 VSS VDD sg13cmos5l_decap_8
Xsg13cmos5l_decap_8_715 VSS VDD sg13cmos5l_decap_8
Xsg13cmos5l_decap_8_726 VSS VDD sg13cmos5l_decap_8
Xsg13cmos5l_decap_8_737 VSS VDD sg13cmos5l_decap_8
Xsg13cmos5l_decap_8_759 VSS VDD sg13cmos5l_decap_8
Xsg13cmos5l_decap_8_748 VSS VDD sg13cmos5l_decap_8
Xsg13cmos5l_decap_8_3306 VSS VDD sg13cmos5l_decap_8
Xsg13cmos5l_decap_8_3339 VSS VDD sg13cmos5l_decap_8
Xsg13cmos5l_decap_8_3328 VSS VDD sg13cmos5l_decap_8
Xsg13cmos5l_decap_8_3317 VSS VDD sg13cmos5l_decap_8
Xsg13cmos5l_decap_8_2627 VSS VDD sg13cmos5l_decap_8
Xsg13cmos5l_decap_8_2616 VSS VDD sg13cmos5l_decap_8
Xsg13cmos5l_decap_8_2605 VSS VDD sg13cmos5l_decap_8
Xsg13cmos5l_decap_8_2638 VSS VDD sg13cmos5l_decap_8
Xsg13cmos5l_decap_8_2649 VSS VDD sg13cmos5l_decap_8
Xsg13cmos5l_decap_8_1926 VSS VDD sg13cmos5l_decap_8
Xsg13cmos5l_decap_8_1904 VSS VDD sg13cmos5l_decap_8
Xsg13cmos5l_decap_8_1915 VSS VDD sg13cmos5l_decap_8
Xsg13cmos5l_decap_8_1959 VSS VDD sg13cmos5l_decap_8
Xsg13cmos5l_decap_8_1937 VSS VDD sg13cmos5l_decap_8
Xsg13cmos5l_decap_8_1948 VSS VDD sg13cmos5l_decap_8
Xsg13cmos5l_decap_8_501 VSS VDD sg13cmos5l_decap_8
Xsg13cmos5l_decap_8_512 VSS VDD sg13cmos5l_decap_8
Xsg13cmos5l_decap_8_523 VSS VDD sg13cmos5l_decap_8
Xsg13cmos5l_decap_8_545 VSS VDD sg13cmos5l_decap_8
Xsg13cmos5l_decap_8_534 VSS VDD sg13cmos5l_decap_8
Xsg13cmos5l_decap_8_556 VSS VDD sg13cmos5l_decap_8
Xsg13cmos5l_decap_8_589 VSS VDD sg13cmos5l_decap_8
Xsg13cmos5l_decap_8_567 VSS VDD sg13cmos5l_decap_8
Xsg13cmos5l_decap_8_578 VSS VDD sg13cmos5l_decap_8
Xsg13cmos5l_decap_8_3103 VSS VDD sg13cmos5l_decap_8
Xsg13cmos5l_decap_8_3114 VSS VDD sg13cmos5l_decap_8
Xsg13cmos5l_decap_8_3136 VSS VDD sg13cmos5l_decap_8
Xsg13cmos5l_decap_8_3125 VSS VDD sg13cmos5l_decap_8
Xsg13cmos5l_decap_8_3147 VSS VDD sg13cmos5l_decap_8
Xsg13cmos5l_decap_8_2402 VSS VDD sg13cmos5l_decap_8
Xsg13cmos5l_decap_8_3158 VSS VDD sg13cmos5l_decap_8
Xsg13cmos5l_decap_8_3169 VSS VDD sg13cmos5l_decap_8
Xsg13cmos5l_decap_8_2424 VSS VDD sg13cmos5l_decap_8
Xsg13cmos5l_decap_8_2435 VSS VDD sg13cmos5l_decap_8
Xsg13cmos5l_decap_8_2446 VSS VDD sg13cmos5l_decap_8
Xsg13cmos5l_decap_8_2413 VSS VDD sg13cmos5l_decap_8
Xsg13cmos5l_decap_8_1701 VSS VDD sg13cmos5l_decap_8
Xsg13cmos5l_decap_8_2457 VSS VDD sg13cmos5l_decap_8
Xsg13cmos5l_decap_8_2468 VSS VDD sg13cmos5l_decap_8
Xsg13cmos5l_decap_8_2479 VSS VDD sg13cmos5l_decap_8
Xsg13cmos5l_decap_8_1734 VSS VDD sg13cmos5l_decap_8
Xsg13cmos5l_decap_8_1712 VSS VDD sg13cmos5l_decap_8
Xsg13cmos5l_decap_8_1723 VSS VDD sg13cmos5l_decap_8
Xsg13cmos5l_decap_8_1745 VSS VDD sg13cmos5l_decap_8
Xsg13cmos5l_decap_8_1756 VSS VDD sg13cmos5l_decap_8
Xsg13cmos5l_decap_8_1767 VSS VDD sg13cmos5l_decap_8
Xsg13cmos5l_decap_8_1789 VSS VDD sg13cmos5l_decap_8
Xsg13cmos5l_decap_8_1778 VSS VDD sg13cmos5l_decap_8
Xsg13cmos5l_decap_8_2980 VSS VDD sg13cmos5l_decap_8
Xsg13cmos5l_decap_8_2991 VSS VDD sg13cmos5l_decap_8
Xsg13cmos5l_decap_8_1019 VSS VDD sg13cmos5l_decap_8
Xsg13cmos5l_decap_8_1008 VSS VDD sg13cmos5l_decap_8
Xsg13cmos5l_decap_8_320 VSS VDD sg13cmos5l_decap_8
Xsg13cmos5l_decap_8_331 VSS VDD sg13cmos5l_decap_8
Xsg13cmos5l_decap_8_364 VSS VDD sg13cmos5l_decap_8
Xsg13cmos5l_decap_8_342 VSS VDD sg13cmos5l_decap_8
Xsg13cmos5l_decap_8_353 VSS VDD sg13cmos5l_decap_8
Xsg13cmos5l_decap_8_397 VSS VDD sg13cmos5l_decap_8
Xsg13cmos5l_decap_8_386 VSS VDD sg13cmos5l_decap_8
Xsg13cmos5l_decap_8_375 VSS VDD sg13cmos5l_decap_8
Xsg13cmos5l_decap_8_31 VSS VDD sg13cmos5l_decap_8
Xsg13cmos5l_decap_8_20 VSS VDD sg13cmos5l_decap_8
Xsg13cmos5l_decap_8_42 VSS VDD sg13cmos5l_decap_8
Xsg13cmos5l_decap_8_75 VSS VDD sg13cmos5l_decap_8
Xsg13cmos5l_decap_8_53 VSS VDD sg13cmos5l_decap_8
Xsg13cmos5l_decap_8_64 VSS VDD sg13cmos5l_decap_8
Xsg13cmos5l_decap_8_97 VSS VDD sg13cmos5l_decap_8
Xsg13cmos5l_decap_8_86 VSS VDD sg13cmos5l_decap_8
Xsg13cmos5l_decap_8_2210 VSS VDD sg13cmos5l_decap_8
Xsg13cmos5l_decap_8_2254 VSS VDD sg13cmos5l_decap_8
Xsg13cmos5l_decap_8_2232 VSS VDD sg13cmos5l_decap_8
Xsg13cmos5l_decap_8_2221 VSS VDD sg13cmos5l_decap_8
Xsg13cmos5l_decap_8_2243 VSS VDD sg13cmos5l_decap_8
Xsg13cmos5l_decap_8_2265 VSS VDD sg13cmos5l_decap_8
Xsg13cmos5l_decap_8_2287 VSS VDD sg13cmos5l_decap_8
Xsg13cmos5l_decap_8_2276 VSS VDD sg13cmos5l_decap_8
Xsg13cmos5l_decap_8_1531 VSS VDD sg13cmos5l_decap_8
Xsg13cmos5l_decap_8_1520 VSS VDD sg13cmos5l_decap_8
Xsg13cmos5l_decap_8_1542 VSS VDD sg13cmos5l_decap_8
Xsg13cmos5l_decap_8_2298 VSS VDD sg13cmos5l_decap_8
Xsg13cmos5l_decap_8_1553 VSS VDD sg13cmos5l_decap_8
Xsg13cmos5l_decap_8_1564 VSS VDD sg13cmos5l_decap_8
Xsg13cmos5l_decap_8_1575 VSS VDD sg13cmos5l_decap_8
Xsg13cmos5l_decap_8_1586 VSS VDD sg13cmos5l_decap_8
Xsg13cmos5l_decap_8_1597 VSS VDD sg13cmos5l_decap_8
Xsg13cmos5l_decap_8_150 VSS VDD sg13cmos5l_decap_8
Xsg13cmos5l_decap_8_172 VSS VDD sg13cmos5l_decap_8
Xsg13cmos5l_decap_8_161 VSS VDD sg13cmos5l_decap_8
Xsg13cmos5l_decap_8_183 VSS VDD sg13cmos5l_decap_8
Xsg13cmos5l_decap_8_194 VSS VDD sg13cmos5l_decap_8
Xsg13cmos5l_decap_8_2062 VSS VDD sg13cmos5l_decap_8
Xsg13cmos5l_decap_8_2040 VSS VDD sg13cmos5l_decap_8
Xsg13cmos5l_decap_8_2051 VSS VDD sg13cmos5l_decap_8
Xsg13cmos5l_decap_8_2095 VSS VDD sg13cmos5l_decap_8
Xsg13cmos5l_decap_8_2084 VSS VDD sg13cmos5l_decap_8
Xsg13cmos5l_decap_8_2073 VSS VDD sg13cmos5l_decap_8
Xsg13cmos5l_decap_8_1350 VSS VDD sg13cmos5l_decap_8
Xsg13cmos5l_decap_8_1361 VSS VDD sg13cmos5l_decap_8
Xsg13cmos5l_decap_8_1383 VSS VDD sg13cmos5l_decap_8
Xsg13cmos5l_decap_8_1394 VSS VDD sg13cmos5l_decap_8
Xsg13cmos5l_decap_8_1372 VSS VDD sg13cmos5l_decap_8
Xsg13cmos5l_decap_8_919 VSS VDD sg13cmos5l_decap_8
Xsg13cmos5l_decap_8_908 VSS VDD sg13cmos5l_decap_8
Xsg13cmos5l_decap_8_1180 VSS VDD sg13cmos5l_decap_8
Xsg13cmos5l_decap_8_1191 VSS VDD sg13cmos5l_decap_8
Xsg13cmos5l_decap_8_2809 VSS VDD sg13cmos5l_decap_8
Xsg13cmos5l_decap_8_716 VSS VDD sg13cmos5l_decap_8
Xsg13cmos5l_decap_8_705 VSS VDD sg13cmos5l_decap_8
Xsg13cmos5l_decap_8_727 VSS VDD sg13cmos5l_decap_8
Xsg13cmos5l_decap_8_738 VSS VDD sg13cmos5l_decap_8
Xsg13cmos5l_decap_8_749 VSS VDD sg13cmos5l_decap_8
Xsg13cmos5l_decap_8_3329 VSS VDD sg13cmos5l_decap_8
Xsg13cmos5l_decap_8_3307 VSS VDD sg13cmos5l_decap_8
Xsg13cmos5l_decap_8_3318 VSS VDD sg13cmos5l_decap_8
Xsg13cmos5l_decap_8_2606 VSS VDD sg13cmos5l_decap_8
Xsg13cmos5l_decap_8_2628 VSS VDD sg13cmos5l_decap_8
Xsg13cmos5l_decap_8_2617 VSS VDD sg13cmos5l_decap_8
Xsg13cmos5l_decap_8_2639 VSS VDD sg13cmos5l_decap_8
Xsg13cmos5l_decap_8_1905 VSS VDD sg13cmos5l_decap_8
Xsg13cmos5l_decap_8_1916 VSS VDD sg13cmos5l_decap_8
Xsg13cmos5l_decap_8_1927 VSS VDD sg13cmos5l_decap_8
Xsg13cmos5l_decap_8_1938 VSS VDD sg13cmos5l_decap_8
Xsg13cmos5l_decap_8_1949 VSS VDD sg13cmos5l_decap_8
Xsg13cmos5l_decap_8_502 VSS VDD sg13cmos5l_decap_8
Xsg13cmos5l_decap_8_513 VSS VDD sg13cmos5l_decap_8
Xsg13cmos5l_decap_8_546 VSS VDD sg13cmos5l_decap_8
Xsg13cmos5l_decap_8_535 VSS VDD sg13cmos5l_decap_8
Xsg13cmos5l_decap_8_524 VSS VDD sg13cmos5l_decap_8
Xsg13cmos5l_decap_8_557 VSS VDD sg13cmos5l_decap_8
Xsg13cmos5l_decap_8_579 VSS VDD sg13cmos5l_decap_8
Xsg13cmos5l_decap_8_568 VSS VDD sg13cmos5l_decap_8
Xsg13cmos5l_decap_8_3104 VSS VDD sg13cmos5l_decap_8
Xsg13cmos5l_decap_8_3148 VSS VDD sg13cmos5l_decap_8
Xsg13cmos5l_decap_8_3115 VSS VDD sg13cmos5l_decap_8
Xsg13cmos5l_decap_8_3126 VSS VDD sg13cmos5l_decap_8
Xsg13cmos5l_decap_8_3137 VSS VDD sg13cmos5l_decap_8
Xsg13cmos5l_decap_8_2403 VSS VDD sg13cmos5l_decap_8
Xsg13cmos5l_decap_8_3159 VSS VDD sg13cmos5l_decap_8
Xsg13cmos5l_decap_8_2436 VSS VDD sg13cmos5l_decap_8
Xsg13cmos5l_decap_8_2414 VSS VDD sg13cmos5l_decap_8
Xsg13cmos5l_decap_8_2425 VSS VDD sg13cmos5l_decap_8
Xsg13cmos5l_decap_8_2458 VSS VDD sg13cmos5l_decap_8
Xsg13cmos5l_decap_8_2447 VSS VDD sg13cmos5l_decap_8
Xsg13cmos5l_decap_8_2469 VSS VDD sg13cmos5l_decap_8
Xsg13cmos5l_decap_8_1702 VSS VDD sg13cmos5l_decap_8
Xsg13cmos5l_decap_8_1735 VSS VDD sg13cmos5l_decap_8
Xsg13cmos5l_decap_8_1713 VSS VDD sg13cmos5l_decap_8
Xsg13cmos5l_decap_8_1724 VSS VDD sg13cmos5l_decap_8
Xsg13cmos5l_decap_8_1746 VSS VDD sg13cmos5l_decap_8
Xsg13cmos5l_decap_8_1768 VSS VDD sg13cmos5l_decap_8
Xsg13cmos5l_decap_8_1757 VSS VDD sg13cmos5l_decap_8
Xsg13cmos5l_decap_8_1779 VSS VDD sg13cmos5l_decap_8
Xsg13cmos5l_decap_8_2992 VSS VDD sg13cmos5l_decap_8
Xsg13cmos5l_decap_8_2981 VSS VDD sg13cmos5l_decap_8
Xsg13cmos5l_decap_8_2970 VSS VDD sg13cmos5l_decap_8
Xsg13cmos5l_decap_8_1009 VSS VDD sg13cmos5l_decap_8
Xsg13cmos5l_decap_8_321 VSS VDD sg13cmos5l_decap_8
Xsg13cmos5l_decap_8_310 VSS VDD sg13cmos5l_decap_8
Xsg13cmos5l_decap_8_343 VSS VDD sg13cmos5l_decap_8
Xsg13cmos5l_decap_8_354 VSS VDD sg13cmos5l_decap_8
Xsg13cmos5l_decap_8_332 VSS VDD sg13cmos5l_decap_8
Xsg13cmos5l_decap_8_365 VSS VDD sg13cmos5l_decap_8
Xsg13cmos5l_decap_8_376 VSS VDD sg13cmos5l_decap_8
Xsg13cmos5l_decap_8_387 VSS VDD sg13cmos5l_decap_8
Xsg13cmos5l_decap_8_398 VSS VDD sg13cmos5l_decap_8
Xsg13cmos5l_decap_8_32 VSS VDD sg13cmos5l_decap_8
Xsg13cmos5l_decap_8_21 VSS VDD sg13cmos5l_decap_8
Xsg13cmos5l_decap_8_10 VSS VDD sg13cmos5l_decap_8
Xsg13cmos5l_decap_8_65 VSS VDD sg13cmos5l_decap_8
Xsg13cmos5l_decap_8_54 VSS VDD sg13cmos5l_decap_8
Xsg13cmos5l_decap_8_43 VSS VDD sg13cmos5l_decap_8
Xsg13cmos5l_decap_8_76 VSS VDD sg13cmos5l_decap_8
Xsg13cmos5l_decap_8_87 VSS VDD sg13cmos5l_decap_8
Xsg13cmos5l_decap_8_98 VSS VDD sg13cmos5l_decap_8
Xsg13cmos5l_decap_8_2211 VSS VDD sg13cmos5l_decap_8
Xsg13cmos5l_decap_8_2200 VSS VDD sg13cmos5l_decap_8
Xsg13cmos5l_decap_8_2233 VSS VDD sg13cmos5l_decap_8
Xsg13cmos5l_decap_8_2222 VSS VDD sg13cmos5l_decap_8
Xsg13cmos5l_decap_8_2244 VSS VDD sg13cmos5l_decap_8
Xsg13cmos5l_decap_8_2255 VSS VDD sg13cmos5l_decap_8
Xsg13cmos5l_decap_8_2266 VSS VDD sg13cmos5l_decap_8
Xsg13cmos5l_decap_8_2288 VSS VDD sg13cmos5l_decap_8
Xsg13cmos5l_decap_8_2277 VSS VDD sg13cmos5l_decap_8
Xsg13cmos5l_decap_8_1532 VSS VDD sg13cmos5l_decap_8
Xsg13cmos5l_decap_8_1521 VSS VDD sg13cmos5l_decap_8
Xsg13cmos5l_decap_8_1543 VSS VDD sg13cmos5l_decap_8
Xsg13cmos5l_decap_8_1510 VSS VDD sg13cmos5l_decap_8
Xsg13cmos5l_decap_8_2299 VSS VDD sg13cmos5l_decap_8
Xsg13cmos5l_decap_8_1565 VSS VDD sg13cmos5l_decap_8
Xsg13cmos5l_decap_8_1554 VSS VDD sg13cmos5l_decap_8
Xsg13cmos5l_decap_8_1576 VSS VDD sg13cmos5l_decap_8
Xsg13cmos5l_decap_8_1598 VSS VDD sg13cmos5l_decap_8
Xsg13cmos5l_decap_8_1587 VSS VDD sg13cmos5l_decap_8
Xsg13cmos5l_decap_8_3490 VSS VDD sg13cmos5l_decap_8
Xsg13cmos5l_decap_8_151 VSS VDD sg13cmos5l_decap_8
Xsg13cmos5l_decap_8_140 VSS VDD sg13cmos5l_decap_8
Xsg13cmos5l_decap_8_162 VSS VDD sg13cmos5l_decap_8
Xsg13cmos5l_decap_8_184 VSS VDD sg13cmos5l_decap_8
Xsg13cmos5l_decap_8_173 VSS VDD sg13cmos5l_decap_8
Xsg13cmos5l_decap_8_195 VSS VDD sg13cmos5l_decap_8
Xsg13cmos5l_decap_8_2052 VSS VDD sg13cmos5l_decap_8
Xsg13cmos5l_decap_8_2041 VSS VDD sg13cmos5l_decap_8
Xsg13cmos5l_decap_8_2030 VSS VDD sg13cmos5l_decap_8
Xsg13cmos5l_decap_8_2074 VSS VDD sg13cmos5l_decap_8
Xsg13cmos5l_decap_8_2096 VSS VDD sg13cmos5l_decap_8
Xsg13cmos5l_decap_8_2085 VSS VDD sg13cmos5l_decap_8
Xsg13cmos5l_decap_8_2063 VSS VDD sg13cmos5l_decap_8
Xsg13cmos5l_decap_8_1351 VSS VDD sg13cmos5l_decap_8
Xsg13cmos5l_decap_8_1340 VSS VDD sg13cmos5l_decap_8
Xsg13cmos5l_decap_8_1362 VSS VDD sg13cmos5l_decap_8
Xsg13cmos5l_decap_8_1384 VSS VDD sg13cmos5l_decap_8
Xsg13cmos5l_decap_8_1373 VSS VDD sg13cmos5l_decap_8
Xsg13cmos5l_decap_8_1395 VSS VDD sg13cmos5l_decap_8
Xsg13cmos5l_decap_8_909 VSS VDD sg13cmos5l_decap_8
Xsg13cmos5l_decap_8_1181 VSS VDD sg13cmos5l_decap_8
Xsg13cmos5l_decap_8_1192 VSS VDD sg13cmos5l_decap_8
Xsg13cmos5l_decap_8_1170 VSS VDD sg13cmos5l_decap_8
Xsg13cmos5l_decap_8_717 VSS VDD sg13cmos5l_decap_8
Xsg13cmos5l_decap_8_706 VSS VDD sg13cmos5l_decap_8
Xsg13cmos5l_decap_8_728 VSS VDD sg13cmos5l_decap_8
Xsg13cmos5l_decap_8_739 VSS VDD sg13cmos5l_decap_8
Xsg13cmos5l_decap_8_3308 VSS VDD sg13cmos5l_decap_8
Xsg13cmos5l_decap_8_3319 VSS VDD sg13cmos5l_decap_8
Xsg13cmos5l_decap_8_2618 VSS VDD sg13cmos5l_decap_8
Xsg13cmos5l_decap_8_2607 VSS VDD sg13cmos5l_decap_8
Xsg13cmos5l_decap_8_2629 VSS VDD sg13cmos5l_decap_8
Xsg13cmos5l_decap_8_1906 VSS VDD sg13cmos5l_decap_8
Xsg13cmos5l_decap_8_1917 VSS VDD sg13cmos5l_decap_8
Xsg13cmos5l_decap_8_1928 VSS VDD sg13cmos5l_decap_8
Xsg13cmos5l_decap_8_1939 VSS VDD sg13cmos5l_decap_8
Xsg13cmos5l_decap_8_503 VSS VDD sg13cmos5l_decap_8
Xsg13cmos5l_decap_8_514 VSS VDD sg13cmos5l_decap_8
Xsg13cmos5l_decap_8_525 VSS VDD sg13cmos5l_decap_8
Xsg13cmos5l_decap_8_536 VSS VDD sg13cmos5l_decap_8
Xsg13cmos5l_decap_8_558 VSS VDD sg13cmos5l_decap_8
Xsg13cmos5l_decap_8_547 VSS VDD sg13cmos5l_decap_8
Xsg13cmos5l_decap_8_569 VSS VDD sg13cmos5l_decap_8
Xsg13cmos5l_decap_8_3105 VSS VDD sg13cmos5l_decap_8
Xsg13cmos5l_decap_8_3116 VSS VDD sg13cmos5l_decap_8
Xsg13cmos5l_decap_8_3127 VSS VDD sg13cmos5l_decap_8
Xsg13cmos5l_decap_8_3138 VSS VDD sg13cmos5l_decap_8
Xsg13cmos5l_decap_8_2437 VSS VDD sg13cmos5l_decap_8
Xsg13cmos5l_decap_8_3149 VSS VDD sg13cmos5l_decap_8
Xsg13cmos5l_decap_8_2426 VSS VDD sg13cmos5l_decap_8
Xsg13cmos5l_decap_8_2415 VSS VDD sg13cmos5l_decap_8
Xsg13cmos5l_decap_8_2404 VSS VDD sg13cmos5l_decap_8
Xsg13cmos5l_decap_8_2448 VSS VDD sg13cmos5l_decap_8
Xsg13cmos5l_decap_8_2459 VSS VDD sg13cmos5l_decap_8
Xsg13cmos5l_decap_8_1725 VSS VDD sg13cmos5l_decap_8
Xsg13cmos5l_decap_8_1703 VSS VDD sg13cmos5l_decap_8
Xsg13cmos5l_decap_8_1714 VSS VDD sg13cmos5l_decap_8
Xsg13cmos5l_decap_8_1736 VSS VDD sg13cmos5l_decap_8
Xsg13cmos5l_decap_8_1747 VSS VDD sg13cmos5l_decap_8
Xsg13cmos5l_decap_8_1758 VSS VDD sg13cmos5l_decap_8
Xsg13cmos5l_decap_8_1769 VSS VDD sg13cmos5l_decap_8
Xsg13cmos5l_decap_8_2982 VSS VDD sg13cmos5l_decap_8
Xsg13cmos5l_decap_8_2960 VSS VDD sg13cmos5l_decap_8
Xsg13cmos5l_decap_8_2971 VSS VDD sg13cmos5l_decap_8
Xsg13cmos5l_decap_8_2993 VSS VDD sg13cmos5l_decap_8
Xsg13cmos5l_decap_8_300 VSS VDD sg13cmos5l_decap_8
Xsg13cmos5l_decap_8_311 VSS VDD sg13cmos5l_decap_8
Xsg13cmos5l_decap_8_333 VSS VDD sg13cmos5l_decap_8
Xsg13cmos5l_decap_8_344 VSS VDD sg13cmos5l_decap_8
Xsg13cmos5l_decap_8_355 VSS VDD sg13cmos5l_decap_8
Xsg13cmos5l_decap_8_322 VSS VDD sg13cmos5l_decap_8
Xsg13cmos5l_decap_8_366 VSS VDD sg13cmos5l_decap_8
Xsg13cmos5l_decap_8_377 VSS VDD sg13cmos5l_decap_8
Xsg13cmos5l_decap_8_388 VSS VDD sg13cmos5l_decap_8
Xsg13cmos5l_decap_8_399 VSS VDD sg13cmos5l_decap_8
Xsg13cmos5l_decap_8_11 VSS VDD sg13cmos5l_decap_8
Xsg13cmos5l_decap_8_33 VSS VDD sg13cmos5l_decap_8
Xsg13cmos5l_decap_8_22 VSS VDD sg13cmos5l_decap_8
Xsg13cmos5l_decap_8_44 VSS VDD sg13cmos5l_decap_8
Xsg13cmos5l_decap_8_66 VSS VDD sg13cmos5l_decap_8
Xsg13cmos5l_decap_8_55 VSS VDD sg13cmos5l_decap_8
Xsg13cmos5l_decap_8_99 VSS VDD sg13cmos5l_decap_8
Xsg13cmos5l_decap_8_77 VSS VDD sg13cmos5l_decap_8
Xsg13cmos5l_decap_8_88 VSS VDD sg13cmos5l_decap_8
Xsg13cmos5l_decap_8_2201 VSS VDD sg13cmos5l_decap_8
Xsg13cmos5l_decap_8_1500 VSS VDD sg13cmos5l_decap_8
Xsg13cmos5l_decap_8_2234 VSS VDD sg13cmos5l_decap_8
Xsg13cmos5l_decap_8_2245 VSS VDD sg13cmos5l_decap_8
Xsg13cmos5l_decap_8_2212 VSS VDD sg13cmos5l_decap_8
Xsg13cmos5l_decap_8_2223 VSS VDD sg13cmos5l_decap_8
Xsg13cmos5l_decap_8_2256 VSS VDD sg13cmos5l_decap_8
Xsg13cmos5l_decap_8_2267 VSS VDD sg13cmos5l_decap_8
Xsg13cmos5l_decap_8_2278 VSS VDD sg13cmos5l_decap_8
Xsg13cmos5l_decap_8_1522 VSS VDD sg13cmos5l_decap_8
Xsg13cmos5l_decap_8_1533 VSS VDD sg13cmos5l_decap_8
Xsg13cmos5l_decap_8_1511 VSS VDD sg13cmos5l_decap_8
Xsg13cmos5l_decap_8_1566 VSS VDD sg13cmos5l_decap_8
Xsg13cmos5l_decap_8_1555 VSS VDD sg13cmos5l_decap_8
Xsg13cmos5l_decap_8_1544 VSS VDD sg13cmos5l_decap_8
Xsg13cmos5l_decap_8_1577 VSS VDD sg13cmos5l_decap_8
Xsg13cmos5l_decap_8_2289 VSS VDD sg13cmos5l_decap_8
Xsg13cmos5l_decap_8_1599 VSS VDD sg13cmos5l_decap_8
Xsg13cmos5l_decap_8_1588 VSS VDD sg13cmos5l_decap_8
Xsg13cmos5l_decap_8_3480 VSS VDD sg13cmos5l_decap_8
Xsg13cmos5l_decap_8_3491 VSS VDD sg13cmos5l_decap_8
Xsg13cmos5l_decap_8_2790 VSS VDD sg13cmos5l_decap_8
Xsg13cmos5l_decap_8_0 VSS VDD sg13cmos5l_decap_8
Xsg13cmos5l_decap_8_152 VSS VDD sg13cmos5l_decap_8
Xsg13cmos5l_decap_8_130 VSS VDD sg13cmos5l_decap_8
Xsg13cmos5l_decap_8_141 VSS VDD sg13cmos5l_decap_8
Xsg13cmos5l_decap_8_163 VSS VDD sg13cmos5l_decap_8
Xsg13cmos5l_decap_8_185 VSS VDD sg13cmos5l_decap_8
Xsg13cmos5l_decap_8_174 VSS VDD sg13cmos5l_decap_8
Xsg13cmos5l_decap_8_196 VSS VDD sg13cmos5l_decap_8
Xsg13cmos5l_decap_8_2020 VSS VDD sg13cmos5l_decap_8
Xsg13cmos5l_decap_8_2053 VSS VDD sg13cmos5l_decap_8
Xsg13cmos5l_decap_8_2042 VSS VDD sg13cmos5l_decap_8
Xsg13cmos5l_decap_8_2031 VSS VDD sg13cmos5l_decap_8
Xsg13cmos5l_decap_8_2075 VSS VDD sg13cmos5l_decap_8
Xsg13cmos5l_decap_8_2086 VSS VDD sg13cmos5l_decap_8
Xsg13cmos5l_decap_8_2064 VSS VDD sg13cmos5l_decap_8
Xsg13cmos5l_decap_8_1330 VSS VDD sg13cmos5l_decap_8
Xsg13cmos5l_decap_8_1341 VSS VDD sg13cmos5l_decap_8
Xsg13cmos5l_decap_8_2097 VSS VDD sg13cmos5l_decap_8
Xsg13cmos5l_decap_8_1352 VSS VDD sg13cmos5l_decap_8
Xsg13cmos5l_decap_8_1385 VSS VDD sg13cmos5l_decap_8
Xsg13cmos5l_decap_8_1374 VSS VDD sg13cmos5l_decap_8
Xsg13cmos5l_decap_8_1363 VSS VDD sg13cmos5l_decap_8
Xsg13cmos5l_decap_8_1396 VSS VDD sg13cmos5l_decap_8
Xsg13cmos5l_decap_8_1160 VSS VDD sg13cmos5l_decap_8
Xsg13cmos5l_decap_8_1182 VSS VDD sg13cmos5l_decap_8
Xsg13cmos5l_decap_8_1193 VSS VDD sg13cmos5l_decap_8
Xsg13cmos5l_decap_8_1171 VSS VDD sg13cmos5l_decap_8
Xsg13cmos5l_decap_8_718 VSS VDD sg13cmos5l_decap_8
Xsg13cmos5l_decap_8_707 VSS VDD sg13cmos5l_decap_8
Xsg13cmos5l_decap_8_729 VSS VDD sg13cmos5l_decap_8
Xsg13cmos5l_decap_8_3309 VSS VDD sg13cmos5l_decap_8
Xsg13cmos5l_decap_8_2619 VSS VDD sg13cmos5l_decap_8
Xsg13cmos5l_decap_8_2608 VSS VDD sg13cmos5l_decap_8
Xsg13cmos5l_decap_8_1907 VSS VDD sg13cmos5l_decap_8
Xsg13cmos5l_decap_8_1918 VSS VDD sg13cmos5l_decap_8
Xsg13cmos5l_decap_8_1929 VSS VDD sg13cmos5l_decap_8
Xsg13cmos5l_decap_8_504 VSS VDD sg13cmos5l_decap_8
Xsg13cmos5l_decap_8_515 VSS VDD sg13cmos5l_decap_8
Xsg13cmos5l_decap_8_537 VSS VDD sg13cmos5l_decap_8
Xsg13cmos5l_decap_8_526 VSS VDD sg13cmos5l_decap_8
Xsg13cmos5l_decap_8_559 VSS VDD sg13cmos5l_decap_8
Xsg13cmos5l_decap_8_548 VSS VDD sg13cmos5l_decap_8
Xsg13cmos5l_decap_8_3128 VSS VDD sg13cmos5l_decap_8
Xsg13cmos5l_decap_8_3139 VSS VDD sg13cmos5l_decap_8
Xsg13cmos5l_decap_8_3117 VSS VDD sg13cmos5l_decap_8
Xsg13cmos5l_decap_8_3106 VSS VDD sg13cmos5l_decap_8
Xsg13cmos5l_decap_8_2427 VSS VDD sg13cmos5l_decap_8
Xsg13cmos5l_decap_8_2416 VSS VDD sg13cmos5l_decap_8
Xsg13cmos5l_decap_8_2405 VSS VDD sg13cmos5l_decap_8
Xsg13cmos5l_decap_8_2438 VSS VDD sg13cmos5l_decap_8
Xsg13cmos5l_decap_8_2449 VSS VDD sg13cmos5l_decap_8
Xsg13cmos5l_decap_8_1704 VSS VDD sg13cmos5l_decap_8
Xsg13cmos5l_decap_8_1715 VSS VDD sg13cmos5l_decap_8
Xsg13cmos5l_decap_8_1748 VSS VDD sg13cmos5l_decap_8
Xsg13cmos5l_decap_8_1737 VSS VDD sg13cmos5l_decap_8
Xsg13cmos5l_decap_8_1726 VSS VDD sg13cmos5l_decap_8
Xsg13cmos5l_decap_8_1759 VSS VDD sg13cmos5l_decap_8
Xsg13cmos5l_decap_8_2950 VSS VDD sg13cmos5l_decap_8
Xsg13cmos5l_decap_8_2983 VSS VDD sg13cmos5l_decap_8
Xsg13cmos5l_decap_8_2972 VSS VDD sg13cmos5l_decap_8
Xsg13cmos5l_decap_8_2961 VSS VDD sg13cmos5l_decap_8
Xsg13cmos5l_decap_8_2994 VSS VDD sg13cmos5l_decap_8
Xsg13cmos5l_decap_8_301 VSS VDD sg13cmos5l_decap_8
Xsg13cmos5l_decap_8_312 VSS VDD sg13cmos5l_decap_8
Xsg13cmos5l_decap_8_334 VSS VDD sg13cmos5l_decap_8
Xsg13cmos5l_decap_8_345 VSS VDD sg13cmos5l_decap_8
Xsg13cmos5l_decap_8_323 VSS VDD sg13cmos5l_decap_8
Xsg13cmos5l_decap_8_356 VSS VDD sg13cmos5l_decap_8
Xsg13cmos5l_decap_8_367 VSS VDD sg13cmos5l_decap_8
Xsg13cmos5l_decap_8_378 VSS VDD sg13cmos5l_decap_8
Xsg13cmos5l_decap_8_389 VSS VDD sg13cmos5l_decap_8
Xsg13cmos5l_decap_8_23 VSS VDD sg13cmos5l_decap_8
Xsg13cmos5l_decap_8_12 VSS VDD sg13cmos5l_decap_8
Xsg13cmos5l_decap_8_34 VSS VDD sg13cmos5l_decap_8
Xsg13cmos5l_decap_8_45 VSS VDD sg13cmos5l_decap_8
Xsg13cmos5l_decap_8_56 VSS VDD sg13cmos5l_decap_8
Xsg13cmos5l_decap_8_67 VSS VDD sg13cmos5l_decap_8
Xsg13cmos5l_decap_8_89 VSS VDD sg13cmos5l_decap_8
Xsg13cmos5l_decap_8_78 VSS VDD sg13cmos5l_decap_8
Xsg13cmos5l_decap_8_2202 VSS VDD sg13cmos5l_decap_8
Xsg13cmos5l_decap_8_2224 VSS VDD sg13cmos5l_decap_8
Xsg13cmos5l_decap_8_2235 VSS VDD sg13cmos5l_decap_8
Xsg13cmos5l_decap_8_2213 VSS VDD sg13cmos5l_decap_8
Xsg13cmos5l_decap_8_2257 VSS VDD sg13cmos5l_decap_8
Xsg13cmos5l_decap_8_2268 VSS VDD sg13cmos5l_decap_8
Xsg13cmos5l_decap_8_2279 VSS VDD sg13cmos5l_decap_8
Xsg13cmos5l_decap_8_1523 VSS VDD sg13cmos5l_decap_8
Xsg13cmos5l_decap_8_1534 VSS VDD sg13cmos5l_decap_8
Xsg13cmos5l_decap_8_1501 VSS VDD sg13cmos5l_decap_8
Xsg13cmos5l_decap_8_1512 VSS VDD sg13cmos5l_decap_8
Xsg13cmos5l_decap_8_2246 VSS VDD sg13cmos5l_decap_8
Xsg13cmos5l_decap_8_1567 VSS VDD sg13cmos5l_decap_8
Xsg13cmos5l_decap_8_1556 VSS VDD sg13cmos5l_decap_8
Xsg13cmos5l_decap_8_1545 VSS VDD sg13cmos5l_decap_8
Xsg13cmos5l_decap_8_1589 VSS VDD sg13cmos5l_decap_8
Xsg13cmos5l_decap_8_1578 VSS VDD sg13cmos5l_decap_8
Xsg13cmos5l_decap_8_890 VSS VDD sg13cmos5l_decap_8
Xsg13cmos5l_decap_8_3470 VSS VDD sg13cmos5l_decap_8
Xsg13cmos5l_decap_8_3492 VSS VDD sg13cmos5l_decap_8
Xsg13cmos5l_decap_8_3481 VSS VDD sg13cmos5l_decap_8
Xsg13cmos5l_decap_8_2791 VSS VDD sg13cmos5l_decap_8
Xsg13cmos5l_decap_8_2780 VSS VDD sg13cmos5l_decap_8
Xsg13cmos5l_decap_8_1 VSS VDD sg13cmos5l_decap_8
Xsg13cmos5l_decap_8_120 VSS VDD sg13cmos5l_decap_8
Xsg13cmos5l_decap_8_142 VSS VDD sg13cmos5l_decap_8
Xsg13cmos5l_decap_8_153 VSS VDD sg13cmos5l_decap_8
Xsg13cmos5l_decap_8_131 VSS VDD sg13cmos5l_decap_8
Xsg13cmos5l_decap_8_175 VSS VDD sg13cmos5l_decap_8
Xsg13cmos5l_decap_8_197 VSS VDD sg13cmos5l_decap_8
Xsg13cmos5l_decap_8_186 VSS VDD sg13cmos5l_decap_8
Xsg13cmos5l_decap_8_164 VSS VDD sg13cmos5l_decap_8
Xsg13cmos5l_decap_8_2010 VSS VDD sg13cmos5l_decap_8
Xsg13cmos5l_decap_8_2043 VSS VDD sg13cmos5l_decap_8
Xsg13cmos5l_decap_8_2032 VSS VDD sg13cmos5l_decap_8
Xsg13cmos5l_decap_8_2021 VSS VDD sg13cmos5l_decap_8
Xsg13cmos5l_decap_8_2087 VSS VDD sg13cmos5l_decap_8
Xsg13cmos5l_decap_8_2076 VSS VDD sg13cmos5l_decap_8
Xsg13cmos5l_decap_8_2054 VSS VDD sg13cmos5l_decap_8
Xsg13cmos5l_decap_8_2065 VSS VDD sg13cmos5l_decap_8
Xsg13cmos5l_decap_8_1331 VSS VDD sg13cmos5l_decap_8
Xsg13cmos5l_decap_8_1342 VSS VDD sg13cmos5l_decap_8
Xsg13cmos5l_decap_8_1320 VSS VDD sg13cmos5l_decap_8
Xsg13cmos5l_decap_8_2098 VSS VDD sg13cmos5l_decap_8
Xsg13cmos5l_decap_8_1353 VSS VDD sg13cmos5l_decap_8
Xsg13cmos5l_decap_8_1375 VSS VDD sg13cmos5l_decap_8
Xsg13cmos5l_decap_8_1364 VSS VDD sg13cmos5l_decap_8
Xsg13cmos5l_decap_8_1386 VSS VDD sg13cmos5l_decap_8
Xsg13cmos5l_decap_8_1397 VSS VDD sg13cmos5l_decap_8
Xsg13cmos5l_decap_8_1150 VSS VDD sg13cmos5l_decap_8
Xsg13cmos5l_decap_8_1161 VSS VDD sg13cmos5l_decap_8
Xsg13cmos5l_decap_8_1183 VSS VDD sg13cmos5l_decap_8
Xsg13cmos5l_decap_8_1172 VSS VDD sg13cmos5l_decap_8
Xsg13cmos5l_decap_8_1194 VSS VDD sg13cmos5l_decap_8
Xsg13cmos5l_decap_8_719 VSS VDD sg13cmos5l_decap_8
Xsg13cmos5l_decap_8_708 VSS VDD sg13cmos5l_decap_8
Xsg13cmos5l_decap_8_2609 VSS VDD sg13cmos5l_decap_8
Xsg13cmos5l_decap_8_1908 VSS VDD sg13cmos5l_decap_8
Xsg13cmos5l_decap_8_1919 VSS VDD sg13cmos5l_decap_8
Xsg13cmos5l_decap_8_516 VSS VDD sg13cmos5l_decap_8
Xsg13cmos5l_decap_8_527 VSS VDD sg13cmos5l_decap_8
Xsg13cmos5l_decap_8_505 VSS VDD sg13cmos5l_decap_8
Xsg13cmos5l_decap_8_549 VSS VDD sg13cmos5l_decap_8
Xsg13cmos5l_decap_8_538 VSS VDD sg13cmos5l_decap_8
Xsg13cmos5l_decap_8_3129 VSS VDD sg13cmos5l_decap_8
Xsg13cmos5l_decap_8_3118 VSS VDD sg13cmos5l_decap_8
Xsg13cmos5l_decap_8_3107 VSS VDD sg13cmos5l_decap_8
Xsg13cmos5l_decap_8_2428 VSS VDD sg13cmos5l_decap_8
Xsg13cmos5l_decap_8_2406 VSS VDD sg13cmos5l_decap_8
Xsg13cmos5l_decap_8_2417 VSS VDD sg13cmos5l_decap_8
Xsg13cmos5l_decap_8_2439 VSS VDD sg13cmos5l_decap_8
Xsg13cmos5l_decap_8_1716 VSS VDD sg13cmos5l_decap_8
Xsg13cmos5l_decap_8_1705 VSS VDD sg13cmos5l_decap_8
Xsg13cmos5l_decap_8_1749 VSS VDD sg13cmos5l_decap_8
Xsg13cmos5l_decap_8_1738 VSS VDD sg13cmos5l_decap_8
Xsg13cmos5l_decap_8_1727 VSS VDD sg13cmos5l_decap_8
Xsg13cmos5l_decap_8_2940 VSS VDD sg13cmos5l_decap_8
Xsg13cmos5l_decap_8_2951 VSS VDD sg13cmos5l_decap_8
Xsg13cmos5l_decap_8_2962 VSS VDD sg13cmos5l_decap_8
Xsg13cmos5l_decap_8_2973 VSS VDD sg13cmos5l_decap_8
Xsg13cmos5l_decap_8_2995 VSS VDD sg13cmos5l_decap_8
Xsg13cmos5l_decap_8_2984 VSS VDD sg13cmos5l_decap_8
Xsg13cmos5l_decap_8_302 VSS VDD sg13cmos5l_decap_8
Xsg13cmos5l_decap_8_346 VSS VDD sg13cmos5l_decap_8
Xsg13cmos5l_decap_8_335 VSS VDD sg13cmos5l_decap_8
Xsg13cmos5l_decap_8_324 VSS VDD sg13cmos5l_decap_8
Xsg13cmos5l_decap_8_313 VSS VDD sg13cmos5l_decap_8
Xsg13cmos5l_decap_8_357 VSS VDD sg13cmos5l_decap_8
Xsg13cmos5l_decap_8_368 VSS VDD sg13cmos5l_decap_8
Xsg13cmos5l_decap_8_379 VSS VDD sg13cmos5l_decap_8
Xsg13cmos5l_decap_8_13 VSS VDD sg13cmos5l_decap_8
Xsg13cmos5l_decap_8_24 VSS VDD sg13cmos5l_decap_8
Xsg13cmos5l_decap_8_46 VSS VDD sg13cmos5l_decap_8
Xsg13cmos5l_decap_8_35 VSS VDD sg13cmos5l_decap_8
Xsg13cmos5l_decap_8_57 VSS VDD sg13cmos5l_decap_8
Xsg13cmos5l_decap_8_68 VSS VDD sg13cmos5l_decap_8
Xsg13cmos5l_decap_8_79 VSS VDD sg13cmos5l_decap_8
Xsg13cmos5l_decap_8_2203 VSS VDD sg13cmos5l_decap_8
Xsg13cmos5l_decap_8_2214 VSS VDD sg13cmos5l_decap_8
Xsg13cmos5l_decap_8_2225 VSS VDD sg13cmos5l_decap_8
Xsg13cmos5l_decap_8_2236 VSS VDD sg13cmos5l_decap_8
Xsg13cmos5l_decap_8_2258 VSS VDD sg13cmos5l_decap_8
Xsg13cmos5l_decap_8_2269 VSS VDD sg13cmos5l_decap_8
Xsg13cmos5l_decap_8_1524 VSS VDD sg13cmos5l_decap_8
Xsg13cmos5l_decap_8_1513 VSS VDD sg13cmos5l_decap_8
Xsg13cmos5l_decap_8_1502 VSS VDD sg13cmos5l_decap_8
Xsg13cmos5l_decap_8_2247 VSS VDD sg13cmos5l_decap_8
Xsg13cmos5l_decap_8_1557 VSS VDD sg13cmos5l_decap_8
Xsg13cmos5l_decap_8_1535 VSS VDD sg13cmos5l_decap_8
Xsg13cmos5l_decap_8_1546 VSS VDD sg13cmos5l_decap_8
Xsg13cmos5l_decap_8_1579 VSS VDD sg13cmos5l_decap_8
Xsg13cmos5l_decap_8_1568 VSS VDD sg13cmos5l_decap_8
Xsg13cmos5l_decap_8_880 VSS VDD sg13cmos5l_decap_8
Xsg13cmos5l_decap_8_891 VSS VDD sg13cmos5l_decap_8
Xsg13cmos5l_decap_8_3460 VSS VDD sg13cmos5l_decap_8
Xsg13cmos5l_decap_8_3493 VSS VDD sg13cmos5l_decap_8
Xsg13cmos5l_decap_8_3471 VSS VDD sg13cmos5l_decap_8
Xsg13cmos5l_decap_8_3482 VSS VDD sg13cmos5l_decap_8
Xsg13cmos5l_decap_8_2792 VSS VDD sg13cmos5l_decap_8
Xsg13cmos5l_decap_8_2781 VSS VDD sg13cmos5l_decap_8
Xsg13cmos5l_decap_8_2770 VSS VDD sg13cmos5l_decap_8
Xsg13cmos5l_decap_8_2 VSS VDD sg13cmos5l_decap_8
Xsg13cmos5l_decap_8_110 VSS VDD sg13cmos5l_decap_8
Xsg13cmos5l_decap_8_121 VSS VDD sg13cmos5l_decap_8
Xsg13cmos5l_decap_8_132 VSS VDD sg13cmos5l_decap_8
Xsg13cmos5l_decap_8_143 VSS VDD sg13cmos5l_decap_8
Xsg13cmos5l_decap_8_154 VSS VDD sg13cmos5l_decap_8
Xsg13cmos5l_decap_8_176 VSS VDD sg13cmos5l_decap_8
Xsg13cmos5l_decap_8_165 VSS VDD sg13cmos5l_decap_8
Xsg13cmos5l_decap_8_187 VSS VDD sg13cmos5l_decap_8
Xsg13cmos5l_decap_8_198 VSS VDD sg13cmos5l_decap_8
Xsg13cmos5l_decap_8_2011 VSS VDD sg13cmos5l_decap_8
Xsg13cmos5l_decap_8_2000 VSS VDD sg13cmos5l_decap_8
Xsg13cmos5l_decap_8_2044 VSS VDD sg13cmos5l_decap_8
Xsg13cmos5l_decap_8_2033 VSS VDD sg13cmos5l_decap_8
Xsg13cmos5l_decap_8_2022 VSS VDD sg13cmos5l_decap_8
Xsg13cmos5l_decap_8_2077 VSS VDD sg13cmos5l_decap_8
Xsg13cmos5l_decap_8_2055 VSS VDD sg13cmos5l_decap_8
Xsg13cmos5l_decap_8_2066 VSS VDD sg13cmos5l_decap_8
Xsg13cmos5l_decap_8_1332 VSS VDD sg13cmos5l_decap_8
Xsg13cmos5l_decap_8_1310 VSS VDD sg13cmos5l_decap_8
Xsg13cmos5l_decap_8_1321 VSS VDD sg13cmos5l_decap_8
Xsg13cmos5l_decap_8_2088 VSS VDD sg13cmos5l_decap_8
Xsg13cmos5l_decap_8_2099 VSS VDD sg13cmos5l_decap_8
Xsg13cmos5l_decap_8_1343 VSS VDD sg13cmos5l_decap_8
Xsg13cmos5l_decap_8_1376 VSS VDD sg13cmos5l_decap_8
Xsg13cmos5l_decap_8_1354 VSS VDD sg13cmos5l_decap_8
Xsg13cmos5l_decap_8_1365 VSS VDD sg13cmos5l_decap_8
Xsg13cmos5l_decap_8_1398 VSS VDD sg13cmos5l_decap_8
Xsg13cmos5l_decap_8_1387 VSS VDD sg13cmos5l_decap_8
Xsg13cmos5l_decap_8_3290 VSS VDD sg13cmos5l_decap_8
Xsg13cmos5l_decap_8_1151 VSS VDD sg13cmos5l_decap_8
Xsg13cmos5l_decap_8_1140 VSS VDD sg13cmos5l_decap_8
Xsg13cmos5l_decap_8_1184 VSS VDD sg13cmos5l_decap_8
Xsg13cmos5l_decap_8_1162 VSS VDD sg13cmos5l_decap_8
Xsg13cmos5l_decap_8_1173 VSS VDD sg13cmos5l_decap_8
Xsg13cmos5l_decap_8_1195 VSS VDD sg13cmos5l_decap_8
Xsg13cmos5l_decap_8_709 VSS VDD sg13cmos5l_decap_8
Xsg13cmos5l_decap_8_1909 VSS VDD sg13cmos5l_decap_8
Xsg13cmos5l_decap_8_517 VSS VDD sg13cmos5l_decap_8
Xsg13cmos5l_decap_8_506 VSS VDD sg13cmos5l_decap_8
Xsg13cmos5l_decap_8_528 VSS VDD sg13cmos5l_decap_8
Xsg13cmos5l_decap_8_539 VSS VDD sg13cmos5l_decap_8
Xsg13cmos5l_decap_8_3108 VSS VDD sg13cmos5l_decap_8
Xsg13cmos5l_decap_8_3119 VSS VDD sg13cmos5l_decap_8
Xsg13cmos5l_decap_8_2418 VSS VDD sg13cmos5l_decap_8
Xsg13cmos5l_decap_8_2407 VSS VDD sg13cmos5l_decap_8
Xsg13cmos5l_decap_8_2429 VSS VDD sg13cmos5l_decap_8
Xsg13cmos5l_decap_8_1706 VSS VDD sg13cmos5l_decap_8
Xsg13cmos5l_decap_8_1728 VSS VDD sg13cmos5l_decap_8
Xsg13cmos5l_decap_8_1739 VSS VDD sg13cmos5l_decap_8
Xsg13cmos5l_decap_8_1717 VSS VDD sg13cmos5l_decap_8
Xsg13cmos5l_decap_8_2930 VSS VDD sg13cmos5l_decap_8
Xsg13cmos5l_decap_8_2941 VSS VDD sg13cmos5l_decap_8
Xsg13cmos5l_decap_8_2952 VSS VDD sg13cmos5l_decap_8
Xsg13cmos5l_decap_8_2974 VSS VDD sg13cmos5l_decap_8
Xsg13cmos5l_decap_8_2963 VSS VDD sg13cmos5l_decap_8
Xsg13cmos5l_decap_8_2985 VSS VDD sg13cmos5l_decap_8
Xsg13cmos5l_decap_8_2996 VSS VDD sg13cmos5l_decap_8
Xsg13cmos5l_decap_8_303 VSS VDD sg13cmos5l_decap_8
Xsg13cmos5l_decap_8_336 VSS VDD sg13cmos5l_decap_8
Xsg13cmos5l_decap_8_325 VSS VDD sg13cmos5l_decap_8
Xsg13cmos5l_decap_8_314 VSS VDD sg13cmos5l_decap_8
Xsg13cmos5l_decap_8_369 VSS VDD sg13cmos5l_decap_8
Xsg13cmos5l_decap_8_347 VSS VDD sg13cmos5l_decap_8
Xsg13cmos5l_decap_8_358 VSS VDD sg13cmos5l_decap_8
Xsg13cmos5l_decap_8_14 VSS VDD sg13cmos5l_decap_8
Xsg13cmos5l_decap_8_25 VSS VDD sg13cmos5l_decap_8
Xsg13cmos5l_decap_8_36 VSS VDD sg13cmos5l_decap_8
Xsg13cmos5l_decap_8_47 VSS VDD sg13cmos5l_decap_8
Xsg13cmos5l_decap_8_58 VSS VDD sg13cmos5l_decap_8
Xsg13cmos5l_decap_8_69 VSS VDD sg13cmos5l_decap_8
Xsg13cmos5l_decap_8_2204 VSS VDD sg13cmos5l_decap_8
Xsg13cmos5l_decap_8_2226 VSS VDD sg13cmos5l_decap_8
Xsg13cmos5l_decap_8_2215 VSS VDD sg13cmos5l_decap_8
Xsg13cmos5l_decap_8_2259 VSS VDD sg13cmos5l_decap_8
Xsg13cmos5l_decap_8_1525 VSS VDD sg13cmos5l_decap_8
Xsg13cmos5l_decap_8_1514 VSS VDD sg13cmos5l_decap_8
Xsg13cmos5l_decap_8_1503 VSS VDD sg13cmos5l_decap_8
Xsg13cmos5l_decap_8_2237 VSS VDD sg13cmos5l_decap_8
Xsg13cmos5l_decap_8_2248 VSS VDD sg13cmos5l_decap_8
Xsg13cmos5l_decap_8_1558 VSS VDD sg13cmos5l_decap_8
Xsg13cmos5l_decap_8_1536 VSS VDD sg13cmos5l_decap_8
Xsg13cmos5l_decap_8_1547 VSS VDD sg13cmos5l_decap_8
Xsg13cmos5l_decap_8_1569 VSS VDD sg13cmos5l_decap_8
Xsg13cmos5l_decap_8_881 VSS VDD sg13cmos5l_decap_8
Xsg13cmos5l_decap_8_892 VSS VDD sg13cmos5l_decap_8
Xsg13cmos5l_decap_8_870 VSS VDD sg13cmos5l_decap_8
Xsg13cmos5l_decap_8_3450 VSS VDD sg13cmos5l_decap_8
Xsg13cmos5l_decap_8_3472 VSS VDD sg13cmos5l_decap_8
Xsg13cmos5l_decap_8_3494 VSS VDD sg13cmos5l_decap_8
Xsg13cmos5l_decap_8_3461 VSS VDD sg13cmos5l_decap_8
Xsg13cmos5l_decap_8_3483 VSS VDD sg13cmos5l_decap_8
Xsg13cmos5l_decap_8_2782 VSS VDD sg13cmos5l_decap_8
Xsg13cmos5l_decap_8_2771 VSS VDD sg13cmos5l_decap_8
Xsg13cmos5l_decap_8_2760 VSS VDD sg13cmos5l_decap_8
Xsg13cmos5l_decap_8_2793 VSS VDD sg13cmos5l_decap_8
Xsg13cmos5l_decap_8_3 VSS VDD sg13cmos5l_decap_8
Xsg13cmos5l_decap_8_111 VSS VDD sg13cmos5l_decap_8
Xsg13cmos5l_decap_8_100 VSS VDD sg13cmos5l_decap_8
Xsg13cmos5l_decap_8_133 VSS VDD sg13cmos5l_decap_8
Xsg13cmos5l_decap_8_144 VSS VDD sg13cmos5l_decap_8
Xsg13cmos5l_decap_8_122 VSS VDD sg13cmos5l_decap_8
Xsg13cmos5l_decap_8_177 VSS VDD sg13cmos5l_decap_8
Xsg13cmos5l_decap_8_155 VSS VDD sg13cmos5l_decap_8
Xsg13cmos5l_decap_8_166 VSS VDD sg13cmos5l_decap_8
Xsg13cmos5l_decap_8_188 VSS VDD sg13cmos5l_decap_8
Xsg13cmos5l_decap_8_199 VSS VDD sg13cmos5l_decap_8
Xsg13cmos5l_decap_8_2001 VSS VDD sg13cmos5l_decap_8
Xsg13cmos5l_decap_8_2034 VSS VDD sg13cmos5l_decap_8
Xsg13cmos5l_decap_8_2012 VSS VDD sg13cmos5l_decap_8
Xsg13cmos5l_decap_8_1300 VSS VDD sg13cmos5l_decap_8
Xsg13cmos5l_decap_8_2023 VSS VDD sg13cmos5l_decap_8
Xsg13cmos5l_decap_8_2078 VSS VDD sg13cmos5l_decap_8
Xsg13cmos5l_decap_8_2056 VSS VDD sg13cmos5l_decap_8
Xsg13cmos5l_decap_8_2067 VSS VDD sg13cmos5l_decap_8
Xsg13cmos5l_decap_8_2045 VSS VDD sg13cmos5l_decap_8
Xsg13cmos5l_decap_8_1333 VSS VDD sg13cmos5l_decap_8
Xsg13cmos5l_decap_8_1311 VSS VDD sg13cmos5l_decap_8
Xsg13cmos5l_decap_8_1322 VSS VDD sg13cmos5l_decap_8
Xsg13cmos5l_decap_8_2089 VSS VDD sg13cmos5l_decap_8
Xsg13cmos5l_decap_8_1344 VSS VDD sg13cmos5l_decap_8
Xsg13cmos5l_decap_8_1355 VSS VDD sg13cmos5l_decap_8
Xsg13cmos5l_decap_8_1366 VSS VDD sg13cmos5l_decap_8
Xsg13cmos5l_decap_8_1388 VSS VDD sg13cmos5l_decap_8
Xsg13cmos5l_decap_8_1399 VSS VDD sg13cmos5l_decap_8
Xsg13cmos5l_decap_8_1377 VSS VDD sg13cmos5l_decap_8
Xsg13cmos5l_decap_8_3291 VSS VDD sg13cmos5l_decap_8
Xsg13cmos5l_decap_8_3280 VSS VDD sg13cmos5l_decap_8
Xsg13cmos5l_decap_8_2590 VSS VDD sg13cmos5l_decap_8
Xsg13cmos5l_decap_8_1141 VSS VDD sg13cmos5l_decap_8
Xsg13cmos5l_decap_8_1130 VSS VDD sg13cmos5l_decap_8
Xsg13cmos5l_decap_8_1152 VSS VDD sg13cmos5l_decap_8
Xsg13cmos5l_decap_8_1163 VSS VDD sg13cmos5l_decap_8
Xsg13cmos5l_decap_8_1174 VSS VDD sg13cmos5l_decap_8
Xsg13cmos5l_decap_8_1196 VSS VDD sg13cmos5l_decap_8
Xsg13cmos5l_decap_8_1185 VSS VDD sg13cmos5l_decap_8
Xsg13cmos5l_decap_8_518 VSS VDD sg13cmos5l_decap_8
Xsg13cmos5l_decap_8_507 VSS VDD sg13cmos5l_decap_8
Xsg13cmos5l_decap_8_529 VSS VDD sg13cmos5l_decap_8
Xsg13cmos5l_decap_8_3109 VSS VDD sg13cmos5l_decap_8
Xsg13cmos5l_decap_8_2419 VSS VDD sg13cmos5l_decap_8
Xsg13cmos5l_decap_8_2408 VSS VDD sg13cmos5l_decap_8
Xsg13cmos5l_decap_8_1707 VSS VDD sg13cmos5l_decap_8
Xsg13cmos5l_decap_8_1729 VSS VDD sg13cmos5l_decap_8
Xsg13cmos5l_decap_8_1718 VSS VDD sg13cmos5l_decap_8
Xsg13cmos5l_decap_8_2920 VSS VDD sg13cmos5l_decap_8
Xsg13cmos5l_decap_8_2931 VSS VDD sg13cmos5l_decap_8
Xsg13cmos5l_decap_8_2953 VSS VDD sg13cmos5l_decap_8
Xsg13cmos5l_decap_8_2964 VSS VDD sg13cmos5l_decap_8
Xsg13cmos5l_decap_8_2942 VSS VDD sg13cmos5l_decap_8
Xsg13cmos5l_decap_8_2986 VSS VDD sg13cmos5l_decap_8
Xsg13cmos5l_decap_8_2997 VSS VDD sg13cmos5l_decap_8
Xsg13cmos5l_decap_8_2975 VSS VDD sg13cmos5l_decap_8
Xsg13cmos5l_decap_8_326 VSS VDD sg13cmos5l_decap_8
Xsg13cmos5l_decap_8_337 VSS VDD sg13cmos5l_decap_8
Xsg13cmos5l_decap_8_315 VSS VDD sg13cmos5l_decap_8
Xsg13cmos5l_decap_8_304 VSS VDD sg13cmos5l_decap_8
Xsg13cmos5l_decap_8_359 VSS VDD sg13cmos5l_decap_8
Xsg13cmos5l_decap_8_348 VSS VDD sg13cmos5l_decap_8
Xsg13cmos5l_decap_8_15 VSS VDD sg13cmos5l_decap_8
Xsg13cmos5l_decap_8_26 VSS VDD sg13cmos5l_decap_8
Xsg13cmos5l_decap_8_37 VSS VDD sg13cmos5l_decap_8
Xsg13cmos5l_decap_8_48 VSS VDD sg13cmos5l_decap_8
Xsg13cmos5l_decap_8_59 VSS VDD sg13cmos5l_decap_8
Xsg13cmos5l_decap_8_2205 VSS VDD sg13cmos5l_decap_8
Xsg13cmos5l_decap_8_2216 VSS VDD sg13cmos5l_decap_8
Xsg13cmos5l_decap_8_2227 VSS VDD sg13cmos5l_decap_8
Xsg13cmos5l_decap_8_1515 VSS VDD sg13cmos5l_decap_8
Xsg13cmos5l_decap_8_1504 VSS VDD sg13cmos5l_decap_8
Xsg13cmos5l_decap_8_2238 VSS VDD sg13cmos5l_decap_8
Xsg13cmos5l_decap_8_2249 VSS VDD sg13cmos5l_decap_8
Xsg13cmos5l_decap_8_1526 VSS VDD sg13cmos5l_decap_8
Xsg13cmos5l_decap_8_1548 VSS VDD sg13cmos5l_decap_8
Xsg13cmos5l_decap_8_1537 VSS VDD sg13cmos5l_decap_8
Xsg13cmos5l_decap_8_1559 VSS VDD sg13cmos5l_decap_8
Xsg13cmos5l_decap_8_882 VSS VDD sg13cmos5l_decap_8
Xsg13cmos5l_decap_8_860 VSS VDD sg13cmos5l_decap_8
Xsg13cmos5l_decap_8_871 VSS VDD sg13cmos5l_decap_8
Xsg13cmos5l_decap_8_893 VSS VDD sg13cmos5l_decap_8
Xsg13cmos5l_decap_8_3451 VSS VDD sg13cmos5l_decap_8
Xsg13cmos5l_decap_8_3440 VSS VDD sg13cmos5l_decap_8
Xsg13cmos5l_decap_8_3473 VSS VDD sg13cmos5l_decap_8
Xsg13cmos5l_decap_8_3462 VSS VDD sg13cmos5l_decap_8
Xsg13cmos5l_decap_8_3484 VSS VDD sg13cmos5l_decap_8
Xsg13cmos5l_decap_8_3495 VSS VDD sg13cmos5l_decap_8
Xsg13cmos5l_decap_8_2772 VSS VDD sg13cmos5l_decap_8
Xsg13cmos5l_decap_8_2783 VSS VDD sg13cmos5l_decap_8
Xsg13cmos5l_decap_8_2761 VSS VDD sg13cmos5l_decap_8
Xsg13cmos5l_decap_8_2750 VSS VDD sg13cmos5l_decap_8
Xsg13cmos5l_decap_8_2794 VSS VDD sg13cmos5l_decap_8
Xsg13cmos5l_decap_8_4 VSS VDD sg13cmos5l_decap_8
Xsg13cmos5l_decap_8_101 VSS VDD sg13cmos5l_decap_8
Xsg13cmos5l_decap_8_145 VSS VDD sg13cmos5l_decap_8
Xsg13cmos5l_decap_8_134 VSS VDD sg13cmos5l_decap_8
Xsg13cmos5l_decap_8_123 VSS VDD sg13cmos5l_decap_8
Xsg13cmos5l_decap_8_112 VSS VDD sg13cmos5l_decap_8
Xsg13cmos5l_decap_8_178 VSS VDD sg13cmos5l_decap_8
Xsg13cmos5l_decap_8_156 VSS VDD sg13cmos5l_decap_8
Xsg13cmos5l_decap_8_167 VSS VDD sg13cmos5l_decap_8
Xsg13cmos5l_decap_8_189 VSS VDD sg13cmos5l_decap_8
Xsg13cmos5l_decap_8_2002 VSS VDD sg13cmos5l_decap_8
Xsg13cmos5l_decap_8_2035 VSS VDD sg13cmos5l_decap_8
Xsg13cmos5l_decap_8_2013 VSS VDD sg13cmos5l_decap_8
Xsg13cmos5l_decap_8_2024 VSS VDD sg13cmos5l_decap_8
Xsg13cmos5l_decap_8_2057 VSS VDD sg13cmos5l_decap_8
Xsg13cmos5l_decap_8_2068 VSS VDD sg13cmos5l_decap_8
Xsg13cmos5l_decap_8_2046 VSS VDD sg13cmos5l_decap_8
Xsg13cmos5l_decap_8_1312 VSS VDD sg13cmos5l_decap_8
Xsg13cmos5l_decap_8_1301 VSS VDD sg13cmos5l_decap_8
Xsg13cmos5l_decap_8_1323 VSS VDD sg13cmos5l_decap_8
Xsg13cmos5l_decap_8_2079 VSS VDD sg13cmos5l_decap_8
Xsg13cmos5l_decap_8_1345 VSS VDD sg13cmos5l_decap_8
Xsg13cmos5l_decap_8_1367 VSS VDD sg13cmos5l_decap_8
Xsg13cmos5l_decap_8_1356 VSS VDD sg13cmos5l_decap_8
Xsg13cmos5l_decap_8_1334 VSS VDD sg13cmos5l_decap_8
Xsg13cmos5l_decap_8_1389 VSS VDD sg13cmos5l_decap_8
Xsg13cmos5l_decap_8_1378 VSS VDD sg13cmos5l_decap_8
Xsg13cmos5l_decap_8_690 VSS VDD sg13cmos5l_decap_8
Xsg13cmos5l_decap_8_3270 VSS VDD sg13cmos5l_decap_8
Xsg13cmos5l_decap_8_3281 VSS VDD sg13cmos5l_decap_8
Xsg13cmos5l_decap_8_3292 VSS VDD sg13cmos5l_decap_8
Xsg13cmos5l_decap_8_2591 VSS VDD sg13cmos5l_decap_8
Xsg13cmos5l_decap_8_2580 VSS VDD sg13cmos5l_decap_8
Xsg13cmos5l_decap_8_1890 VSS VDD sg13cmos5l_decap_8
Xsg13cmos5l_decap_8_1120 VSS VDD sg13cmos5l_decap_8
Xsg13cmos5l_decap_8_1142 VSS VDD sg13cmos5l_decap_8
Xsg13cmos5l_decap_8_1131 VSS VDD sg13cmos5l_decap_8
Xsg13cmos5l_decap_8_1153 VSS VDD sg13cmos5l_decap_8
Xsg13cmos5l_decap_8_1164 VSS VDD sg13cmos5l_decap_8
Xsg13cmos5l_decap_8_1175 VSS VDD sg13cmos5l_decap_8
Xsg13cmos5l_decap_8_1197 VSS VDD sg13cmos5l_decap_8
Xsg13cmos5l_decap_8_1186 VSS VDD sg13cmos5l_decap_8
Xsg13cmos5l_decap_8_508 VSS VDD sg13cmos5l_decap_8
Xsg13cmos5l_decap_8_519 VSS VDD sg13cmos5l_decap_8
Xsg13cmos5l_decap_8_2409 VSS VDD sg13cmos5l_decap_8
Xsg13cmos5l_decap_8_1708 VSS VDD sg13cmos5l_decap_8
Xsg13cmos5l_decap_8_1719 VSS VDD sg13cmos5l_decap_8
Xsg13cmos5l_decap_8_2910 VSS VDD sg13cmos5l_decap_8
Xsg13cmos5l_decap_8_2921 VSS VDD sg13cmos5l_decap_8
Xsg13cmos5l_decap_8_2932 VSS VDD sg13cmos5l_decap_8
Xsg13cmos5l_decap_8_2965 VSS VDD sg13cmos5l_decap_8
Xsg13cmos5l_decap_8_2943 VSS VDD sg13cmos5l_decap_8
Xsg13cmos5l_decap_8_2954 VSS VDD sg13cmos5l_decap_8
Xsg13cmos5l_decap_8_2998 VSS VDD sg13cmos5l_decap_8
Xsg13cmos5l_decap_8_2987 VSS VDD sg13cmos5l_decap_8
Xsg13cmos5l_decap_8_2976 VSS VDD sg13cmos5l_decap_8
Xsg13cmos5l_decap_8_327 VSS VDD sg13cmos5l_decap_8
Xsg13cmos5l_decap_8_316 VSS VDD sg13cmos5l_decap_8
Xsg13cmos5l_decap_8_305 VSS VDD sg13cmos5l_decap_8
Xsg13cmos5l_decap_8_349 VSS VDD sg13cmos5l_decap_8
Xsg13cmos5l_decap_8_338 VSS VDD sg13cmos5l_decap_8
Xsg13cmos5l_decap_8_38 VSS VDD sg13cmos5l_decap_8
Xsg13cmos5l_decap_8_16 VSS VDD sg13cmos5l_decap_8
Xsg13cmos5l_decap_8_27 VSS VDD sg13cmos5l_decap_8
Xsg13cmos5l_decap_8_49 VSS VDD sg13cmos5l_decap_8
Xsg13cmos5l_decap_8_2206 VSS VDD sg13cmos5l_decap_8
Xsg13cmos5l_decap_8_2217 VSS VDD sg13cmos5l_decap_8
Xsg13cmos5l_decap_8_1516 VSS VDD sg13cmos5l_decap_8
Xsg13cmos5l_decap_8_1505 VSS VDD sg13cmos5l_decap_8
Xsg13cmos5l_decap_8_2228 VSS VDD sg13cmos5l_decap_8
Xsg13cmos5l_decap_8_2239 VSS VDD sg13cmos5l_decap_8
Xsg13cmos5l_decap_8_1538 VSS VDD sg13cmos5l_decap_8
Xsg13cmos5l_decap_8_1527 VSS VDD sg13cmos5l_decap_8
Xsg13cmos5l_decap_8_1549 VSS VDD sg13cmos5l_decap_8
Xsg13cmos5l_decap_8_850 VSS VDD sg13cmos5l_decap_8
Xsg13cmos5l_decap_8_883 VSS VDD sg13cmos5l_decap_8
Xsg13cmos5l_decap_8_861 VSS VDD sg13cmos5l_decap_8
Xsg13cmos5l_decap_8_872 VSS VDD sg13cmos5l_decap_8
Xsg13cmos5l_decap_8_894 VSS VDD sg13cmos5l_decap_8
Xsg13cmos5l_decap_8_3430 VSS VDD sg13cmos5l_decap_8
Xsg13cmos5l_decap_8_3441 VSS VDD sg13cmos5l_decap_8
Xsg13cmos5l_decap_8_3474 VSS VDD sg13cmos5l_decap_8
Xsg13cmos5l_decap_8_3452 VSS VDD sg13cmos5l_decap_8
Xsg13cmos5l_decap_8_3463 VSS VDD sg13cmos5l_decap_8
Xsg13cmos5l_decap_8_3485 VSS VDD sg13cmos5l_decap_8
Xsg13cmos5l_decap_8_2740 VSS VDD sg13cmos5l_decap_8
Xsg13cmos5l_decap_8_3496 VSS VDD sg13cmos5l_decap_8
Xsg13cmos5l_decap_8_2762 VSS VDD sg13cmos5l_decap_8
Xsg13cmos5l_decap_8_2773 VSS VDD sg13cmos5l_decap_8
Xsg13cmos5l_decap_8_2751 VSS VDD sg13cmos5l_decap_8
Xsg13cmos5l_decap_8_2795 VSS VDD sg13cmos5l_decap_8
Xsg13cmos5l_decap_8_2784 VSS VDD sg13cmos5l_decap_8
Xsg13cmos5l_decap_8_5 VSS VDD sg13cmos5l_decap_8
Xsg13cmos5l_decap_8_102 VSS VDD sg13cmos5l_decap_8
Xsg13cmos5l_decap_8_135 VSS VDD sg13cmos5l_decap_8
Xsg13cmos5l_decap_8_124 VSS VDD sg13cmos5l_decap_8
Xsg13cmos5l_decap_8_113 VSS VDD sg13cmos5l_decap_8
Xsg13cmos5l_decap_8_179 VSS VDD sg13cmos5l_decap_8
Xsg13cmos5l_decap_8_146 VSS VDD sg13cmos5l_decap_8
Xsg13cmos5l_decap_8_157 VSS VDD sg13cmos5l_decap_8
Xsg13cmos5l_decap_8_168 VSS VDD sg13cmos5l_decap_8
Xsg13cmos5l_decap_8_2014 VSS VDD sg13cmos5l_decap_8
Xsg13cmos5l_decap_8_2003 VSS VDD sg13cmos5l_decap_8
Xsg13cmos5l_decap_8_2025 VSS VDD sg13cmos5l_decap_8
Xsg13cmos5l_decap_8_2058 VSS VDD sg13cmos5l_decap_8
Xsg13cmos5l_decap_8_2069 VSS VDD sg13cmos5l_decap_8
Xsg13cmos5l_decap_8_2036 VSS VDD sg13cmos5l_decap_8
Xsg13cmos5l_decap_8_2047 VSS VDD sg13cmos5l_decap_8
Xsg13cmos5l_decap_8_1324 VSS VDD sg13cmos5l_decap_8
Xsg13cmos5l_decap_8_1313 VSS VDD sg13cmos5l_decap_8
Xsg13cmos5l_decap_8_1302 VSS VDD sg13cmos5l_decap_8
Xsg13cmos5l_decap_8_1335 VSS VDD sg13cmos5l_decap_8
Xsg13cmos5l_decap_8_1346 VSS VDD sg13cmos5l_decap_8
Xsg13cmos5l_decap_8_1357 VSS VDD sg13cmos5l_decap_8
Xsg13cmos5l_decap_8_1379 VSS VDD sg13cmos5l_decap_8
Xsg13cmos5l_decap_8_1368 VSS VDD sg13cmos5l_decap_8
Xsg13cmos5l_decap_8_680 VSS VDD sg13cmos5l_decap_8
Xsg13cmos5l_decap_8_691 VSS VDD sg13cmos5l_decap_8
Xsg13cmos5l_decap_8_3260 VSS VDD sg13cmos5l_decap_8
Xsg13cmos5l_decap_8_3282 VSS VDD sg13cmos5l_decap_8
Xsg13cmos5l_decap_8_3293 VSS VDD sg13cmos5l_decap_8
Xsg13cmos5l_decap_8_3271 VSS VDD sg13cmos5l_decap_8
Xsg13cmos5l_decap_8_2581 VSS VDD sg13cmos5l_decap_8
Xsg13cmos5l_decap_8_2570 VSS VDD sg13cmos5l_decap_8
Xsg13cmos5l_decap_8_2592 VSS VDD sg13cmos5l_decap_8
Xsg13cmos5l_decap_8_1880 VSS VDD sg13cmos5l_decap_8
Xsg13cmos5l_decap_8_1891 VSS VDD sg13cmos5l_decap_8
Xsg13cmos5l_decap_8_1110 VSS VDD sg13cmos5l_decap_8
Xsg13cmos5l_decap_8_1121 VSS VDD sg13cmos5l_decap_8
Xsg13cmos5l_decap_8_1132 VSS VDD sg13cmos5l_decap_8
Xsg13cmos5l_decap_8_1143 VSS VDD sg13cmos5l_decap_8
Xsg13cmos5l_decap_8_1154 VSS VDD sg13cmos5l_decap_8
Xsg13cmos5l_decap_8_1165 VSS VDD sg13cmos5l_decap_8
Xsg13cmos5l_decap_8_1198 VSS VDD sg13cmos5l_decap_8
Xsg13cmos5l_decap_8_1187 VSS VDD sg13cmos5l_decap_8
Xsg13cmos5l_decap_8_1176 VSS VDD sg13cmos5l_decap_8
Xsg13cmos5l_decap_8_3090 VSS VDD sg13cmos5l_decap_8
Xsg13cmos5l_decap_8_509 VSS VDD sg13cmos5l_decap_8
Xsg13cmos5l_decap_8_1709 VSS VDD sg13cmos5l_decap_8
Xsg13cmos5l_IOPadIOVss_0 IOVDD VSS VDD IOVDD sg13cmos5l_IOPadIOVss
Xsg13cmos5l_decap_8_2922 VSS VDD sg13cmos5l_decap_8
Xsg13cmos5l_decap_8_2900 VSS VDD sg13cmos5l_decap_8
Xsg13cmos5l_decap_8_2911 VSS VDD sg13cmos5l_decap_8
Xsg13cmos5l_decap_8_2955 VSS VDD sg13cmos5l_decap_8
Xsg13cmos5l_decap_8_2944 VSS VDD sg13cmos5l_decap_8
Xsg13cmos5l_decap_8_2933 VSS VDD sg13cmos5l_decap_8
Xsg13cmos5l_decap_8_2966 VSS VDD sg13cmos5l_decap_8
Xsg13cmos5l_decap_8_2977 VSS VDD sg13cmos5l_decap_8
Xsg13cmos5l_decap_8_2988 VSS VDD sg13cmos5l_decap_8
Xsg13cmos5l_decap_8_2999 VSS VDD sg13cmos5l_decap_8
Xsg13cmos5l_decap_8_328 VSS VDD sg13cmos5l_decap_8
Xsg13cmos5l_decap_8_306 VSS VDD sg13cmos5l_decap_8
Xsg13cmos5l_decap_8_317 VSS VDD sg13cmos5l_decap_8
Xsg13cmos5l_decap_8_339 VSS VDD sg13cmos5l_decap_8
Xsg13cmos5l_decap_8_17 VSS VDD sg13cmos5l_decap_8
Xsg13cmos5l_decap_8_28 VSS VDD sg13cmos5l_decap_8
Xsg13cmos5l_decap_8_39 VSS VDD sg13cmos5l_decap_8
Xsg13cmos5l_decap_8_2207 VSS VDD sg13cmos5l_decap_8
Xsg13cmos5l_decap_8_2218 VSS VDD sg13cmos5l_decap_8
Xsg13cmos5l_decap_8_1506 VSS VDD sg13cmos5l_decap_8
Xsg13cmos5l_decap_8_2229 VSS VDD sg13cmos5l_decap_8
Xsg13cmos5l_decap_8_1528 VSS VDD sg13cmos5l_decap_8
Xsg13cmos5l_decap_8_1517 VSS VDD sg13cmos5l_decap_8
Xsg13cmos5l_decap_8_1539 VSS VDD sg13cmos5l_decap_8
Xsg13cmos5l_decap_8_840 VSS VDD sg13cmos5l_decap_8
Xsg13cmos5l_decap_8_862 VSS VDD sg13cmos5l_decap_8
Xsg13cmos5l_decap_8_851 VSS VDD sg13cmos5l_decap_8
Xsg13cmos5l_decap_8_873 VSS VDD sg13cmos5l_decap_8
Xsg13cmos5l_decap_8_895 VSS VDD sg13cmos5l_decap_8
Xsg13cmos5l_decap_8_884 VSS VDD sg13cmos5l_decap_8
Xsg13cmos5l_decap_8_3431 VSS VDD sg13cmos5l_decap_8
Xsg13cmos5l_decap_8_3442 VSS VDD sg13cmos5l_decap_8
Xsg13cmos5l_decap_8_3420 VSS VDD sg13cmos5l_decap_8
Xsg13cmos5l_decap_8_3464 VSS VDD sg13cmos5l_decap_8
Xsg13cmos5l_decap_8_3475 VSS VDD sg13cmos5l_decap_8
Xsg13cmos5l_decap_8_3453 VSS VDD sg13cmos5l_decap_8
Xsg13cmos5l_decap_8_2730 VSS VDD sg13cmos5l_decap_8
Xsg13cmos5l_decap_8_3497 VSS VDD sg13cmos5l_decap_8
Xsg13cmos5l_decap_8_3486 VSS VDD sg13cmos5l_decap_8
Xsg13cmos5l_decap_8_2763 VSS VDD sg13cmos5l_decap_8
Xsg13cmos5l_decap_8_2774 VSS VDD sg13cmos5l_decap_8
Xsg13cmos5l_decap_8_2741 VSS VDD sg13cmos5l_decap_8
Xsg13cmos5l_decap_8_2752 VSS VDD sg13cmos5l_decap_8
Xsg13cmos5l_decap_8_2785 VSS VDD sg13cmos5l_decap_8
Xsg13cmos5l_decap_8_2796 VSS VDD sg13cmos5l_decap_8
Xsg13cmos5l_decap_8_6 VSS VDD sg13cmos5l_decap_8
Xsg13cmos5l_decap_8_114 VSS VDD sg13cmos5l_decap_8
Xsg13cmos5l_decap_8_136 VSS VDD sg13cmos5l_decap_8
Xsg13cmos5l_decap_8_125 VSS VDD sg13cmos5l_decap_8
Xsg13cmos5l_decap_8_103 VSS VDD sg13cmos5l_decap_8
Xsg13cmos5l_decap_8_147 VSS VDD sg13cmos5l_decap_8
Xsg13cmos5l_decap_8_169 VSS VDD sg13cmos5l_decap_8
Xsg13cmos5l_decap_8_158 VSS VDD sg13cmos5l_decap_8
Xsg13cmos5l_decap_8_2015 VSS VDD sg13cmos5l_decap_8
Xsg13cmos5l_decap_8_2004 VSS VDD sg13cmos5l_decap_8
Xsg13cmos5l_decap_8_2026 VSS VDD sg13cmos5l_decap_8
Xsg13cmos5l_decap_8_2059 VSS VDD sg13cmos5l_decap_8
Xsg13cmos5l_decap_8_2037 VSS VDD sg13cmos5l_decap_8
Xsg13cmos5l_decap_8_2048 VSS VDD sg13cmos5l_decap_8
Xsg13cmos5l_decap_8_1303 VSS VDD sg13cmos5l_decap_8
Xsg13cmos5l_decap_8_1314 VSS VDD sg13cmos5l_decap_8
Xsg13cmos5l_decap_8_1347 VSS VDD sg13cmos5l_decap_8
Xsg13cmos5l_decap_8_1336 VSS VDD sg13cmos5l_decap_8
Xsg13cmos5l_decap_8_1325 VSS VDD sg13cmos5l_decap_8
Xsg13cmos5l_decap_8_1358 VSS VDD sg13cmos5l_decap_8
Xsg13cmos5l_decap_8_1369 VSS VDD sg13cmos5l_decap_8
Xsg13cmos5l_decap_8_692 VSS VDD sg13cmos5l_decap_8
Xsg13cmos5l_decap_8_670 VSS VDD sg13cmos5l_decap_8
Xsg13cmos5l_decap_8_681 VSS VDD sg13cmos5l_decap_8
Xsg13cmos5l_decap_8_3250 VSS VDD sg13cmos5l_decap_8
Xsg13cmos5l_decap_8_3261 VSS VDD sg13cmos5l_decap_8
Xsg13cmos5l_decap_8_3283 VSS VDD sg13cmos5l_decap_8
Xsg13cmos5l_decap_8_3272 VSS VDD sg13cmos5l_decap_8
Xsg13cmos5l_decap_8_3294 VSS VDD sg13cmos5l_decap_8
Xsg13cmos5l_decap_8_2560 VSS VDD sg13cmos5l_decap_8
Xsg13cmos5l_decap_8_2571 VSS VDD sg13cmos5l_decap_8
Xsg13cmos5l_decap_8_2582 VSS VDD sg13cmos5l_decap_8
Xsg13cmos5l_decap_8_2593 VSS VDD sg13cmos5l_decap_8
Xsg13cmos5l_decap_8_1870 VSS VDD sg13cmos5l_decap_8
Xsg13cmos5l_decap_8_1881 VSS VDD sg13cmos5l_decap_8
Xsg13cmos5l_decap_8_1892 VSS VDD sg13cmos5l_decap_8
Xsg13cmos5l_decap_8_1111 VSS VDD sg13cmos5l_decap_8
Xsg13cmos5l_decap_8_1133 VSS VDD sg13cmos5l_decap_8
Xsg13cmos5l_decap_8_1100 VSS VDD sg13cmos5l_decap_8
Xsg13cmos5l_decap_8_1122 VSS VDD sg13cmos5l_decap_8
Xsg13cmos5l_decap_8_1144 VSS VDD sg13cmos5l_decap_8
Xsg13cmos5l_decap_8_1155 VSS VDD sg13cmos5l_decap_8
Xsg13cmos5l_decap_8_1166 VSS VDD sg13cmos5l_decap_8
Xsg13cmos5l_decap_8_1199 VSS VDD sg13cmos5l_decap_8
Xsg13cmos5l_decap_8_1188 VSS VDD sg13cmos5l_decap_8
Xsg13cmos5l_decap_8_1177 VSS VDD sg13cmos5l_decap_8
Xsg13cmos5l_decap_8_3080 VSS VDD sg13cmos5l_decap_8
Xsg13cmos5l_decap_8_3091 VSS VDD sg13cmos5l_decap_8
Xsg13cmos5l_decap_8_2390 VSS VDD sg13cmos5l_decap_8
Xsg13cmos5l_decap_4_0 VSS VDD sg13cmos5l_decap_4
Xsg13cmos5l_IOPadIOVss_1 IOVDD VSS VDD IOVDD sg13cmos5l_IOPadIOVss
Xsg13cmos5l_decap_8_2923 VSS VDD sg13cmos5l_decap_8
Xsg13cmos5l_decap_8_2901 VSS VDD sg13cmos5l_decap_8
Xsg13cmos5l_decap_8_2912 VSS VDD sg13cmos5l_decap_8
Xsg13cmos5l_decap_8_2934 VSS VDD sg13cmos5l_decap_8
Xsg13cmos5l_decap_8_2945 VSS VDD sg13cmos5l_decap_8
Xsg13cmos5l_decap_8_2956 VSS VDD sg13cmos5l_decap_8
Xsg13cmos5l_decap_8_2989 VSS VDD sg13cmos5l_decap_8
Xsg13cmos5l_decap_8_2967 VSS VDD sg13cmos5l_decap_8
Xsg13cmos5l_decap_8_2978 VSS VDD sg13cmos5l_decap_8
Xsg13cmos5l_decap_8_318 VSS VDD sg13cmos5l_decap_8
Xsg13cmos5l_decap_8_307 VSS VDD sg13cmos5l_decap_8
Xsg13cmos5l_decap_8_329 VSS VDD sg13cmos5l_decap_8
Xsg13cmos5l_decap_8_18 VSS VDD sg13cmos5l_decap_8
Xsg13cmos5l_decap_8_29 VSS VDD sg13cmos5l_decap_8
Xsg13cmos5l_decap_8_2208 VSS VDD sg13cmos5l_decap_8
Xsg13cmos5l_decap_8_1507 VSS VDD sg13cmos5l_decap_8
Xsg13cmos5l_decap_8_2219 VSS VDD sg13cmos5l_decap_8
Xsg13cmos5l_decap_8_1518 VSS VDD sg13cmos5l_decap_8
Xsg13cmos5l_decap_8_1529 VSS VDD sg13cmos5l_decap_8
Xsg13cmos5l_decap_8_841 VSS VDD sg13cmos5l_decap_8
Xsg13cmos5l_decap_8_830 VSS VDD sg13cmos5l_decap_8
Xsg13cmos5l_decap_8_852 VSS VDD sg13cmos5l_decap_8
Xsg13cmos5l_decap_8_863 VSS VDD sg13cmos5l_decap_8
Xsg13cmos5l_decap_8_874 VSS VDD sg13cmos5l_decap_8
Xsg13cmos5l_decap_8_896 VSS VDD sg13cmos5l_decap_8
Xsg13cmos5l_decap_8_885 VSS VDD sg13cmos5l_decap_8
Xsg13cmos5l_decap_8_3432 VSS VDD sg13cmos5l_decap_8
Xsg13cmos5l_decap_8_3410 VSS VDD sg13cmos5l_decap_8
Xsg13cmos5l_decap_8_3421 VSS VDD sg13cmos5l_decap_8
Xsg13cmos5l_decap_8_3476 VSS VDD sg13cmos5l_decap_8
Xsg13cmos5l_decap_8_3465 VSS VDD sg13cmos5l_decap_8
Xsg13cmos5l_decap_8_3443 VSS VDD sg13cmos5l_decap_8
Xsg13cmos5l_decap_8_3454 VSS VDD sg13cmos5l_decap_8
Xsg13cmos5l_decap_8_2731 VSS VDD sg13cmos5l_decap_8
Xsg13cmos5l_decap_8_2720 VSS VDD sg13cmos5l_decap_8
Xsg13cmos5l_decap_8_3498 VSS VDD sg13cmos5l_decap_8
Xsg13cmos5l_decap_8_3487 VSS VDD sg13cmos5l_decap_8
Xsg13cmos5l_decap_8_2764 VSS VDD sg13cmos5l_decap_8
Xsg13cmos5l_decap_8_2742 VSS VDD sg13cmos5l_decap_8
Xsg13cmos5l_decap_8_2753 VSS VDD sg13cmos5l_decap_8
Xsg13cmos5l_decap_8_2786 VSS VDD sg13cmos5l_decap_8
Xsg13cmos5l_decap_8_2775 VSS VDD sg13cmos5l_decap_8
Xsg13cmos5l_decap_8_2797 VSS VDD sg13cmos5l_decap_8
Xsg13cmos5l_decap_8_7 VSS VDD sg13cmos5l_decap_8
Xsg13cmos5l_decap_8_126 VSS VDD sg13cmos5l_decap_8
Xsg13cmos5l_decap_8_115 VSS VDD sg13cmos5l_decap_8
Xsg13cmos5l_decap_8_104 VSS VDD sg13cmos5l_decap_8
Xsg13cmos5l_decap_8_137 VSS VDD sg13cmos5l_decap_8
Xsg13cmos5l_decap_8_148 VSS VDD sg13cmos5l_decap_8
Xsg13cmos5l_decap_8_159 VSS VDD sg13cmos5l_decap_8
Xsg13cmos5l_decap_8_2016 VSS VDD sg13cmos5l_decap_8
Xsg13cmos5l_decap_8_2005 VSS VDD sg13cmos5l_decap_8
Xsg13cmos5l_decap_8_2049 VSS VDD sg13cmos5l_decap_8
Xsg13cmos5l_decap_8_2038 VSS VDD sg13cmos5l_decap_8
Xsg13cmos5l_decap_8_2027 VSS VDD sg13cmos5l_decap_8
Xsg13cmos5l_decap_8_1304 VSS VDD sg13cmos5l_decap_8
Xsg13cmos5l_decap_8_1315 VSS VDD sg13cmos5l_decap_8
Xsg13cmos5l_decap_8_1348 VSS VDD sg13cmos5l_decap_8
Xsg13cmos5l_decap_8_1326 VSS VDD sg13cmos5l_decap_8
Xsg13cmos5l_decap_8_1337 VSS VDD sg13cmos5l_decap_8
Xsg13cmos5l_decap_8_1359 VSS VDD sg13cmos5l_decap_8
Xsg13cmos5l_decap_8_671 VSS VDD sg13cmos5l_decap_8
Xsg13cmos5l_decap_8_682 VSS VDD sg13cmos5l_decap_8
Xsg13cmos5l_decap_8_660 VSS VDD sg13cmos5l_decap_8
Xsg13cmos5l_decap_8_693 VSS VDD sg13cmos5l_decap_8
Xsg13cmos5l_decap_8_3240 VSS VDD sg13cmos5l_decap_8
Xsg13cmos5l_decap_8_3251 VSS VDD sg13cmos5l_decap_8
Xsg13cmos5l_decap_8_3262 VSS VDD sg13cmos5l_decap_8
Xsg13cmos5l_decap_8_3284 VSS VDD sg13cmos5l_decap_8
Xsg13cmos5l_decap_8_3273 VSS VDD sg13cmos5l_decap_8
Xsg13cmos5l_decap_8_3295 VSS VDD sg13cmos5l_decap_8
Xsg13cmos5l_decap_8_2561 VSS VDD sg13cmos5l_decap_8
Xsg13cmos5l_decap_8_2572 VSS VDD sg13cmos5l_decap_8
Xsg13cmos5l_decap_8_2550 VSS VDD sg13cmos5l_decap_8
Xsg13cmos5l_decap_8_2594 VSS VDD sg13cmos5l_decap_8
Xsg13cmos5l_decap_8_2583 VSS VDD sg13cmos5l_decap_8
Xsg13cmos5l_decap_8_1860 VSS VDD sg13cmos5l_decap_8
Xsg13cmos5l_decap_8_1871 VSS VDD sg13cmos5l_decap_8
Xsg13cmos5l_decap_8_1882 VSS VDD sg13cmos5l_decap_8
Xsg13cmos5l_decap_8_1893 VSS VDD sg13cmos5l_decap_8
Xsg13cmos5l_decap_8_1123 VSS VDD sg13cmos5l_decap_8
Xsg13cmos5l_decap_8_1112 VSS VDD sg13cmos5l_decap_8
Xsg13cmos5l_decap_8_1101 VSS VDD sg13cmos5l_decap_8
Xsg13cmos5l_decap_8_1145 VSS VDD sg13cmos5l_decap_8
Xsg13cmos5l_decap_8_1156 VSS VDD sg13cmos5l_decap_8
Xsg13cmos5l_decap_8_1134 VSS VDD sg13cmos5l_decap_8
Xsg13cmos5l_decap_8_1189 VSS VDD sg13cmos5l_decap_8
Xsg13cmos5l_decap_8_1178 VSS VDD sg13cmos5l_decap_8
Xsg13cmos5l_decap_8_1167 VSS VDD sg13cmos5l_decap_8
Xsg13cmos5l_decap_8_490 VSS VDD sg13cmos5l_decap_8
Xsg13cmos5l_decap_8_3092 VSS VDD sg13cmos5l_decap_8
Xsg13cmos5l_decap_8_3070 VSS VDD sg13cmos5l_decap_8
Xsg13cmos5l_decap_8_3081 VSS VDD sg13cmos5l_decap_8
Xsg13cmos5l_decap_8_2380 VSS VDD sg13cmos5l_decap_8
Xsg13cmos5l_decap_8_2391 VSS VDD sg13cmos5l_decap_8
Xsg13cmos5l_decap_8_1690 VSS VDD sg13cmos5l_decap_8
Xsg13cmos5l_decap_4_1 VSS VDD sg13cmos5l_decap_4
Xsg13cmos5l_decap_8_2902 VSS VDD sg13cmos5l_decap_8
Xsg13cmos5l_decap_8_2913 VSS VDD sg13cmos5l_decap_8
Xsg13cmos5l_decap_8_2924 VSS VDD sg13cmos5l_decap_8
Xsg13cmos5l_decap_8_2946 VSS VDD sg13cmos5l_decap_8
Xsg13cmos5l_decap_8_2935 VSS VDD sg13cmos5l_decap_8
Xsg13cmos5l_decap_8_2979 VSS VDD sg13cmos5l_decap_8
Xsg13cmos5l_decap_8_2957 VSS VDD sg13cmos5l_decap_8
Xsg13cmos5l_decap_8_2968 VSS VDD sg13cmos5l_decap_8
Xsg13cmos5l_decap_8_319 VSS VDD sg13cmos5l_decap_8
Xsg13cmos5l_decap_8_308 VSS VDD sg13cmos5l_decap_8
Xsg13cmos5l_decap_8_19 VSS VDD sg13cmos5l_decap_8
Xsg13cmos5l_decap_8_2209 VSS VDD sg13cmos5l_decap_8
Xsg13cmos5l_decap_8_1519 VSS VDD sg13cmos5l_decap_8
Xsg13cmos5l_decap_8_1508 VSS VDD sg13cmos5l_decap_8
Xsg13cmos5l_decap_8_820 VSS VDD sg13cmos5l_decap_8
Xsg13cmos5l_decap_8_831 VSS VDD sg13cmos5l_decap_8
Xsg13cmos5l_decap_8_842 VSS VDD sg13cmos5l_decap_8
Xsg13cmos5l_decap_8_853 VSS VDD sg13cmos5l_decap_8
Xsg13cmos5l_decap_8_864 VSS VDD sg13cmos5l_decap_8
Xsg13cmos5l_decap_8_897 VSS VDD sg13cmos5l_decap_8
Xsg13cmos5l_decap_8_886 VSS VDD sg13cmos5l_decap_8
Xsg13cmos5l_decap_8_875 VSS VDD sg13cmos5l_decap_8
Xsg13cmos5l_decap_8_3400 VSS VDD sg13cmos5l_decap_8
Xsg13cmos5l_decap_8_3411 VSS VDD sg13cmos5l_decap_8
Xsg13cmos5l_decap_8_3433 VSS VDD sg13cmos5l_decap_8
Xsg13cmos5l_decap_8_3422 VSS VDD sg13cmos5l_decap_8
Xsg13cmos5l_decap_8_3466 VSS VDD sg13cmos5l_decap_8
Xsg13cmos5l_decap_8_3444 VSS VDD sg13cmos5l_decap_8
Xsg13cmos5l_decap_8_3455 VSS VDD sg13cmos5l_decap_8
Xsg13cmos5l_decap_8_2721 VSS VDD sg13cmos5l_decap_8
Xsg13cmos5l_decap_8_2710 VSS VDD sg13cmos5l_decap_8
Xsg13cmos5l_decap_8_3499 VSS VDD sg13cmos5l_decap_8
Xsg13cmos5l_decap_8_3477 VSS VDD sg13cmos5l_decap_8
Xsg13cmos5l_decap_8_3488 VSS VDD sg13cmos5l_decap_8
Xsg13cmos5l_decap_8_2765 VSS VDD sg13cmos5l_decap_8
Xsg13cmos5l_decap_8_2732 VSS VDD sg13cmos5l_decap_8
Xsg13cmos5l_decap_8_2743 VSS VDD sg13cmos5l_decap_8
Xsg13cmos5l_decap_8_2754 VSS VDD sg13cmos5l_decap_8
Xsg13cmos5l_decap_8_2787 VSS VDD sg13cmos5l_decap_8
Xsg13cmos5l_decap_8_2776 VSS VDD sg13cmos5l_decap_8
Xsg13cmos5l_decap_8_2798 VSS VDD sg13cmos5l_decap_8
Xsg13cmos5l_decap_8_8 VSS VDD sg13cmos5l_decap_8
Xsg13cmos5l_decap_8_127 VSS VDD sg13cmos5l_decap_8
Xsg13cmos5l_decap_8_105 VSS VDD sg13cmos5l_decap_8
Xsg13cmos5l_decap_8_116 VSS VDD sg13cmos5l_decap_8
Xsg13cmos5l_decap_8_138 VSS VDD sg13cmos5l_decap_8
Xsg13cmos5l_decap_8_149 VSS VDD sg13cmos5l_decap_8
Xsg13cmos5l_decap_8_2017 VSS VDD sg13cmos5l_decap_8
Xsg13cmos5l_decap_8_2006 VSS VDD sg13cmos5l_decap_8
Xsg13cmos5l_decap_8_2039 VSS VDD sg13cmos5l_decap_8
Xsg13cmos5l_decap_8_2028 VSS VDD sg13cmos5l_decap_8
Xsg13cmos5l_decap_8_1305 VSS VDD sg13cmos5l_decap_8
Xsg13cmos5l_decap_8_1327 VSS VDD sg13cmos5l_decap_8
Xsg13cmos5l_decap_8_1349 VSS VDD sg13cmos5l_decap_8
Xsg13cmos5l_decap_8_1338 VSS VDD sg13cmos5l_decap_8
Xsg13cmos5l_decap_8_1316 VSS VDD sg13cmos5l_decap_8
Xsg13cmos5l_decap_8_672 VSS VDD sg13cmos5l_decap_8
Xsg13cmos5l_decap_8_683 VSS VDD sg13cmos5l_decap_8
Xsg13cmos5l_decap_8_661 VSS VDD sg13cmos5l_decap_8
Xsg13cmos5l_decap_8_650 VSS VDD sg13cmos5l_decap_8
Xsg13cmos5l_decap_8_694 VSS VDD sg13cmos5l_decap_8
Xsg13cmos5l_decap_8_3230 VSS VDD sg13cmos5l_decap_8
Xsg13cmos5l_decap_8_3241 VSS VDD sg13cmos5l_decap_8
Xsg13cmos5l_decap_8_3263 VSS VDD sg13cmos5l_decap_8
Xsg13cmos5l_decap_8_3274 VSS VDD sg13cmos5l_decap_8
Xsg13cmos5l_decap_8_3252 VSS VDD sg13cmos5l_decap_8
Xsg13cmos5l_decap_8_3296 VSS VDD sg13cmos5l_decap_8
Xsg13cmos5l_decap_8_3285 VSS VDD sg13cmos5l_decap_8
Xsg13cmos5l_decap_8_2562 VSS VDD sg13cmos5l_decap_8
Xsg13cmos5l_decap_8_2573 VSS VDD sg13cmos5l_decap_8
Xsg13cmos5l_decap_8_2551 VSS VDD sg13cmos5l_decap_8
Xsg13cmos5l_decap_8_2540 VSS VDD sg13cmos5l_decap_8
Xsg13cmos5l_decap_8_2595 VSS VDD sg13cmos5l_decap_8
Xsg13cmos5l_decap_8_2584 VSS VDD sg13cmos5l_decap_8
Xsg13cmos5l_decap_8_1861 VSS VDD sg13cmos5l_decap_8
Xsg13cmos5l_decap_8_1850 VSS VDD sg13cmos5l_decap_8
Xsg13cmos5l_decap_8_1872 VSS VDD sg13cmos5l_decap_8
Xsg13cmos5l_decap_8_1883 VSS VDD sg13cmos5l_decap_8
Xsg13cmos5l_decap_8_1894 VSS VDD sg13cmos5l_decap_8
Xsg13cmos5l_IOPadIOVdd_0 VSS VDD VSS IOVDD sg13cmos5l_IOPadIOVdd
Xsg13cmos5l_decap_8_1113 VSS VDD sg13cmos5l_decap_8
Xsg13cmos5l_decap_8_1102 VSS VDD sg13cmos5l_decap_8
Xsg13cmos5l_decap_8_1124 VSS VDD sg13cmos5l_decap_8
Xsg13cmos5l_decap_8_1157 VSS VDD sg13cmos5l_decap_8
Xsg13cmos5l_decap_8_1146 VSS VDD sg13cmos5l_decap_8
Xsg13cmos5l_decap_8_1135 VSS VDD sg13cmos5l_decap_8
Xsg13cmos5l_decap_8_1179 VSS VDD sg13cmos5l_decap_8
Xsg13cmos5l_decap_8_1168 VSS VDD sg13cmos5l_decap_8
Xsg13cmos5l_decap_8_480 VSS VDD sg13cmos5l_decap_8
Xsg13cmos5l_decap_8_491 VSS VDD sg13cmos5l_decap_8
Xsg13cmos5l_decap_8_3071 VSS VDD sg13cmos5l_decap_8
Xsg13cmos5l_decap_8_3093 VSS VDD sg13cmos5l_decap_8
Xsg13cmos5l_decap_8_3082 VSS VDD sg13cmos5l_decap_8
Xsg13cmos5l_decap_8_3060 VSS VDD sg13cmos5l_decap_8
Xsg13cmos5l_decap_8_2381 VSS VDD sg13cmos5l_decap_8
Xsg13cmos5l_decap_8_2370 VSS VDD sg13cmos5l_decap_8
Xsg13cmos5l_decap_8_2392 VSS VDD sg13cmos5l_decap_8
Xsg13cmos5l_decap_8_1691 VSS VDD sg13cmos5l_decap_8
Xsg13cmos5l_decap_8_1680 VSS VDD sg13cmos5l_decap_8
Xsg13cmos5l_decap_4_2 VSS VDD sg13cmos5l_decap_4
Xsg13cmos5l_decap_8_2914 VSS VDD sg13cmos5l_decap_8
Xsg13cmos5l_decap_8_2903 VSS VDD sg13cmos5l_decap_8
Xsg13cmos5l_decap_8_2947 VSS VDD sg13cmos5l_decap_8
Xsg13cmos5l_decap_8_2925 VSS VDD sg13cmos5l_decap_8
Xsg13cmos5l_decap_8_2936 VSS VDD sg13cmos5l_decap_8
Xsg13cmos5l_decap_8_2969 VSS VDD sg13cmos5l_decap_8
Xsg13cmos5l_decap_8_2958 VSS VDD sg13cmos5l_decap_8
Xsg13cmos5l_decap_8_309 VSS VDD sg13cmos5l_decap_8
Xsg13cmos5l_decap_8_1509 VSS VDD sg13cmos5l_decap_8
Xsg13cmos5l_decap_8_810 VSS VDD sg13cmos5l_decap_8
Xsg13cmos5l_decap_8_821 VSS VDD sg13cmos5l_decap_8
Xsg13cmos5l_decap_8_832 VSS VDD sg13cmos5l_decap_8
Xsg13cmos5l_decap_8_854 VSS VDD sg13cmos5l_decap_8
Xsg13cmos5l_decap_8_843 VSS VDD sg13cmos5l_decap_8
Xsg13cmos5l_decap_8_865 VSS VDD sg13cmos5l_decap_8
Xsg13cmos5l_decap_8_898 VSS VDD sg13cmos5l_decap_8
Xsg13cmos5l_decap_8_876 VSS VDD sg13cmos5l_decap_8
Xsg13cmos5l_decap_8_887 VSS VDD sg13cmos5l_decap_8
Xsg13cmos5l_decap_8_3412 VSS VDD sg13cmos5l_decap_8
Xsg13cmos5l_decap_8_3423 VSS VDD sg13cmos5l_decap_8
Xsg13cmos5l_decap_8_3401 VSS VDD sg13cmos5l_decap_8
Xsg13cmos5l_decap_8_3467 VSS VDD sg13cmos5l_decap_8
Xsg13cmos5l_decap_8_3445 VSS VDD sg13cmos5l_decap_8
Xsg13cmos5l_decap_8_3456 VSS VDD sg13cmos5l_decap_8
Xsg13cmos5l_decap_8_3434 VSS VDD sg13cmos5l_decap_8
Xsg13cmos5l_decap_8_2722 VSS VDD sg13cmos5l_decap_8
Xsg13cmos5l_decap_8_2700 VSS VDD sg13cmos5l_decap_8
Xsg13cmos5l_decap_8_2711 VSS VDD sg13cmos5l_decap_8
Xsg13cmos5l_decap_8_3478 VSS VDD sg13cmos5l_decap_8
Xsg13cmos5l_decap_8_3489 VSS VDD sg13cmos5l_decap_8
Xsg13cmos5l_decap_8_2744 VSS VDD sg13cmos5l_decap_8
Xsg13cmos5l_decap_8_2755 VSS VDD sg13cmos5l_decap_8
Xsg13cmos5l_decap_8_2733 VSS VDD sg13cmos5l_decap_8
Xsg13cmos5l_decap_8_2788 VSS VDD sg13cmos5l_decap_8
Xsg13cmos5l_decap_8_2766 VSS VDD sg13cmos5l_decap_8
Xsg13cmos5l_decap_8_2777 VSS VDD sg13cmos5l_decap_8
Xsg13cmos5l_decap_8_2799 VSS VDD sg13cmos5l_decap_8
Xsg13cmos5l_decap_8_9 VSS VDD sg13cmos5l_decap_8
Xsg13cmos5l_decap_8_117 VSS VDD sg13cmos5l_decap_8
Xsg13cmos5l_decap_8_106 VSS VDD sg13cmos5l_decap_8
Xsg13cmos5l_decap_8_128 VSS VDD sg13cmos5l_decap_8
Xsg13cmos5l_decap_8_139 VSS VDD sg13cmos5l_decap_8
Xsg13cmos5l_decap_8_2007 VSS VDD sg13cmos5l_decap_8
Xsg13cmos5l_decap_8_2018 VSS VDD sg13cmos5l_decap_8
Xsg13cmos5l_decap_8_2029 VSS VDD sg13cmos5l_decap_8
Xsg13cmos5l_decap_8_1306 VSS VDD sg13cmos5l_decap_8
Xsg13cmos5l_decap_8_1339 VSS VDD sg13cmos5l_decap_8
Xsg13cmos5l_decap_8_1328 VSS VDD sg13cmos5l_decap_8
Xsg13cmos5l_decap_8_1317 VSS VDD sg13cmos5l_decap_8
Xsg13cmos5l_decap_8_640 VSS VDD sg13cmos5l_decap_8
Xsg13cmos5l_decap_8_673 VSS VDD sg13cmos5l_decap_8
Xsg13cmos5l_decap_8_662 VSS VDD sg13cmos5l_decap_8
Xsg13cmos5l_decap_8_651 VSS VDD sg13cmos5l_decap_8
Xsg13cmos5l_decap_8_684 VSS VDD sg13cmos5l_decap_8
Xsg13cmos5l_decap_8_695 VSS VDD sg13cmos5l_decap_8
Xsg13cmos5l_decap_8_3231 VSS VDD sg13cmos5l_decap_8
Xsg13cmos5l_decap_8_3220 VSS VDD sg13cmos5l_decap_8
Xsg13cmos5l_decap_8_3253 VSS VDD sg13cmos5l_decap_8
Xsg13cmos5l_decap_8_3242 VSS VDD sg13cmos5l_decap_8
Xsg13cmos5l_decap_8_3264 VSS VDD sg13cmos5l_decap_8
Xsg13cmos5l_decap_8_3275 VSS VDD sg13cmos5l_decap_8
Xsg13cmos5l_decap_8_2530 VSS VDD sg13cmos5l_decap_8
Xsg13cmos5l_decap_8_3286 VSS VDD sg13cmos5l_decap_8
Xsg13cmos5l_decap_8_3297 VSS VDD sg13cmos5l_decap_8
Xsg13cmos5l_decap_8_2541 VSS VDD sg13cmos5l_decap_8
Xsg13cmos5l_decap_8_2552 VSS VDD sg13cmos5l_decap_8
Xsg13cmos5l_decap_8_2563 VSS VDD sg13cmos5l_decap_8
Xsg13cmos5l_decap_8_2596 VSS VDD sg13cmos5l_decap_8
Xsg13cmos5l_decap_8_2585 VSS VDD sg13cmos5l_decap_8
Xsg13cmos5l_decap_8_2574 VSS VDD sg13cmos5l_decap_8
Xsg13cmos5l_decap_8_1862 VSS VDD sg13cmos5l_decap_8
Xsg13cmos5l_decap_8_1840 VSS VDD sg13cmos5l_decap_8
Xsg13cmos5l_decap_8_1851 VSS VDD sg13cmos5l_decap_8
Xsg13cmos5l_decap_8_1873 VSS VDD sg13cmos5l_decap_8
Xsg13cmos5l_decap_8_1895 VSS VDD sg13cmos5l_decap_8
Xsg13cmos5l_decap_8_1884 VSS VDD sg13cmos5l_decap_8
Xsg13cmos5l_decap_4_120 VSS VDD sg13cmos5l_decap_4
Xsg13cmos5l_IOPadIOVdd_1 VSS VDD VSS IOVDD sg13cmos5l_IOPadIOVdd
Xsg13cmos5l_decap_8_1103 VSS VDD sg13cmos5l_decap_8
Xsg13cmos5l_decap_8_1114 VSS VDD sg13cmos5l_decap_8
Xsg13cmos5l_decap_8_1136 VSS VDD sg13cmos5l_decap_8
Xsg13cmos5l_decap_8_1125 VSS VDD sg13cmos5l_decap_8
Xsg13cmos5l_decap_8_1147 VSS VDD sg13cmos5l_decap_8
Xsg13cmos5l_decap_8_1158 VSS VDD sg13cmos5l_decap_8
Xsg13cmos5l_decap_8_1169 VSS VDD sg13cmos5l_decap_8
Xsg13cmos5l_decap_8_470 VSS VDD sg13cmos5l_decap_8
Xsg13cmos5l_decap_8_481 VSS VDD sg13cmos5l_decap_8
Xsg13cmos5l_decap_8_492 VSS VDD sg13cmos5l_decap_8
Xsg13cmos5l_decap_8_3050 VSS VDD sg13cmos5l_decap_8
Xsg13cmos5l_decap_8_3061 VSS VDD sg13cmos5l_decap_8
Xsg13cmos5l_decap_8_3072 VSS VDD sg13cmos5l_decap_8
Xsg13cmos5l_decap_8_3083 VSS VDD sg13cmos5l_decap_8
Xsg13cmos5l_decap_8_3094 VSS VDD sg13cmos5l_decap_8
Xsg13cmos5l_decap_8_2371 VSS VDD sg13cmos5l_decap_8
Xsg13cmos5l_decap_8_2360 VSS VDD sg13cmos5l_decap_8
Xsg13cmos5l_decap_8_2393 VSS VDD sg13cmos5l_decap_8
Xsg13cmos5l_decap_8_2382 VSS VDD sg13cmos5l_decap_8
Xsg13cmos5l_decap_8_1670 VSS VDD sg13cmos5l_decap_8
Xsg13cmos5l_decap_8_1692 VSS VDD sg13cmos5l_decap_8
Xsg13cmos5l_decap_8_1681 VSS VDD sg13cmos5l_decap_8
Xsg13cmos5l_decap_4_3 VSS VDD sg13cmos5l_decap_4
Xsg13cmos5l_decap_8_2190 VSS VDD sg13cmos5l_decap_8
Xsg13cmos5l_decap_8_2904 VSS VDD sg13cmos5l_decap_8
Xsg13cmos5l_decap_8_2915 VSS VDD sg13cmos5l_decap_8
Xsg13cmos5l_decap_8_2937 VSS VDD sg13cmos5l_decap_8
Xsg13cmos5l_decap_8_2926 VSS VDD sg13cmos5l_decap_8
Xsg13cmos5l_decap_8_2948 VSS VDD sg13cmos5l_decap_8
Xsg13cmos5l_decap_8_2959 VSS VDD sg13cmos5l_decap_8
Xsg13cmos5l_decap_8_811 VSS VDD sg13cmos5l_decap_8
Xsg13cmos5l_decap_8_822 VSS VDD sg13cmos5l_decap_8
Xsg13cmos5l_decap_8_800 VSS VDD sg13cmos5l_decap_8
Xsg13cmos5l_decap_8_855 VSS VDD sg13cmos5l_decap_8
Xsg13cmos5l_decap_8_844 VSS VDD sg13cmos5l_decap_8
Xsg13cmos5l_decap_8_833 VSS VDD sg13cmos5l_decap_8
Xsg13cmos5l_decap_8_899 VSS VDD sg13cmos5l_decap_8
Xsg13cmos5l_decap_8_877 VSS VDD sg13cmos5l_decap_8
Xsg13cmos5l_decap_8_888 VSS VDD sg13cmos5l_decap_8
Xsg13cmos5l_decap_8_866 VSS VDD sg13cmos5l_decap_8
Xsg13cmos5l_decap_8_3402 VSS VDD sg13cmos5l_decap_8
Xsg13cmos5l_decap_8_3413 VSS VDD sg13cmos5l_decap_8
Xsg13cmos5l_decap_8_3424 VSS VDD sg13cmos5l_decap_8
Xsg13cmos5l_decap_8_3457 VSS VDD sg13cmos5l_decap_8
Xsg13cmos5l_decap_8_3435 VSS VDD sg13cmos5l_decap_8
Xsg13cmos5l_decap_8_3446 VSS VDD sg13cmos5l_decap_8
Xsg13cmos5l_decap_8_2701 VSS VDD sg13cmos5l_decap_8
Xsg13cmos5l_decap_8_2712 VSS VDD sg13cmos5l_decap_8
Xsg13cmos5l_decap_8_3479 VSS VDD sg13cmos5l_decap_8
Xsg13cmos5l_decap_8_3468 VSS VDD sg13cmos5l_decap_8
Xsg13cmos5l_decap_8_2745 VSS VDD sg13cmos5l_decap_8
Xsg13cmos5l_decap_8_2734 VSS VDD sg13cmos5l_decap_8
Xsg13cmos5l_decap_8_2723 VSS VDD sg13cmos5l_decap_8
Xsg13cmos5l_decap_8_2756 VSS VDD sg13cmos5l_decap_8
Xsg13cmos5l_decap_8_2767 VSS VDD sg13cmos5l_decap_8
Xsg13cmos5l_decap_8_2789 VSS VDD sg13cmos5l_decap_8
Xsg13cmos5l_decap_8_2778 VSS VDD sg13cmos5l_decap_8
Xsg13cmos5l_decap_8_107 VSS VDD sg13cmos5l_decap_8
Xsg13cmos5l_decap_8_118 VSS VDD sg13cmos5l_decap_8
Xsg13cmos5l_decap_8_129 VSS VDD sg13cmos5l_decap_8
Xsg13cmos5l_decap_8_2008 VSS VDD sg13cmos5l_decap_8
Xsg13cmos5l_decap_8_2019 VSS VDD sg13cmos5l_decap_8
Xsg13cmos5l_decap_8_1329 VSS VDD sg13cmos5l_decap_8
Xsg13cmos5l_decap_8_1307 VSS VDD sg13cmos5l_decap_8
Xsg13cmos5l_decap_8_1318 VSS VDD sg13cmos5l_decap_8
Xsg13cmos5l_decap_8_630 VSS VDD sg13cmos5l_decap_8
Xsg13cmos5l_decap_8_674 VSS VDD sg13cmos5l_decap_8
Xsg13cmos5l_decap_8_641 VSS VDD sg13cmos5l_decap_8
Xsg13cmos5l_decap_8_663 VSS VDD sg13cmos5l_decap_8
Xsg13cmos5l_decap_8_652 VSS VDD sg13cmos5l_decap_8
Xsg13cmos5l_decap_8_685 VSS VDD sg13cmos5l_decap_8
Xsg13cmos5l_decap_8_696 VSS VDD sg13cmos5l_decap_8
Xsg13cmos5l_decap_8_3232 VSS VDD sg13cmos5l_decap_8
Xsg13cmos5l_decap_8_3210 VSS VDD sg13cmos5l_decap_8
Xsg13cmos5l_decap_8_3221 VSS VDD sg13cmos5l_decap_8
Xsg13cmos5l_decap_8_3254 VSS VDD sg13cmos5l_decap_8
Xsg13cmos5l_decap_8_3243 VSS VDD sg13cmos5l_decap_8
Xsg13cmos5l_decap_8_3265 VSS VDD sg13cmos5l_decap_8
Xsg13cmos5l_decap_8_2520 VSS VDD sg13cmos5l_decap_8
Xsg13cmos5l_decap_8_3287 VSS VDD sg13cmos5l_decap_8
Xsg13cmos5l_decap_8_3276 VSS VDD sg13cmos5l_decap_8
Xsg13cmos5l_decap_8_3298 VSS VDD sg13cmos5l_decap_8
Xsg13cmos5l_decap_8_2542 VSS VDD sg13cmos5l_decap_8
Xsg13cmos5l_decap_8_2553 VSS VDD sg13cmos5l_decap_8
Xsg13cmos5l_decap_8_2564 VSS VDD sg13cmos5l_decap_8
Xsg13cmos5l_decap_8_2531 VSS VDD sg13cmos5l_decap_8
Xsg13cmos5l_decap_8_2586 VSS VDD sg13cmos5l_decap_8
Xsg13cmos5l_decap_8_2597 VSS VDD sg13cmos5l_decap_8
Xsg13cmos5l_decap_8_2575 VSS VDD sg13cmos5l_decap_8
Xsg13cmos5l_decap_8_1852 VSS VDD sg13cmos5l_decap_8
Xsg13cmos5l_decap_8_1830 VSS VDD sg13cmos5l_decap_8
Xsg13cmos5l_decap_8_1841 VSS VDD sg13cmos5l_decap_8
Xsg13cmos5l_decap_8_1863 VSS VDD sg13cmos5l_decap_8
Xsg13cmos5l_decap_8_1874 VSS VDD sg13cmos5l_decap_8
Xsg13cmos5l_decap_8_1885 VSS VDD sg13cmos5l_decap_8
Xsg13cmos5l_decap_8_1896 VSS VDD sg13cmos5l_decap_8
Xsg13cmos5l_decap_4_110 VSS VDD sg13cmos5l_decap_4
Xsg13cmos5l_decap_4_121 VSS VDD sg13cmos5l_decap_4
Xsg13cmos5l_IOPadIOVdd_2 VSS VDD VSS IOVDD sg13cmos5l_IOPadIOVdd
Xsg13cmos5l_decap_8_1115 VSS VDD sg13cmos5l_decap_8
Xsg13cmos5l_decap_8_1104 VSS VDD sg13cmos5l_decap_8
Xsg13cmos5l_decap_8_1137 VSS VDD sg13cmos5l_decap_8
Xsg13cmos5l_decap_8_1148 VSS VDD sg13cmos5l_decap_8
Xsg13cmos5l_decap_8_1126 VSS VDD sg13cmos5l_decap_8
Xsg13cmos5l_decap_8_1159 VSS VDD sg13cmos5l_decap_8
Xsg13cmos5l_decap_8_471 VSS VDD sg13cmos5l_decap_8
Xsg13cmos5l_decap_8_460 VSS VDD sg13cmos5l_decap_8
Xsg13cmos5l_decap_8_482 VSS VDD sg13cmos5l_decap_8
Xsg13cmos5l_decap_8_493 VSS VDD sg13cmos5l_decap_8
Xsg13cmos5l_decap_8_3040 VSS VDD sg13cmos5l_decap_8
Xsg13cmos5l_decap_8_3051 VSS VDD sg13cmos5l_decap_8
Xsg13cmos5l_decap_8_3073 VSS VDD sg13cmos5l_decap_8
Xsg13cmos5l_decap_8_3062 VSS VDD sg13cmos5l_decap_8
Xsg13cmos5l_decap_8_3084 VSS VDD sg13cmos5l_decap_8
Xsg13cmos5l_decap_8_3095 VSS VDD sg13cmos5l_decap_8
Xsg13cmos5l_decap_8_2361 VSS VDD sg13cmos5l_decap_8
Xsg13cmos5l_decap_8_2372 VSS VDD sg13cmos5l_decap_8
Xsg13cmos5l_decap_8_2350 VSS VDD sg13cmos5l_decap_8
Xsg13cmos5l_decap_8_2394 VSS VDD sg13cmos5l_decap_8
Xsg13cmos5l_decap_8_2383 VSS VDD sg13cmos5l_decap_8
Xsg13cmos5l_decap_8_1660 VSS VDD sg13cmos5l_decap_8
Xsg13cmos5l_decap_8_1682 VSS VDD sg13cmos5l_decap_8
Xsg13cmos5l_decap_8_1671 VSS VDD sg13cmos5l_decap_8
Xsg13cmos5l_decap_8_1693 VSS VDD sg13cmos5l_decap_8
Xsg13cmos5l_decap_4_4 VSS VDD sg13cmos5l_decap_4
Xsg13cmos5l_decap_8_290 VSS VDD sg13cmos5l_decap_8
Xsg13cmos5l_decap_8_2180 VSS VDD sg13cmos5l_decap_8
Xsg13cmos5l_decap_8_2191 VSS VDD sg13cmos5l_decap_8
Xsg13cmos5l_decap_8_1490 VSS VDD sg13cmos5l_decap_8
Xsg13cmos5l_decap_8_2905 VSS VDD sg13cmos5l_decap_8
Xsg13cmos5l_decap_8_2927 VSS VDD sg13cmos5l_decap_8
Xsg13cmos5l_decap_8_2916 VSS VDD sg13cmos5l_decap_8
Xsg13cmos5l_decap_8_2938 VSS VDD sg13cmos5l_decap_8
Xsg13cmos5l_decap_8_2949 VSS VDD sg13cmos5l_decap_8
Xsg13cmos5l_decap_8_812 VSS VDD sg13cmos5l_decap_8
Xsg13cmos5l_decap_8_823 VSS VDD sg13cmos5l_decap_8
Xsg13cmos5l_decap_8_801 VSS VDD sg13cmos5l_decap_8
Xsg13cmos5l_decap_8_856 VSS VDD sg13cmos5l_decap_8
Xsg13cmos5l_decap_8_845 VSS VDD sg13cmos5l_decap_8
Xsg13cmos5l_decap_8_834 VSS VDD sg13cmos5l_decap_8
Xsg13cmos5l_decap_8_878 VSS VDD sg13cmos5l_decap_8
Xsg13cmos5l_decap_8_889 VSS VDD sg13cmos5l_decap_8
Xsg13cmos5l_decap_8_867 VSS VDD sg13cmos5l_decap_8
Xsg13cmos5l_decap_8_3403 VSS VDD sg13cmos5l_decap_8
Xsg13cmos5l_decap_8_3414 VSS VDD sg13cmos5l_decap_8
Xsg13cmos5l_decap_8_3458 VSS VDD sg13cmos5l_decap_8
Xsg13cmos5l_decap_8_3447 VSS VDD sg13cmos5l_decap_8
Xsg13cmos5l_decap_8_3425 VSS VDD sg13cmos5l_decap_8
Xsg13cmos5l_decap_8_3436 VSS VDD sg13cmos5l_decap_8
Xsg13cmos5l_decap_8_2702 VSS VDD sg13cmos5l_decap_8
Xsg13cmos5l_decap_8_2713 VSS VDD sg13cmos5l_decap_8
Xsg13cmos5l_decap_8_3469 VSS VDD sg13cmos5l_decap_8
Xsg13cmos5l_decap_8_2735 VSS VDD sg13cmos5l_decap_8
Xsg13cmos5l_decap_8_2746 VSS VDD sg13cmos5l_decap_8
Xsg13cmos5l_decap_8_2724 VSS VDD sg13cmos5l_decap_8
Xsg13cmos5l_decap_8_2768 VSS VDD sg13cmos5l_decap_8
Xsg13cmos5l_decap_8_2779 VSS VDD sg13cmos5l_decap_8
Xsg13cmos5l_decap_8_2757 VSS VDD sg13cmos5l_decap_8
Xsg13cmos5l_decap_8_108 VSS VDD sg13cmos5l_decap_8
Xsg13cmos5l_decap_8_119 VSS VDD sg13cmos5l_decap_8
Xsg13cmos5l_decap_8_2009 VSS VDD sg13cmos5l_decap_8
Xsg13cmos5l_decap_8_1308 VSS VDD sg13cmos5l_decap_8
Xsg13cmos5l_decap_8_1319 VSS VDD sg13cmos5l_decap_8
Xsg13cmos5l_decap_8_620 VSS VDD sg13cmos5l_decap_8
Xsg13cmos5l_decap_8_631 VSS VDD sg13cmos5l_decap_8
Xsg13cmos5l_decap_8_653 VSS VDD sg13cmos5l_decap_8
Xsg13cmos5l_decap_8_642 VSS VDD sg13cmos5l_decap_8
Xsg13cmos5l_decap_8_664 VSS VDD sg13cmos5l_decap_8
Xsg13cmos5l_decap_8_697 VSS VDD sg13cmos5l_decap_8
Xsg13cmos5l_decap_8_686 VSS VDD sg13cmos5l_decap_8
Xsg13cmos5l_decap_8_675 VSS VDD sg13cmos5l_decap_8
Xsg13cmos5l_decap_8_3211 VSS VDD sg13cmos5l_decap_8
Xsg13cmos5l_decap_8_3200 VSS VDD sg13cmos5l_decap_8
Xsg13cmos5l_decap_8_3222 VSS VDD sg13cmos5l_decap_8
Xsg13cmos5l_decap_8_3255 VSS VDD sg13cmos5l_decap_8
Xsg13cmos5l_decap_8_3233 VSS VDD sg13cmos5l_decap_8
Xsg13cmos5l_decap_8_3244 VSS VDD sg13cmos5l_decap_8
Xsg13cmos5l_decap_8_3266 VSS VDD sg13cmos5l_decap_8
Xsg13cmos5l_decap_8_2510 VSS VDD sg13cmos5l_decap_8
Xsg13cmos5l_decap_8_2521 VSS VDD sg13cmos5l_decap_8
Xsg13cmos5l_decap_8_3288 VSS VDD sg13cmos5l_decap_8
Xsg13cmos5l_decap_8_3277 VSS VDD sg13cmos5l_decap_8
Xsg13cmos5l_decap_8_3299 VSS VDD sg13cmos5l_decap_8
Xsg13cmos5l_decap_8_2554 VSS VDD sg13cmos5l_decap_8
Xsg13cmos5l_decap_8_2543 VSS VDD sg13cmos5l_decap_8
Xsg13cmos5l_decap_8_2532 VSS VDD sg13cmos5l_decap_8
Xsg13cmos5l_decap_8_2565 VSS VDD sg13cmos5l_decap_8
Xsg13cmos5l_decap_8_2598 VSS VDD sg13cmos5l_decap_8
Xsg13cmos5l_decap_8_2587 VSS VDD sg13cmos5l_decap_8
Xsg13cmos5l_decap_8_2576 VSS VDD sg13cmos5l_decap_8
Xsg13cmos5l_decap_8_1842 VSS VDD sg13cmos5l_decap_8
Xsg13cmos5l_decap_8_1831 VSS VDD sg13cmos5l_decap_8
Xsg13cmos5l_decap_8_1820 VSS VDD sg13cmos5l_decap_8
Xsg13cmos5l_decap_8_1853 VSS VDD sg13cmos5l_decap_8
Xsg13cmos5l_decap_8_1864 VSS VDD sg13cmos5l_decap_8
Xsg13cmos5l_decap_8_1875 VSS VDD sg13cmos5l_decap_8
Xsg13cmos5l_decap_8_1886 VSS VDD sg13cmos5l_decap_8
Xsg13cmos5l_decap_8_1897 VSS VDD sg13cmos5l_decap_8
Xsg13cmos5l_decap_4_111 VSS VDD sg13cmos5l_decap_4
Xsg13cmos5l_decap_4_100 VSS VDD sg13cmos5l_decap_4
Xsg13cmos5l_decap_4_122 VSS VDD sg13cmos5l_decap_4
Xsg13cmos5l_decap_8_1105 VSS VDD sg13cmos5l_decap_8
Xsg13cmos5l_decap_8_1116 VSS VDD sg13cmos5l_decap_8
Xsg13cmos5l_decap_8_1138 VSS VDD sg13cmos5l_decap_8
Xsg13cmos5l_decap_8_1127 VSS VDD sg13cmos5l_decap_8
Xsg13cmos5l_decap_8_1149 VSS VDD sg13cmos5l_decap_8
Xsg13cmos5l_decap_8_472 VSS VDD sg13cmos5l_decap_8
Xsg13cmos5l_decap_8_461 VSS VDD sg13cmos5l_decap_8
Xsg13cmos5l_decap_8_450 VSS VDD sg13cmos5l_decap_8
Xsg13cmos5l_decap_8_494 VSS VDD sg13cmos5l_decap_8
Xsg13cmos5l_decap_8_483 VSS VDD sg13cmos5l_decap_8
Xsg13cmos5l_decap_8_3041 VSS VDD sg13cmos5l_decap_8
Xsg13cmos5l_decap_8_3030 VSS VDD sg13cmos5l_decap_8
Xsg13cmos5l_decap_8_3074 VSS VDD sg13cmos5l_decap_8
Xsg13cmos5l_decap_8_3063 VSS VDD sg13cmos5l_decap_8
Xsg13cmos5l_decap_8_3052 VSS VDD sg13cmos5l_decap_8
Xsg13cmos5l_decap_8_3096 VSS VDD sg13cmos5l_decap_8
Xsg13cmos5l_decap_8_3085 VSS VDD sg13cmos5l_decap_8
Xsg13cmos5l_decap_8_2362 VSS VDD sg13cmos5l_decap_8
Xsg13cmos5l_decap_8_2351 VSS VDD sg13cmos5l_decap_8
Xsg13cmos5l_decap_8_2340 VSS VDD sg13cmos5l_decap_8
Xsg13cmos5l_decap_8_2395 VSS VDD sg13cmos5l_decap_8
Xsg13cmos5l_decap_8_2373 VSS VDD sg13cmos5l_decap_8
Xsg13cmos5l_decap_8_2384 VSS VDD sg13cmos5l_decap_8
Xsg13cmos5l_decap_8_1661 VSS VDD sg13cmos5l_decap_8
Xsg13cmos5l_decap_8_1650 VSS VDD sg13cmos5l_decap_8
Xsg13cmos5l_decap_8_1672 VSS VDD sg13cmos5l_decap_8
Xsg13cmos5l_decap_8_1694 VSS VDD sg13cmos5l_decap_8
Xsg13cmos5l_decap_8_1683 VSS VDD sg13cmos5l_decap_8
Xsg13cmos5l_decap_4_5 VSS VDD sg13cmos5l_decap_4
Xsg13cmos5l_decap_8_280 VSS VDD sg13cmos5l_decap_8
Xsg13cmos5l_decap_8_291 VSS VDD sg13cmos5l_decap_8
Xsg13cmos5l_decap_8_2170 VSS VDD sg13cmos5l_decap_8
Xsg13cmos5l_decap_8_2181 VSS VDD sg13cmos5l_decap_8
Xsg13cmos5l_decap_8_2192 VSS VDD sg13cmos5l_decap_8
Xsg13cmos5l_decap_8_1480 VSS VDD sg13cmos5l_decap_8
Xsg13cmos5l_decap_8_1491 VSS VDD sg13cmos5l_decap_8
Xsg13cmos5l_decap_8_2906 VSS VDD sg13cmos5l_decap_8
Xsg13cmos5l_decap_8_2917 VSS VDD sg13cmos5l_decap_8
Xsg13cmos5l_decap_8_2928 VSS VDD sg13cmos5l_decap_8
Xsg13cmos5l_decap_8_2939 VSS VDD sg13cmos5l_decap_8
Xsg13cmos5l_decap_8_813 VSS VDD sg13cmos5l_decap_8
Xsg13cmos5l_decap_8_802 VSS VDD sg13cmos5l_decap_8
Xsg13cmos5l_decap_8_824 VSS VDD sg13cmos5l_decap_8
Xsg13cmos5l_decap_8_846 VSS VDD sg13cmos5l_decap_8
Xsg13cmos5l_decap_8_835 VSS VDD sg13cmos5l_decap_8
Xsg13cmos5l_decap_8_879 VSS VDD sg13cmos5l_decap_8
Xsg13cmos5l_decap_8_857 VSS VDD sg13cmos5l_decap_8
Xsg13cmos5l_decap_8_868 VSS VDD sg13cmos5l_decap_8
Xsg13cmos5l_decap_8_3404 VSS VDD sg13cmos5l_decap_8
Xsg13cmos5l_decap_8_3415 VSS VDD sg13cmos5l_decap_8
Xsg13cmos5l_decap_8_3426 VSS VDD sg13cmos5l_decap_8
Xsg13cmos5l_decap_8_3448 VSS VDD sg13cmos5l_decap_8
Xsg13cmos5l_decap_8_3437 VSS VDD sg13cmos5l_decap_8
Xsg13cmos5l_decap_8_2703 VSS VDD sg13cmos5l_decap_8
Xsg13cmos5l_decap_8_3459 VSS VDD sg13cmos5l_decap_8
Xsg13cmos5l_decap_8_2736 VSS VDD sg13cmos5l_decap_8
Xsg13cmos5l_decap_8_2747 VSS VDD sg13cmos5l_decap_8
Xsg13cmos5l_decap_8_2725 VSS VDD sg13cmos5l_decap_8
Xsg13cmos5l_decap_8_2714 VSS VDD sg13cmos5l_decap_8
Xsg13cmos5l_decap_8_2758 VSS VDD sg13cmos5l_decap_8
Xsg13cmos5l_decap_8_2769 VSS VDD sg13cmos5l_decap_8
Xsg13cmos5l_decap_8_109 VSS VDD sg13cmos5l_decap_8
Xsg13cmos5l_decap_8_1309 VSS VDD sg13cmos5l_decap_8
Xsg13cmos5l_decap_8_610 VSS VDD sg13cmos5l_decap_8
Xsg13cmos5l_decap_8_621 VSS VDD sg13cmos5l_decap_8
Xsg13cmos5l_decap_8_665 VSS VDD sg13cmos5l_decap_8
Xsg13cmos5l_decap_8_632 VSS VDD sg13cmos5l_decap_8
Xsg13cmos5l_decap_8_654 VSS VDD sg13cmos5l_decap_8
Xsg13cmos5l_decap_8_643 VSS VDD sg13cmos5l_decap_8
Xsg13cmos5l_decap_8_687 VSS VDD sg13cmos5l_decap_8
Xsg13cmos5l_decap_8_698 VSS VDD sg13cmos5l_decap_8
Xsg13cmos5l_decap_8_676 VSS VDD sg13cmos5l_decap_8
Xsg13cmos5l_decap_8_3201 VSS VDD sg13cmos5l_decap_8
Xsg13cmos5l_decap_8_3212 VSS VDD sg13cmos5l_decap_8
Xsg13cmos5l_decap_8_3223 VSS VDD sg13cmos5l_decap_8
Xsg13cmos5l_decap_8_3256 VSS VDD sg13cmos5l_decap_8
Xsg13cmos5l_decap_8_3245 VSS VDD sg13cmos5l_decap_8
Xsg13cmos5l_decap_8_3234 VSS VDD sg13cmos5l_decap_8
Xsg13cmos5l_decap_8_2511 VSS VDD sg13cmos5l_decap_8
Xsg13cmos5l_decap_8_2500 VSS VDD sg13cmos5l_decap_8
Xsg13cmos5l_decap_8_3267 VSS VDD sg13cmos5l_decap_8
Xsg13cmos5l_decap_8_3289 VSS VDD sg13cmos5l_decap_8
Xsg13cmos5l_decap_8_3278 VSS VDD sg13cmos5l_decap_8
Xsg13cmos5l_decap_8_2555 VSS VDD sg13cmos5l_decap_8
Xsg13cmos5l_decap_8_2544 VSS VDD sg13cmos5l_decap_8
Xsg13cmos5l_decap_8_2533 VSS VDD sg13cmos5l_decap_8
Xsg13cmos5l_decap_8_2522 VSS VDD sg13cmos5l_decap_8
Xsg13cmos5l_decap_8_1810 VSS VDD sg13cmos5l_decap_8
Xsg13cmos5l_decap_8_2588 VSS VDD sg13cmos5l_decap_8
Xsg13cmos5l_decap_8_2566 VSS VDD sg13cmos5l_decap_8
Xsg13cmos5l_decap_8_2577 VSS VDD sg13cmos5l_decap_8
Xsg13cmos5l_decap_8_1832 VSS VDD sg13cmos5l_decap_8
Xsg13cmos5l_decap_8_1821 VSS VDD sg13cmos5l_decap_8
Xsg13cmos5l_decap_8_1843 VSS VDD sg13cmos5l_decap_8
Xsg13cmos5l_decap_8_2599 VSS VDD sg13cmos5l_decap_8
Xsg13cmos5l_decap_8_1865 VSS VDD sg13cmos5l_decap_8
Xsg13cmos5l_decap_8_1876 VSS VDD sg13cmos5l_decap_8
Xsg13cmos5l_decap_8_1854 VSS VDD sg13cmos5l_decap_8
Xsg13cmos5l_decap_8_1887 VSS VDD sg13cmos5l_decap_8
Xsg13cmos5l_decap_8_1898 VSS VDD sg13cmos5l_decap_8
Xsg13cmos5l_decap_4_112 VSS VDD sg13cmos5l_decap_4
Xsg13cmos5l_decap_4_101 VSS VDD sg13cmos5l_decap_4
Xsg13cmos5l_decap_8_1106 VSS VDD sg13cmos5l_decap_8
Xsg13cmos5l_decap_8_1128 VSS VDD sg13cmos5l_decap_8
Xsg13cmos5l_decap_8_1117 VSS VDD sg13cmos5l_decap_8
Xsg13cmos5l_decap_8_1139 VSS VDD sg13cmos5l_decap_8
Xsg13cmos5l_decap_8_462 VSS VDD sg13cmos5l_decap_8
Xsg13cmos5l_decap_8_440 VSS VDD sg13cmos5l_decap_8
Xsg13cmos5l_decap_8_451 VSS VDD sg13cmos5l_decap_8
Xsg13cmos5l_decap_8_473 VSS VDD sg13cmos5l_decap_8
Xsg13cmos5l_decap_8_495 VSS VDD sg13cmos5l_decap_8
Xsg13cmos5l_decap_8_484 VSS VDD sg13cmos5l_decap_8
Xsg13cmos5l_decap_8_3020 VSS VDD sg13cmos5l_decap_8
Xsg13cmos5l_decap_8_3031 VSS VDD sg13cmos5l_decap_8
Xsg13cmos5l_decap_8_3064 VSS VDD sg13cmos5l_decap_8
Xsg13cmos5l_decap_8_3042 VSS VDD sg13cmos5l_decap_8
Xsg13cmos5l_decap_8_3053 VSS VDD sg13cmos5l_decap_8
Xsg13cmos5l_decap_8_2330 VSS VDD sg13cmos5l_decap_8
Xsg13cmos5l_decap_8_3075 VSS VDD sg13cmos5l_decap_8
Xsg13cmos5l_decap_8_3097 VSS VDD sg13cmos5l_decap_8
Xsg13cmos5l_decap_8_3086 VSS VDD sg13cmos5l_decap_8
Xsg13cmos5l_decap_8_2363 VSS VDD sg13cmos5l_decap_8
Xsg13cmos5l_decap_8_2341 VSS VDD sg13cmos5l_decap_8
Xsg13cmos5l_decap_8_2352 VSS VDD sg13cmos5l_decap_8
Xsg13cmos5l_decap_8_2396 VSS VDD sg13cmos5l_decap_8
Xsg13cmos5l_decap_8_2374 VSS VDD sg13cmos5l_decap_8
Xsg13cmos5l_decap_8_2385 VSS VDD sg13cmos5l_decap_8
Xsg13cmos5l_decap_8_1640 VSS VDD sg13cmos5l_decap_8
Xsg13cmos5l_decap_8_1651 VSS VDD sg13cmos5l_decap_8
Xsg13cmos5l_decap_8_1684 VSS VDD sg13cmos5l_decap_8
Xsg13cmos5l_decap_8_1695 VSS VDD sg13cmos5l_decap_8
Xsg13cmos5l_decap_8_1673 VSS VDD sg13cmos5l_decap_8
Xsg13cmos5l_decap_8_1662 VSS VDD sg13cmos5l_decap_8
Xsg13cmos5l_decap_4_6 VSS VDD sg13cmos5l_decap_4
Xsg13cmos5l_decap_8_281 VSS VDD sg13cmos5l_decap_8
Xsg13cmos5l_decap_8_270 VSS VDD sg13cmos5l_decap_8
Xsg13cmos5l_decap_8_292 VSS VDD sg13cmos5l_decap_8
Xsg13cmos5l_decap_8_2160 VSS VDD sg13cmos5l_decap_8
Xsg13cmos5l_decap_8_2171 VSS VDD sg13cmos5l_decap_8
Xsg13cmos5l_decap_8_2193 VSS VDD sg13cmos5l_decap_8
Xsg13cmos5l_decap_8_2182 VSS VDD sg13cmos5l_decap_8
Xsg13cmos5l_decap_8_1470 VSS VDD sg13cmos5l_decap_8
Xsg13cmos5l_decap_8_1481 VSS VDD sg13cmos5l_decap_8
Xsg13cmos5l_decap_8_1492 VSS VDD sg13cmos5l_decap_8
Xsg13cmos5l_decap_8_2918 VSS VDD sg13cmos5l_decap_8
Xsg13cmos5l_decap_8_2929 VSS VDD sg13cmos5l_decap_8
Xsg13cmos5l_decap_8_2907 VSS VDD sg13cmos5l_decap_8
Xsg13cmos5l_decap_8_803 VSS VDD sg13cmos5l_decap_8
Xsg13cmos5l_decap_8_814 VSS VDD sg13cmos5l_decap_8
Xsg13cmos5l_decap_8_847 VSS VDD sg13cmos5l_decap_8
Xsg13cmos5l_decap_8_825 VSS VDD sg13cmos5l_decap_8
Xsg13cmos5l_decap_8_836 VSS VDD sg13cmos5l_decap_8
Xsg13cmos5l_decap_8_858 VSS VDD sg13cmos5l_decap_8
Xsg13cmos5l_decap_8_869 VSS VDD sg13cmos5l_decap_8
Xsg13cmos5l_decap_8_3405 VSS VDD sg13cmos5l_decap_8
Xsg13cmos5l_decap_8_3416 VSS VDD sg13cmos5l_decap_8
Xsg13cmos5l_decap_8_3438 VSS VDD sg13cmos5l_decap_8
Xsg13cmos5l_decap_8_3427 VSS VDD sg13cmos5l_decap_8
Xsg13cmos5l_decap_8_3449 VSS VDD sg13cmos5l_decap_8
Xsg13cmos5l_decap_8_2704 VSS VDD sg13cmos5l_decap_8
Xsg13cmos5l_decap_8_2737 VSS VDD sg13cmos5l_decap_8
Xsg13cmos5l_decap_8_2726 VSS VDD sg13cmos5l_decap_8
Xsg13cmos5l_decap_8_2715 VSS VDD sg13cmos5l_decap_8
Xsg13cmos5l_decap_8_2759 VSS VDD sg13cmos5l_decap_8
Xsg13cmos5l_decap_8_2748 VSS VDD sg13cmos5l_decap_8
Xsg13cmos5l_decap_8_600 VSS VDD sg13cmos5l_decap_8
Xsg13cmos5l_decap_8_611 VSS VDD sg13cmos5l_decap_8
Xsg13cmos5l_decap_8_622 VSS VDD sg13cmos5l_decap_8
Xsg13cmos5l_decap_8_633 VSS VDD sg13cmos5l_decap_8
Xsg13cmos5l_decap_8_644 VSS VDD sg13cmos5l_decap_8
Xsg13cmos5l_decap_8_655 VSS VDD sg13cmos5l_decap_8
Xsg13cmos5l_decap_8_688 VSS VDD sg13cmos5l_decap_8
Xsg13cmos5l_decap_8_677 VSS VDD sg13cmos5l_decap_8
Xsg13cmos5l_decap_8_666 VSS VDD sg13cmos5l_decap_8
Xsg13cmos5l_decap_8_699 VSS VDD sg13cmos5l_decap_8
Xsg13cmos5l_decap_8_3202 VSS VDD sg13cmos5l_decap_8
Xsg13cmos5l_decap_8_3213 VSS VDD sg13cmos5l_decap_8
Xsg13cmos5l_decap_8_3257 VSS VDD sg13cmos5l_decap_8
Xsg13cmos5l_decap_8_3246 VSS VDD sg13cmos5l_decap_8
Xsg13cmos5l_decap_8_3224 VSS VDD sg13cmos5l_decap_8
Xsg13cmos5l_decap_8_3235 VSS VDD sg13cmos5l_decap_8
Xsg13cmos5l_decap_8_2512 VSS VDD sg13cmos5l_decap_8
Xsg13cmos5l_decap_8_2501 VSS VDD sg13cmos5l_decap_8
Xsg13cmos5l_decap_8_3268 VSS VDD sg13cmos5l_decap_8
Xsg13cmos5l_decap_8_3279 VSS VDD sg13cmos5l_decap_8
Xsg13cmos5l_decap_8_2545 VSS VDD sg13cmos5l_decap_8
Xsg13cmos5l_decap_8_2523 VSS VDD sg13cmos5l_decap_8
Xsg13cmos5l_decap_8_2534 VSS VDD sg13cmos5l_decap_8
Xsg13cmos5l_decap_8_1800 VSS VDD sg13cmos5l_decap_8
Xsg13cmos5l_decap_8_2556 VSS VDD sg13cmos5l_decap_8
Xsg13cmos5l_decap_8_2589 VSS VDD sg13cmos5l_decap_8
Xsg13cmos5l_decap_8_2567 VSS VDD sg13cmos5l_decap_8
Xsg13cmos5l_decap_8_2578 VSS VDD sg13cmos5l_decap_8
Xsg13cmos5l_decap_8_1833 VSS VDD sg13cmos5l_decap_8
Xsg13cmos5l_decap_8_1822 VSS VDD sg13cmos5l_decap_8
Xsg13cmos5l_decap_8_1811 VSS VDD sg13cmos5l_decap_8
Xsg13cmos5l_decap_8_1844 VSS VDD sg13cmos5l_decap_8
Xsg13cmos5l_decap_8_1866 VSS VDD sg13cmos5l_decap_8
Xsg13cmos5l_decap_8_1877 VSS VDD sg13cmos5l_decap_8
Xsg13cmos5l_decap_8_1855 VSS VDD sg13cmos5l_decap_8
Xsg13cmos5l_decap_8_1899 VSS VDD sg13cmos5l_decap_8
Xsg13cmos5l_decap_8_1888 VSS VDD sg13cmos5l_decap_8
Xsg13cmos5l_decap_4_113 VSS VDD sg13cmos5l_decap_4
Xsg13cmos5l_decap_4_102 VSS VDD sg13cmos5l_decap_4
Xsg13cmos5l_decap_8_1118 VSS VDD sg13cmos5l_decap_8
Xsg13cmos5l_decap_8_1107 VSS VDD sg13cmos5l_decap_8
Xsg13cmos5l_decap_8_1129 VSS VDD sg13cmos5l_decap_8
Xsg13cmos5l_decap_8_430 VSS VDD sg13cmos5l_decap_8
Xsg13cmos5l_decap_8_441 VSS VDD sg13cmos5l_decap_8
Xsg13cmos5l_decap_8_463 VSS VDD sg13cmos5l_decap_8
Xsg13cmos5l_decap_8_452 VSS VDD sg13cmos5l_decap_8
Xsg13cmos5l_decap_8_474 VSS VDD sg13cmos5l_decap_8
Xsg13cmos5l_decap_8_496 VSS VDD sg13cmos5l_decap_8
Xsg13cmos5l_decap_8_485 VSS VDD sg13cmos5l_decap_8
Xsg13cmos5l_decap_8_3021 VSS VDD sg13cmos5l_decap_8
Xsg13cmos5l_decap_8_3010 VSS VDD sg13cmos5l_decap_8
Xsg13cmos5l_decap_8_3032 VSS VDD sg13cmos5l_decap_8
Xsg13cmos5l_decap_8_3043 VSS VDD sg13cmos5l_decap_8
Xsg13cmos5l_decap_8_3065 VSS VDD sg13cmos5l_decap_8
Xsg13cmos5l_decap_8_3054 VSS VDD sg13cmos5l_decap_8
Xsg13cmos5l_decap_8_2320 VSS VDD sg13cmos5l_decap_8
Xsg13cmos5l_decap_8_3076 VSS VDD sg13cmos5l_decap_8
Xsg13cmos5l_decap_8_3087 VSS VDD sg13cmos5l_decap_8
Xsg13cmos5l_decap_8_3098 VSS VDD sg13cmos5l_decap_8
Xsg13cmos5l_decap_8_2331 VSS VDD sg13cmos5l_decap_8
Xsg13cmos5l_decap_8_2353 VSS VDD sg13cmos5l_decap_8
Xsg13cmos5l_decap_8_2342 VSS VDD sg13cmos5l_decap_8
Xsg13cmos5l_decap_8_2364 VSS VDD sg13cmos5l_decap_8
Xsg13cmos5l_decap_8_2397 VSS VDD sg13cmos5l_decap_8
Xsg13cmos5l_decap_8_2375 VSS VDD sg13cmos5l_decap_8
Xsg13cmos5l_decap_8_2386 VSS VDD sg13cmos5l_decap_8
Xsg13cmos5l_decap_8_1630 VSS VDD sg13cmos5l_decap_8
Xsg13cmos5l_decap_8_1641 VSS VDD sg13cmos5l_decap_8
Xsg13cmos5l_decap_8_1652 VSS VDD sg13cmos5l_decap_8
Xsg13cmos5l_decap_8_1685 VSS VDD sg13cmos5l_decap_8
Xsg13cmos5l_decap_8_1674 VSS VDD sg13cmos5l_decap_8
Xsg13cmos5l_decap_8_1663 VSS VDD sg13cmos5l_decap_8
Xsg13cmos5l_decap_8_1696 VSS VDD sg13cmos5l_decap_8
Xsg13cmos5l_decap_4_7 VSS VDD sg13cmos5l_decap_4
Xsg13cmos5l_decap_8_260 VSS VDD sg13cmos5l_decap_8
Xsg13cmos5l_decap_8_271 VSS VDD sg13cmos5l_decap_8
Xsg13cmos5l_decap_8_293 VSS VDD sg13cmos5l_decap_8
Xsg13cmos5l_decap_8_282 VSS VDD sg13cmos5l_decap_8
Xsg13cmos5l_decap_8_2172 VSS VDD sg13cmos5l_decap_8
Xsg13cmos5l_decap_8_2161 VSS VDD sg13cmos5l_decap_8
Xsg13cmos5l_decap_8_2150 VSS VDD sg13cmos5l_decap_8
Xsg13cmos5l_decap_8_2194 VSS VDD sg13cmos5l_decap_8
Xsg13cmos5l_decap_8_2183 VSS VDD sg13cmos5l_decap_8
Xsg13cmos5l_decap_8_1460 VSS VDD sg13cmos5l_decap_8
Xsg13cmos5l_decap_8_1493 VSS VDD sg13cmos5l_decap_8
Xsg13cmos5l_decap_8_1482 VSS VDD sg13cmos5l_decap_8
Xsg13cmos5l_decap_8_1471 VSS VDD sg13cmos5l_decap_8
Xsg13cmos5l_decap_8_1290 VSS VDD sg13cmos5l_decap_8
Xsg13cmos5l_decap_8_2919 VSS VDD sg13cmos5l_decap_8
Xsg13cmos5l_decap_8_2908 VSS VDD sg13cmos5l_decap_8
Xsg13cmos5l_decap_8_804 VSS VDD sg13cmos5l_decap_8
Xsg13cmos5l_decap_8_815 VSS VDD sg13cmos5l_decap_8
Xsg13cmos5l_decap_8_826 VSS VDD sg13cmos5l_decap_8
Xsg13cmos5l_decap_8_837 VSS VDD sg13cmos5l_decap_8
Xsg13cmos5l_decap_8_848 VSS VDD sg13cmos5l_decap_8
Xsg13cmos5l_decap_8_859 VSS VDD sg13cmos5l_decap_8
Xsg13cmos5l_decap_8_3406 VSS VDD sg13cmos5l_decap_8
Xsg13cmos5l_decap_8_3439 VSS VDD sg13cmos5l_decap_8
Xsg13cmos5l_decap_8_3428 VSS VDD sg13cmos5l_decap_8
Xsg13cmos5l_decap_8_3417 VSS VDD sg13cmos5l_decap_8
Xsg13cmos5l_decap_8_2738 VSS VDD sg13cmos5l_decap_8
Xsg13cmos5l_decap_8_2727 VSS VDD sg13cmos5l_decap_8
Xsg13cmos5l_decap_8_2705 VSS VDD sg13cmos5l_decap_8
Xsg13cmos5l_decap_8_2716 VSS VDD sg13cmos5l_decap_8
Xsg13cmos5l_decap_8_2749 VSS VDD sg13cmos5l_decap_8
Xsg13cmos5l_decap_4_90 VSS VDD sg13cmos5l_decap_4
Xsg13cmos5l_decap_8_601 VSS VDD sg13cmos5l_decap_8
Xsg13cmos5l_decap_8_612 VSS VDD sg13cmos5l_decap_8
Xsg13cmos5l_decap_8_634 VSS VDD sg13cmos5l_decap_8
Xsg13cmos5l_decap_8_656 VSS VDD sg13cmos5l_decap_8
Xsg13cmos5l_decap_8_623 VSS VDD sg13cmos5l_decap_8
Xsg13cmos5l_decap_8_645 VSS VDD sg13cmos5l_decap_8
Xsg13cmos5l_decap_8_689 VSS VDD sg13cmos5l_decap_8
Xsg13cmos5l_decap_8_667 VSS VDD sg13cmos5l_decap_8
Xsg13cmos5l_decap_8_678 VSS VDD sg13cmos5l_decap_8
Xsg13cmos5l_decap_8_3214 VSS VDD sg13cmos5l_decap_8
Xsg13cmos5l_decap_8_3203 VSS VDD sg13cmos5l_decap_8
Xsg13cmos5l_decap_8_3225 VSS VDD sg13cmos5l_decap_8
Xsg13cmos5l_decap_8_3247 VSS VDD sg13cmos5l_decap_8
Xsg13cmos5l_decap_8_3236 VSS VDD sg13cmos5l_decap_8
Xsg13cmos5l_decap_8_2502 VSS VDD sg13cmos5l_decap_8
Xsg13cmos5l_decap_8_3258 VSS VDD sg13cmos5l_decap_8
Xsg13cmos5l_decap_8_3269 VSS VDD sg13cmos5l_decap_8
Xsg13cmos5l_decap_8_2513 VSS VDD sg13cmos5l_decap_8
Xsg13cmos5l_decap_8_2546 VSS VDD sg13cmos5l_decap_8
Xsg13cmos5l_decap_8_2524 VSS VDD sg13cmos5l_decap_8
Xsg13cmos5l_decap_8_2535 VSS VDD sg13cmos5l_decap_8
Xsg13cmos5l_decap_8_1801 VSS VDD sg13cmos5l_decap_8
Xsg13cmos5l_decap_8_2557 VSS VDD sg13cmos5l_decap_8
Xsg13cmos5l_decap_8_2568 VSS VDD sg13cmos5l_decap_8
Xsg13cmos5l_decap_8_2579 VSS VDD sg13cmos5l_decap_8
Xsg13cmos5l_decap_8_1834 VSS VDD sg13cmos5l_decap_8
Xsg13cmos5l_decap_8_1823 VSS VDD sg13cmos5l_decap_8
Xsg13cmos5l_decap_8_1812 VSS VDD sg13cmos5l_decap_8
Xsg13cmos5l_decap_8_1867 VSS VDD sg13cmos5l_decap_8
Xsg13cmos5l_decap_8_1845 VSS VDD sg13cmos5l_decap_8
Xsg13cmos5l_decap_8_1856 VSS VDD sg13cmos5l_decap_8
Xsg13cmos5l_decap_8_1878 VSS VDD sg13cmos5l_decap_8
Xsg13cmos5l_decap_8_1889 VSS VDD sg13cmos5l_decap_8
Xsg13cmos5l_decap_4_114 VSS VDD sg13cmos5l_decap_4
Xsg13cmos5l_decap_4_103 VSS VDD sg13cmos5l_decap_4
Xsg13cmos5l_decap_8_1119 VSS VDD sg13cmos5l_decap_8
Xsg13cmos5l_decap_8_1108 VSS VDD sg13cmos5l_decap_8
Xsg13cmos5l_decap_8_420 VSS VDD sg13cmos5l_decap_8
Xsg13cmos5l_decap_8_464 VSS VDD sg13cmos5l_decap_8
Xsg13cmos5l_decap_8_442 VSS VDD sg13cmos5l_decap_8
Xsg13cmos5l_decap_8_453 VSS VDD sg13cmos5l_decap_8
Xsg13cmos5l_decap_8_431 VSS VDD sg13cmos5l_decap_8
Xsg13cmos5l_decap_8_475 VSS VDD sg13cmos5l_decap_8
Xsg13cmos5l_decap_8_497 VSS VDD sg13cmos5l_decap_8
Xsg13cmos5l_decap_8_486 VSS VDD sg13cmos5l_decap_8
Xsg13cmos5l_decap_8_3000 VSS VDD sg13cmos5l_decap_8
Xsg13cmos5l_decap_8_3011 VSS VDD sg13cmos5l_decap_8
Xsg13cmos5l_decap_8_3022 VSS VDD sg13cmos5l_decap_8
Xsg13cmos5l_decap_8_3055 VSS VDD sg13cmos5l_decap_8
Xsg13cmos5l_decap_8_3044 VSS VDD sg13cmos5l_decap_8
Xsg13cmos5l_decap_8_3033 VSS VDD sg13cmos5l_decap_8
Xsg13cmos5l_decap_8_2321 VSS VDD sg13cmos5l_decap_8
Xsg13cmos5l_decap_8_2310 VSS VDD sg13cmos5l_decap_8
Xsg13cmos5l_decap_8_3088 VSS VDD sg13cmos5l_decap_8
Xsg13cmos5l_decap_8_3099 VSS VDD sg13cmos5l_decap_8
Xsg13cmos5l_decap_8_3066 VSS VDD sg13cmos5l_decap_8
Xsg13cmos5l_decap_8_3077 VSS VDD sg13cmos5l_decap_8
Xsg13cmos5l_decap_8_2332 VSS VDD sg13cmos5l_decap_8
Xsg13cmos5l_decap_8_2343 VSS VDD sg13cmos5l_decap_8
Xsg13cmos5l_decap_8_2354 VSS VDD sg13cmos5l_decap_8
Xsg13cmos5l_decap_8_2365 VSS VDD sg13cmos5l_decap_8
Xsg13cmos5l_decap_8_2376 VSS VDD sg13cmos5l_decap_8
Xsg13cmos5l_decap_8_2387 VSS VDD sg13cmos5l_decap_8
Xsg13cmos5l_decap_8_1620 VSS VDD sg13cmos5l_decap_8
Xsg13cmos5l_decap_8_1642 VSS VDD sg13cmos5l_decap_8
Xsg13cmos5l_decap_8_1631 VSS VDD sg13cmos5l_decap_8
Xsg13cmos5l_decap_8_2398 VSS VDD sg13cmos5l_decap_8
Xsg13cmos5l_decap_8_1686 VSS VDD sg13cmos5l_decap_8
Xsg13cmos5l_decap_8_1675 VSS VDD sg13cmos5l_decap_8
Xsg13cmos5l_decap_8_1664 VSS VDD sg13cmos5l_decap_8
Xsg13cmos5l_decap_8_1653 VSS VDD sg13cmos5l_decap_8
Xsg13cmos5l_decap_8_1697 VSS VDD sg13cmos5l_decap_8
Xsg13cmos5l_decap_4_8 VSS VDD sg13cmos5l_decap_4
Xsg13cmos5l_decap_8_261 VSS VDD sg13cmos5l_decap_8
Xsg13cmos5l_decap_8_272 VSS VDD sg13cmos5l_decap_8
Xsg13cmos5l_decap_8_250 VSS VDD sg13cmos5l_decap_8
Xsg13cmos5l_decap_8_294 VSS VDD sg13cmos5l_decap_8
Xsg13cmos5l_decap_8_283 VSS VDD sg13cmos5l_decap_8
Xsg13cmos5l_decap_8_2162 VSS VDD sg13cmos5l_decap_8
Xsg13cmos5l_decap_8_2151 VSS VDD sg13cmos5l_decap_8
Xsg13cmos5l_decap_8_2140 VSS VDD sg13cmos5l_decap_8
Xsg13cmos5l_decap_8_2195 VSS VDD sg13cmos5l_decap_8
Xsg13cmos5l_decap_8_2173 VSS VDD sg13cmos5l_decap_8
Xsg13cmos5l_decap_8_2184 VSS VDD sg13cmos5l_decap_8
Xsg13cmos5l_decap_8_1450 VSS VDD sg13cmos5l_decap_8
Xsg13cmos5l_decap_8_1461 VSS VDD sg13cmos5l_decap_8
Xsg13cmos5l_decap_8_1483 VSS VDD sg13cmos5l_decap_8
Xsg13cmos5l_decap_8_1494 VSS VDD sg13cmos5l_decap_8
Xsg13cmos5l_decap_8_1472 VSS VDD sg13cmos5l_decap_8
Xsg13cmos5l_decap_8_1280 VSS VDD sg13cmos5l_decap_8
Xsg13cmos5l_decap_8_1291 VSS VDD sg13cmos5l_decap_8
Xsg13cmos5l_decap_8_2909 VSS VDD sg13cmos5l_decap_8
Xsg13cmos5l_decap_8_816 VSS VDD sg13cmos5l_decap_8
Xsg13cmos5l_decap_8_805 VSS VDD sg13cmos5l_decap_8
Xsg13cmos5l_decap_8_827 VSS VDD sg13cmos5l_decap_8
Xsg13cmos5l_decap_8_838 VSS VDD sg13cmos5l_decap_8
Xsg13cmos5l_decap_8_849 VSS VDD sg13cmos5l_decap_8
Xsg13cmos5l_decap_8_3418 VSS VDD sg13cmos5l_decap_8
Xsg13cmos5l_decap_8_3407 VSS VDD sg13cmos5l_decap_8
Xsg13cmos5l_decap_8_3429 VSS VDD sg13cmos5l_decap_8
Xsg13cmos5l_decap_8_2728 VSS VDD sg13cmos5l_decap_8
Xsg13cmos5l_decap_8_2717 VSS VDD sg13cmos5l_decap_8
Xsg13cmos5l_decap_8_2706 VSS VDD sg13cmos5l_decap_8
Xsg13cmos5l_decap_8_2739 VSS VDD sg13cmos5l_decap_8
Xsg13cmos5l_decap_4_91 VSS VDD sg13cmos5l_decap_4
Xsg13cmos5l_decap_4_80 VSS VDD sg13cmos5l_decap_4
Xsg13cmos5l_decap_8_602 VSS VDD sg13cmos5l_decap_8
Xsg13cmos5l_decap_8_613 VSS VDD sg13cmos5l_decap_8
Xsg13cmos5l_decap_8_635 VSS VDD sg13cmos5l_decap_8
Xsg13cmos5l_decap_8_646 VSS VDD sg13cmos5l_decap_8
Xsg13cmos5l_decap_8_624 VSS VDD sg13cmos5l_decap_8
Xsg13cmos5l_decap_8_657 VSS VDD sg13cmos5l_decap_8
Xsg13cmos5l_decap_8_668 VSS VDD sg13cmos5l_decap_8
Xsg13cmos5l_decap_8_679 VSS VDD sg13cmos5l_decap_8
Xsg13cmos5l_decap_8_3204 VSS VDD sg13cmos5l_decap_8
Xsg13cmos5l_decap_8_3215 VSS VDD sg13cmos5l_decap_8
Xsg13cmos5l_decap_8_3226 VSS VDD sg13cmos5l_decap_8
Xsg13cmos5l_decap_8_3248 VSS VDD sg13cmos5l_decap_8
Xsg13cmos5l_decap_8_3237 VSS VDD sg13cmos5l_decap_8
Xsg13cmos5l_decap_8_2503 VSS VDD sg13cmos5l_decap_8
Xsg13cmos5l_decap_8_3259 VSS VDD sg13cmos5l_decap_8
Xsg13cmos5l_decap_8_2536 VSS VDD sg13cmos5l_decap_8
Xsg13cmos5l_decap_8_2514 VSS VDD sg13cmos5l_decap_8
Xsg13cmos5l_decap_8_2525 VSS VDD sg13cmos5l_decap_8
Xsg13cmos5l_decap_8_2569 VSS VDD sg13cmos5l_decap_8
Xsg13cmos5l_decap_8_2547 VSS VDD sg13cmos5l_decap_8
Xsg13cmos5l_decap_8_2558 VSS VDD sg13cmos5l_decap_8
Xsg13cmos5l_decap_8_1824 VSS VDD sg13cmos5l_decap_8
Xsg13cmos5l_decap_8_1835 VSS VDD sg13cmos5l_decap_8
Xsg13cmos5l_decap_8_1813 VSS VDD sg13cmos5l_decap_8
Xsg13cmos5l_decap_8_1802 VSS VDD sg13cmos5l_decap_8
Xsg13cmos5l_decap_8_1868 VSS VDD sg13cmos5l_decap_8
Xsg13cmos5l_decap_8_1857 VSS VDD sg13cmos5l_decap_8
Xsg13cmos5l_decap_8_1846 VSS VDD sg13cmos5l_decap_8
Xsg13cmos5l_decap_8_1879 VSS VDD sg13cmos5l_decap_8
Xsg13cmos5l_decap_4_115 VSS VDD sg13cmos5l_decap_4
Xsg13cmos5l_decap_4_104 VSS VDD sg13cmos5l_decap_4
Xsg13cmos5l_decap_8_1109 VSS VDD sg13cmos5l_decap_8
Xsg13cmos5l_decap_8_410 VSS VDD sg13cmos5l_decap_8
Xsg13cmos5l_decap_8_421 VSS VDD sg13cmos5l_decap_8
Xsg13cmos5l_decap_8_454 VSS VDD sg13cmos5l_decap_8
Xsg13cmos5l_decap_8_443 VSS VDD sg13cmos5l_decap_8
Xsg13cmos5l_decap_8_432 VSS VDD sg13cmos5l_decap_8
Xsg13cmos5l_decap_8_465 VSS VDD sg13cmos5l_decap_8
Xsg13cmos5l_decap_8_498 VSS VDD sg13cmos5l_decap_8
Xsg13cmos5l_decap_8_476 VSS VDD sg13cmos5l_decap_8
Xsg13cmos5l_decap_8_487 VSS VDD sg13cmos5l_decap_8
Xsg13cmos5l_decap_8_3001 VSS VDD sg13cmos5l_decap_8
Xsg13cmos5l_decap_8_3012 VSS VDD sg13cmos5l_decap_8
Xsg13cmos5l_decap_8_3023 VSS VDD sg13cmos5l_decap_8
Xsg13cmos5l_decap_8_3056 VSS VDD sg13cmos5l_decap_8
Xsg13cmos5l_decap_8_3045 VSS VDD sg13cmos5l_decap_8
Xsg13cmos5l_decap_8_3034 VSS VDD sg13cmos5l_decap_8
Xsg13cmos5l_decap_8_2300 VSS VDD sg13cmos5l_decap_8
Xsg13cmos5l_decap_8_2311 VSS VDD sg13cmos5l_decap_8
Xsg13cmos5l_decap_8_3067 VSS VDD sg13cmos5l_decap_8
Xsg13cmos5l_decap_8_3078 VSS VDD sg13cmos5l_decap_8
Xsg13cmos5l_decap_8_3089 VSS VDD sg13cmos5l_decap_8
Xsg13cmos5l_decap_8_2322 VSS VDD sg13cmos5l_decap_8
Xsg13cmos5l_decap_8_2333 VSS VDD sg13cmos5l_decap_8
Xsg13cmos5l_decap_8_2344 VSS VDD sg13cmos5l_decap_8
Xsg13cmos5l_decap_8_1610 VSS VDD sg13cmos5l_decap_8
Xsg13cmos5l_decap_8_2366 VSS VDD sg13cmos5l_decap_8
Xsg13cmos5l_decap_8_2388 VSS VDD sg13cmos5l_decap_8
Xsg13cmos5l_decap_8_2377 VSS VDD sg13cmos5l_decap_8
Xsg13cmos5l_decap_8_2355 VSS VDD sg13cmos5l_decap_8
Xsg13cmos5l_decap_8_1621 VSS VDD sg13cmos5l_decap_8
Xsg13cmos5l_decap_8_1632 VSS VDD sg13cmos5l_decap_8
Xsg13cmos5l_decap_8_1643 VSS VDD sg13cmos5l_decap_8
Xsg13cmos5l_decap_8_2399 VSS VDD sg13cmos5l_decap_8
Xsg13cmos5l_decap_8_1665 VSS VDD sg13cmos5l_decap_8
Xsg13cmos5l_decap_8_1676 VSS VDD sg13cmos5l_decap_8
Xsg13cmos5l_decap_8_1654 VSS VDD sg13cmos5l_decap_8
Xsg13cmos5l_decap_8_1698 VSS VDD sg13cmos5l_decap_8
Xsg13cmos5l_decap_8_1687 VSS VDD sg13cmos5l_decap_8
Xsg13cmos5l_decap_4_9 VSS VDD sg13cmos5l_decap_4
Xsg13cmos5l_decap_8_251 VSS VDD sg13cmos5l_decap_8
Xsg13cmos5l_decap_8_262 VSS VDD sg13cmos5l_decap_8
Xsg13cmos5l_decap_8_240 VSS VDD sg13cmos5l_decap_8
Xsg13cmos5l_decap_8_295 VSS VDD sg13cmos5l_decap_8
Xsg13cmos5l_decap_8_284 VSS VDD sg13cmos5l_decap_8
Xsg13cmos5l_decap_8_273 VSS VDD sg13cmos5l_decap_8
Xsg13cmos5l_decap_8_2163 VSS VDD sg13cmos5l_decap_8
Xsg13cmos5l_decap_8_2130 VSS VDD sg13cmos5l_decap_8
Xsg13cmos5l_decap_8_2141 VSS VDD sg13cmos5l_decap_8
Xsg13cmos5l_decap_8_2152 VSS VDD sg13cmos5l_decap_8
Xsg13cmos5l_decap_8_2174 VSS VDD sg13cmos5l_decap_8
Xsg13cmos5l_decap_8_2185 VSS VDD sg13cmos5l_decap_8
Xsg13cmos5l_decap_8_2196 VSS VDD sg13cmos5l_decap_8
Xsg13cmos5l_decap_8_1440 VSS VDD sg13cmos5l_decap_8
Xsg13cmos5l_decap_8_1451 VSS VDD sg13cmos5l_decap_8
Xsg13cmos5l_decap_8_1484 VSS VDD sg13cmos5l_decap_8
Xsg13cmos5l_decap_8_1462 VSS VDD sg13cmos5l_decap_8
Xsg13cmos5l_decap_8_1473 VSS VDD sg13cmos5l_decap_8
Xsg13cmos5l_decap_8_1495 VSS VDD sg13cmos5l_decap_8
XCOMPLETE_PROYECT_FIG_0 VDD COMPLETE_PROYECT_FIG_0/X VSS COMPLETE_PROYECT_FIG_0/Y
+ COMPLETE_PROYECT_FIG_0/Q COMPLETE_PROYECT_FIG_0/L_HI COMPLETE_PROYECT_FIG_0/D COMPLETE_PROYECT_FIG_0/B
+ COMPLETE_PROYECT_FIG_0/C COMPLETE_PROYECT_FIG_0/B_N COMPLETE_PROYECT_FIG_0/S COMPLETE_PROYECT_FIG_0/A_N
+ COMPLETE_PROYECT_FIG_0/B1 COMPLETE_PROYECT_FIG_0/A2 COMPLETE_PROYECT_FIG_0/A1 COMPLETE_PROYECT_FIG_0/A0
+ COMPLETE_PROYECT_FIG_0/B2 COMPLETE_PROYECT_FIG_0/C1 sg13cmos5l_IOPadIn_5/p2c sg13cmos5l_IOPadIn_4/p2c
+ COMPLETE_PROYECT_FIG_0/q[21] COMPLETE_PROYECT_FIG_0/q[22] COMPLETE_PROYECT_FIG_0/q[24]
+ COMPLETE_PROYECT_FIG_0/q[25] COMPLETE_PROYECT_FIG_0/q[26] COMPLETE_PROYECT_FIG_0/q[28]
+ COMPLETE_PROYECT_FIG_0/q[29] COMPLETE_PROYECT_FIG_0/q[19] COMPLETE_PROYECT_FIG_0/q[18]
+ COMPLETE_PROYECT_FIG_0/q[10] COMPLETE_PROYECT_FIG_0/q[11] COMPLETE_PROYECT_FIG_0/q[12]
+ COMPLETE_PROYECT_FIG_0/q[13] COMPLETE_PROYECT_FIG_0/q[8] COMPLETE_PROYECT_FIG_0/q[7]
+ COMPLETE_PROYECT_FIG_0/q[3] COMPLETE_PROYECT_FIG_0/q[5] COMPLETE_PROYECT_FIG_0/q[6]
+ sg13cmos5l_IOPadAnalog_0/padres COMPLETE_PROYECT_FIG_0/VEVAL1 COMPLETE_PROYECT_FIG_0/PC
+ COMPLETE_PROYECT_FIG_0/q[1] COMPLETE_PROYECT_FIG_0/SLN[1] COMPLETE_PROYECT_FIG_0/q[14]
+ COMPLETE_PROYECT_FIG_0/SL[0] COMPLETE_PROYECT_FIG_0/q[9] COMPLETE_PROYECT_FIG_0/q[4]
+ COMPLETE_PROYECT_FIG_0/SLN[9] COMPLETE_PROYECT_FIG_0/q[2] COMPLETE_PROYECT_FIG_0/SLN[5]
+ COMPLETE_PROYECT_FIG_0/SLN[0] COMPLETE_PROYECT_FIG_0/q[15] COMPLETE_PROYECT_FIG_0/X_uq343
+ COMPLETE_PROYECT_FIG_0/q[17] COMPLETE_PROYECT_FIG_0/X_uq346 COMPLETE_PROYECT_FIG_0/q[16]
+ COMPLETE_PROYECT_FIG_0/q[20] COMPLETE_PROYECT_FIG_0/X_uq362 COMPLETE_PROYECT_FIG_0/X_uq338
+ COMPLETE_PROYECT_FIG_0/X_uq339 COMPLETE_PROYECT_FIG_0/q[31] COMPLETE_PROYECT_FIG_0/q[30]
+ COMPLETE_PROYECT_FIG_0/q[23] COMPLETE_PROYECT_FIG_0/q[27] COMPLETE_PROYECT_FIG_0/WL_REF
+ sg13cmos5l_IOPadIn_3/p2c COMPLETE_PROYECT_FIG_0/din[19] COMPLETE_PROYECT_FIG_0/din[1]
+ COMPLETE_PROYECT_FIG_0/din[20] COMPLETE_PROYECT_FIG_0/din[21] COMPLETE_PROYECT_FIG_0/din[22]
+ COMPLETE_PROYECT_FIG_0/din[23] COMPLETE_PROYECT_FIG_0/din[24] COMPLETE_PROYECT_FIG_0/din[25]
+ COMPLETE_PROYECT_FIG_0/din[26] COMPLETE_PROYECT_FIG_0/din[28] COMPLETE_PROYECT_FIG_0/din[29]
+ COMPLETE_PROYECT_FIG_0/din[2] COMPLETE_PROYECT_FIG_0/din[30] COMPLETE_PROYECT_FIG_0/din[31]
+ COMPLETE_PROYECT_FIG_0/din[3] COMPLETE_PROYECT_FIG_0/din[4] COMPLETE_PROYECT_FIG_0/din[5]
+ COMPLETE_PROYECT_FIG_0/din[6] COMPLETE_PROYECT_FIG_0/din[7] COMPLETE_PROYECT_FIG_0/din[8]
+ COMPLETE_PROYECT_FIG_0/din[9] COMPLETE_PROYECT_FIG_0/dout COMPLETE_PROYECT_FIG_0/din[14]
+ COMPLETE_PROYECT_FIG_0/din[0] COMPLETE_PROYECT_FIG_0/din[27] COMPLETE_PROYECT_FIG_0/din[10]
+ COMPLETE_PROYECT_FIG_0/din[11] COMPLETE_PROYECT_FIG_0/din[12] COMPLETE_PROYECT_FIG_0/din[13]
+ COMPLETE_PROYECT_FIG_0/din[15] COMPLETE_PROYECT_FIG_0/din[16] COMPLETE_PROYECT_FIG_0/din[17]
+ COMPLETE_PROYECT_FIG_0/din[18] COMPLETE_PROYECT_FIG_0/X_uq0 COMPLETE_PROYECT_FIG_0/X_uq1
+ COMPLETE_PROYECT_FIG_0/X_uq2 COMPLETE_PROYECT_FIG_0/X_uq3 COMPLETE_PROYECT_FIG_0/X_uq4
+ COMPLETE_PROYECT_FIG_0/X_uq5 COMPLETE_PROYECT_FIG_0/X_uq6 COMPLETE_PROYECT_FIG_0/X_uq7
+ COMPLETE_PROYECT_FIG_0/X_uq8 COMPLETE_PROYECT_FIG_0/X_uq9 COMPLETE_PROYECT_FIG_0/X_uq10
+ COMPLETE_PROYECT_FIG_0/X_uq11 COMPLETE_PROYECT_FIG_0/X_uq12 COMPLETE_PROYECT_FIG_0/X_uq13
+ COMPLETE_PROYECT_FIG_0/X_uq14 COMPLETE_PROYECT_FIG_0/X_uq15 COMPLETE_PROYECT_FIG_0/X_uq16
+ COMPLETE_PROYECT_FIG_0/X_uq17 COMPLETE_PROYECT_FIG_0/X_uq18 COMPLETE_PROYECT_FIG_0/X_uq19
+ COMPLETE_PROYECT_FIG_0/X_uq20 COMPLETE_PROYECT_FIG_0/X_uq21 COMPLETE_PROYECT_FIG_0/X_uq22
+ COMPLETE_PROYECT_FIG_0/X_uq23 COMPLETE_PROYECT_FIG_0/X_uq24 COMPLETE_PROYECT_FIG_0/X_uq25
+ COMPLETE_PROYECT_FIG_0/X_uq26 COMPLETE_PROYECT_FIG_0/X_uq27 COMPLETE_PROYECT_FIG_0/X_uq28
+ COMPLETE_PROYECT_FIG_0/X_uq29 COMPLETE_PROYECT_FIG_0/X_uq30 COMPLETE_PROYECT_FIG_0/X_uq31
+ COMPLETE_PROYECT_FIG_0/X_uq32 COMPLETE_PROYECT_FIG_0/X_uq33 COMPLETE_PROYECT_FIG_0/X_uq34
+ COMPLETE_PROYECT_FIG_0/X_uq35 COMPLETE_PROYECT_FIG_0/X_uq36 COMPLETE_PROYECT_FIG_0/X_uq37
+ COMPLETE_PROYECT_FIG_0/X_uq38 COMPLETE_PROYECT_FIG_0/X_uq39 COMPLETE_PROYECT_FIG_0/X_uq40
+ COMPLETE_PROYECT_FIG_0/X_uq41 COMPLETE_PROYECT_FIG_0/X_uq42 COMPLETE_PROYECT_FIG_0/X_uq43
+ COMPLETE_PROYECT_FIG_0/X_uq44 COMPLETE_PROYECT_FIG_0/X_uq45 COMPLETE_PROYECT_FIG_0/X_uq46
+ COMPLETE_PROYECT_FIG_0/X_uq47 COMPLETE_PROYECT_FIG_0/X_uq48 COMPLETE_PROYECT_FIG_0/X_uq49
+ COMPLETE_PROYECT_FIG_0/X_uq50 COMPLETE_PROYECT_FIG_0/X_uq51 COMPLETE_PROYECT_FIG_0/X_uq52
+ COMPLETE_PROYECT_FIG_0/X_uq53 COMPLETE_PROYECT_FIG_0/X_uq54 COMPLETE_PROYECT_FIG_0/X_uq55
+ COMPLETE_PROYECT_FIG_0/X_uq56 COMPLETE_PROYECT_FIG_0/X_uq57 COMPLETE_PROYECT_FIG_0/X_uq58
+ COMPLETE_PROYECT_FIG_0/X_uq59 COMPLETE_PROYECT_FIG_0/X_uq61 COMPLETE_PROYECT_FIG_0/X_uq62
+ COMPLETE_PROYECT_FIG_0/X_uq63 COMPLETE_PROYECT_FIG_0/X_uq64 COMPLETE_PROYECT_FIG_0/X_uq65
+ COMPLETE_PROYECT_FIG_0/X_uq66 COMPLETE_PROYECT_FIG_0/X_uq67 COMPLETE_PROYECT_FIG_0/X_uq68
+ COMPLETE_PROYECT_FIG_0/X_uq69 COMPLETE_PROYECT_FIG_0/X_uq70 COMPLETE_PROYECT_FIG_0/X_uq72
+ COMPLETE_PROYECT_FIG_0/X_uq73 COMPLETE_PROYECT_FIG_0/X_uq74 COMPLETE_PROYECT_FIG_0/X_uq77
+ COMPLETE_PROYECT_FIG_0/X_uq78 COMPLETE_PROYECT_FIG_0/X_uq79 COMPLETE_PROYECT_FIG_0/X_uq80
+ COMPLETE_PROYECT_FIG_0/X_uq81 COMPLETE_PROYECT_FIG_0/X_uq82 COMPLETE_PROYECT_FIG_0/X_uq83
+ COMPLETE_PROYECT_FIG_0/X_uq84 COMPLETE_PROYECT_FIG_0/X_uq85 COMPLETE_PROYECT_FIG_0/X_uq88
+ COMPLETE_PROYECT_FIG_0/X_uq89 COMPLETE_PROYECT_FIG_0/X_uq90 COMPLETE_PROYECT_FIG_0/X_uq91
+ COMPLETE_PROYECT_FIG_0/X_uq93 COMPLETE_PROYECT_FIG_0/X_uq94 COMPLETE_PROYECT_FIG_0/X_uq95
+ COMPLETE_PROYECT_FIG_0/X_uq96 COMPLETE_PROYECT_FIG_0/X_uq97 COMPLETE_PROYECT_FIG_0/X_uq98
+ COMPLETE_PROYECT_FIG_0/X_uq99 COMPLETE_PROYECT_FIG_0/X_uq112 COMPLETE_PROYECT_FIG_0/X_uq113
+ COMPLETE_PROYECT_FIG_0/X_uq123 COMPLETE_PROYECT_FIG_0/X_uq135 COMPLETE_PROYECT_FIG_0/X_uq136
+ COMPLETE_PROYECT_FIG_0/X_uq137 COMPLETE_PROYECT_FIG_0/X_uq138 COMPLETE_PROYECT_FIG_0/X_uq141
+ COMPLETE_PROYECT_FIG_0/X_uq143 COMPLETE_PROYECT_FIG_0/X_uq144 COMPLETE_PROYECT_FIG_0/X_uq145
+ COMPLETE_PROYECT_FIG_0/X_uq147 COMPLETE_PROYECT_FIG_0/X_uq148 COMPLETE_PROYECT_FIG_0/X_uq150
+ COMPLETE_PROYECT_FIG_0/X_uq152 COMPLETE_PROYECT_FIG_0/X_uq156 COMPLETE_PROYECT_FIG_0/X_uq157
+ COMPLETE_PROYECT_FIG_0/X_uq159 COMPLETE_PROYECT_FIG_0/X_uq160 COMPLETE_PROYECT_FIG_0/X_uq162
+ COMPLETE_PROYECT_FIG_0/X_uq163 COMPLETE_PROYECT_FIG_0/X_uq164 COMPLETE_PROYECT_FIG_0/X_uq167
+ COMPLETE_PROYECT_FIG_0/X_uq168 COMPLETE_PROYECT_FIG_0/X_uq170 COMPLETE_PROYECT_FIG_0/X_uq171
+ COMPLETE_PROYECT_FIG_0/X_uq172 COMPLETE_PROYECT_FIG_0/X_uq173 COMPLETE_PROYECT_FIG_0/X_uq174
+ COMPLETE_PROYECT_FIG_0/X_uq175 COMPLETE_PROYECT_FIG_0/X_uq176 COMPLETE_PROYECT_FIG_0/X_uq177
+ COMPLETE_PROYECT_FIG_0/X_uq178 COMPLETE_PROYECT_FIG_0/X_uq179 COMPLETE_PROYECT_FIG_0/X_uq182
+ COMPLETE_PROYECT_FIG_0/X_uq183 COMPLETE_PROYECT_FIG_0/X_uq184 COMPLETE_PROYECT_FIG_0/X_uq185
+ COMPLETE_PROYECT_FIG_0/X_uq188 COMPLETE_PROYECT_FIG_0/X_uq189 COMPLETE_PROYECT_FIG_0/X_uq190
+ COMPLETE_PROYECT_FIG_0/X_uq191 COMPLETE_PROYECT_FIG_0/X_uq192 COMPLETE_PROYECT_FIG_0/X_uq193
+ COMPLETE_PROYECT_FIG_0/X_uq194 COMPLETE_PROYECT_FIG_0/X_uq195 COMPLETE_PROYECT_FIG_0/X_uq197
+ COMPLETE_PROYECT_FIG_0/X_uq198 COMPLETE_PROYECT_FIG_0/X_uq199 COMPLETE_PROYECT_FIG_0/X_uq200
+ COMPLETE_PROYECT_FIG_0/X_uq201 COMPLETE_PROYECT_FIG_0/X_uq202 COMPLETE_PROYECT_FIG_0/X_uq203
+ COMPLETE_PROYECT_FIG_0/X_uq205 COMPLETE_PROYECT_FIG_0/X_uq206 COMPLETE_PROYECT_FIG_0/X_uq208
+ COMPLETE_PROYECT_FIG_0/X_uq210 COMPLETE_PROYECT_FIG_0/X_uq211 COMPLETE_PROYECT_FIG_0/X_uq212
+ COMPLETE_PROYECT_FIG_0/X_uq215 COMPLETE_PROYECT_FIG_0/X_uq216 COMPLETE_PROYECT_FIG_0/X_uq218
+ COMPLETE_PROYECT_FIG_0/X_uq219 COMPLETE_PROYECT_FIG_0/X_uq220 COMPLETE_PROYECT_FIG_0/X_uq221
+ COMPLETE_PROYECT_FIG_0/X_uq222 COMPLETE_PROYECT_FIG_0/X_uq224 COMPLETE_PROYECT_FIG_0/X_uq226
+ COMPLETE_PROYECT_FIG_0/X_uq233 COMPLETE_PROYECT_FIG_0/X_uq235 COMPLETE_PROYECT_FIG_0/X_uq236
+ COMPLETE_PROYECT_FIG_0/X_uq237 COMPLETE_PROYECT_FIG_0/X_uq239 COMPLETE_PROYECT_FIG_0/X_uq240
+ COMPLETE_PROYECT_FIG_0/X_uq241 COMPLETE_PROYECT_FIG_0/X_uq242 COMPLETE_PROYECT_FIG_0/X_uq243
+ COMPLETE_PROYECT_FIG_0/X_uq244 COMPLETE_PROYECT_FIG_0/X_uq247 COMPLETE_PROYECT_FIG_0/X_uq248
+ COMPLETE_PROYECT_FIG_0/X_uq249 COMPLETE_PROYECT_FIG_0/X_uq250 COMPLETE_PROYECT_FIG_0/X_uq251
+ COMPLETE_PROYECT_FIG_0/X_uq255 COMPLETE_PROYECT_FIG_0/X_uq256 COMPLETE_PROYECT_FIG_0/X_uq259
+ COMPLETE_PROYECT_FIG_0/X_uq260 COMPLETE_PROYECT_FIG_0/X_uq262 COMPLETE_PROYECT_FIG_0/X_uq263
+ COMPLETE_PROYECT_FIG_0/X_uq264 COMPLETE_PROYECT_FIG_0/X_uq266 COMPLETE_PROYECT_FIG_0/X_uq267
+ COMPLETE_PROYECT_FIG_0/X_uq268 COMPLETE_PROYECT_FIG_0/X_uq271 COMPLETE_PROYECT_FIG_0/X_uq272
+ COMPLETE_PROYECT_FIG_0/X_uq273 COMPLETE_PROYECT_FIG_0/X_uq275 COMPLETE_PROYECT_FIG_0/X_uq276
+ COMPLETE_PROYECT_FIG_0/X_uq277 COMPLETE_PROYECT_FIG_0/X_uq279 COMPLETE_PROYECT_FIG_0/X_uq280
+ COMPLETE_PROYECT_FIG_0/X_uq281 COMPLETE_PROYECT_FIG_0/X_uq282 COMPLETE_PROYECT_FIG_0/X_uq284
+ COMPLETE_PROYECT_FIG_0/X_uq286 COMPLETE_PROYECT_FIG_0/X_uq293 COMPLETE_PROYECT_FIG_0/X_uq294
+ COMPLETE_PROYECT_FIG_0/X_uq297 COMPLETE_PROYECT_FIG_0/X_uq300 COMPLETE_PROYECT_FIG_0/X_uq303
+ COMPLETE_PROYECT_FIG_0/X_uq304 COMPLETE_PROYECT_FIG_0/X_uq305 COMPLETE_PROYECT_FIG_0/X_uq308
+ COMPLETE_PROYECT_FIG_0/X_uq311 COMPLETE_PROYECT_FIG_0/X_uq312 COMPLETE_PROYECT_FIG_0/X_uq313
+ COMPLETE_PROYECT_FIG_0/X_uq314 COMPLETE_PROYECT_FIG_0/X_uq315 COMPLETE_PROYECT_FIG_0/X_uq319
+ COMPLETE_PROYECT_FIG_0/X_uq321 COMPLETE_PROYECT_FIG_0/X_uq323 COMPLETE_PROYECT_FIG_0/X_uq324
+ COMPLETE_PROYECT_FIG_0/X_uq326 COMPLETE_PROYECT_FIG_0/X_uq328 COMPLETE_PROYECT_FIG_0/X_uq333
+ COMPLETE_PROYECT_FIG_0/X_uq335 COMPLETE_PROYECT_FIG_0/X_uq341 COMPLETE_PROYECT_FIG_0/X_uq345
+ COMPLETE_PROYECT_FIG_0/X_uq348 COMPLETE_PROYECT_FIG_0/A_uq24 COMPLETE_PROYECT_FIG_0/X_uq352
+ COMPLETE_PROYECT_FIG_0/A_uq30 COMPLETE_PROYECT_FIG_0/SLN[7] COMPLETE_PROYECT_FIG_0/SLN[6]
+ COMPLETE_PROYECT_FIG_0/X_uq372 COMPLETE_PROYECT_FIG_0/X_uq373 COMPLETE_PROYECT_FIG_0/X_uq375
+ COMPLETE_PROYECT_FIG_0/X_uq376 COMPLETE_PROYECT_FIG_0/X_uq379 COMPLETE_PROYECT_FIG_0/X_uq382
+ COMPLETE_PROYECT_FIG_0/X_uq383 COMPLETE_PROYECT_FIG_0/X_uq387 COMPLETE_PROYECT_FIG_0/X_uq390
+ COMPLETE_PROYECT_FIG_0/A COMPLETE_PROYECT_FIG_0/A_uq0 COMPLETE_PROYECT_FIG_0/X_uq397
+ COMPLETE_PROYECT_FIG_0/X_uq399 COMPLETE_PROYECT_FIG_0/X_uq400 COMPLETE_PROYECT_FIG_0/X_uq401
+ COMPLETE_PROYECT_FIG_0/X_uq404 COMPLETE_PROYECT_FIG_0/X_uq405 COMPLETE_PROYECT_FIG_0/X_uq406
+ COMPLETE_PROYECT_FIG_0/X_uq407 COMPLETE_PROYECT_FIG_0/X_uq409 COMPLETE_PROYECT_FIG_0/X_uq411
+ COMPLETE_PROYECT_FIG_0/X_uq412 COMPLETE_PROYECT_FIG_0/X_uq413 COMPLETE_PROYECT_FIG_0/X_uq420
+ COMPLETE_PROYECT_FIG_0/A_uq37 COMPLETE_PROYECT_FIG_0/X_uq424 COMPLETE_PROYECT_FIG_0/X_uq425
+ COMPLETE_PROYECT_FIG_0/X_uq426 COMPLETE_PROYECT_FIG_0/X_uq427 COMPLETE_PROYECT_FIG_0/X_uq429
+ COMPLETE_PROYECT_FIG_0/X_uq430 COMPLETE_PROYECT_FIG_0/X_uq431 COMPLETE_PROYECT_FIG_0/X_uq432
+ COMPLETE_PROYECT_FIG_0/X_uq433 COMPLETE_PROYECT_FIG_0/X_uq434 COMPLETE_PROYECT_FIG_0/X_uq435
+ COMPLETE_PROYECT_FIG_0/X_uq436 COMPLETE_PROYECT_FIG_0/X_uq437 COMPLETE_PROYECT_FIG_0/X_uq438
+ COMPLETE_PROYECT_FIG_0/A_uq15 COMPLETE_PROYECT_FIG_0/A_uq20 COMPLETE_PROYECT_FIG_0/X_uq444
+ COMPLETE_PROYECT_FIG_0/X_uq445 COMPLETE_PROYECT_FIG_0/X_uq446 COMPLETE_PROYECT_FIG_0/X_uq447
+ COMPLETE_PROYECT_FIG_0/X_uq448 COMPLETE_PROYECT_FIG_0/X_uq449 COMPLETE_PROYECT_FIG_0/X_uq450
+ COMPLETE_PROYECT_FIG_0/X_uq451 COMPLETE_PROYECT_FIG_0/X_uq452 COMPLETE_PROYECT_FIG_0/X_uq454
+ COMPLETE_PROYECT_FIG_0/X_uq455 COMPLETE_PROYECT_FIG_0/X_uq458 COMPLETE_PROYECT_FIG_0/A_uq2
+ COMPLETE_PROYECT_FIG_0/A_uq6 COMPLETE_PROYECT_FIG_0/A_uq7 COMPLETE_PROYECT_FIG_0/A_uq8
+ COMPLETE_PROYECT_FIG_0/A_uq19 COMPLETE_PROYECT_FIG_0/A_uq38 COMPLETE_PROYECT_FIG_0/A_uq44
+ COMPLETE_PROYECT_FIG_0/A_uq57 COMPLETE_PROYECT_FIG_0/A_uq65 COMPLETE_PROYECT_FIG_0/A_uq71
+ COMPLETE_PROYECT_FIG_0/A_uq72 COMPLETE_PROYECT_FIG_0/A_uq74 COMPLETE_PROYECT_FIG_0/A_uq75
+ COMPLETE_PROYECT_FIG_0/A_uq76 COMPLETE_PROYECT_FIG_0/A_uq80 COMPLETE_PROYECT_FIG_0/A_uq81
+ COMPLETE_PROYECT_FIG_0/A_uq82 COMPLETE_PROYECT_FIG_0/A_uq87 COMPLETE_PROYECT_FIG_0/A_uq88
+ COMPLETE_PROYECT_FIG_0/A_uq89 COMPLETE_PROYECT_FIG_0/A_uq90 COMPLETE_PROYECT_FIG_0/A_uq91
+ COMPLETE_PROYECT_FIG_0/A_uq92 COMPLETE_PROYECT_FIG_0/A_uq93 COMPLETE_PROYECT_FIG_0/A_uq94
+ COMPLETE_PROYECT_FIG_0/A_uq95 COMPLETE_PROYECT_FIG_0/A_uq97 COMPLETE_PROYECT_FIG_0/A_uq98
+ COMPLETE_PROYECT_FIG_0/A_uq99 COMPLETE_PROYECT_FIG_0/X_uq325 sg13cmos5l_IOPadIn_0/p2c
+ sg13cmos5l_IOPadIn_6/p2c sg13cmos5l_IOPadIn_1/p2c sg13cmos5l_IOPadIn_2/p2c COMPLETE_PROYECT_FIG_0/A_uq391
+ COMPLETE_PROYECT_FIG_0/Y_uq0 COMPLETE_PROYECT_FIG_0/Y_uq1 COMPLETE_PROYECT_FIG_0/Y_uq2
+ COMPLETE_PROYECT_FIG_0/Y_uq3 COMPLETE_PROYECT_FIG_0/Y_uq4 COMPLETE_PROYECT_FIG_0/Y_uq5
+ COMPLETE_PROYECT_FIG_0/Y_uq6 COMPLETE_PROYECT_FIG_0/Y_uq7 COMPLETE_PROYECT_FIG_0/Y_uq8
+ COMPLETE_PROYECT_FIG_0/Y_uq9 COMPLETE_PROYECT_FIG_0/Y_uq10 COMPLETE_PROYECT_FIG_0/Y_uq11
+ COMPLETE_PROYECT_FIG_0/Y_uq12 COMPLETE_PROYECT_FIG_0/Y_uq13 COMPLETE_PROYECT_FIG_0/Y_uq14
+ COMPLETE_PROYECT_FIG_0/Y_uq15 COMPLETE_PROYECT_FIG_0/Y_uq16 COMPLETE_PROYECT_FIG_0/Y_uq17
+ COMPLETE_PROYECT_FIG_0/Y_uq18 COMPLETE_PROYECT_FIG_0/Y_uq19 COMPLETE_PROYECT_FIG_0/Y_uq20
+ COMPLETE_PROYECT_FIG_0/Y_uq21 COMPLETE_PROYECT_FIG_0/Y_uq22 COMPLETE_PROYECT_FIG_0/Y_uq23
+ COMPLETE_PROYECT_FIG_0/Y_uq24 COMPLETE_PROYECT_FIG_0/Y_uq25 COMPLETE_PROYECT_FIG_0/Y_uq26
+ COMPLETE_PROYECT_FIG_0/Y_uq27 COMPLETE_PROYECT_FIG_0/Y_uq28 COMPLETE_PROYECT_FIG_0/Y_uq29
+ COMPLETE_PROYECT_FIG_0/Y_uq30 COMPLETE_PROYECT_FIG_0/Y_uq31 COMPLETE_PROYECT_FIG_0/Y_uq32
+ COMPLETE_PROYECT_FIG_0/Y_uq33 COMPLETE_PROYECT_FIG_0/Y_uq34 COMPLETE_PROYECT_FIG_0/Y_uq35
+ COMPLETE_PROYECT_FIG_0/Y_uq36 COMPLETE_PROYECT_FIG_0/Y_uq37 COMPLETE_PROYECT_FIG_0/Y_uq39
+ COMPLETE_PROYECT_FIG_0/Y_uq40 COMPLETE_PROYECT_FIG_0/Y_uq41 COMPLETE_PROYECT_FIG_0/Y_uq42
+ COMPLETE_PROYECT_FIG_0/Y_uq44 COMPLETE_PROYECT_FIG_0/Y_uq45 COMPLETE_PROYECT_FIG_0/Y_uq47
+ COMPLETE_PROYECT_FIG_0/Y_uq48 COMPLETE_PROYECT_FIG_0/Y_uq49 COMPLETE_PROYECT_FIG_0/Y_uq51
+ COMPLETE_PROYECT_FIG_0/Y_uq52 COMPLETE_PROYECT_FIG_0/Y_uq54 COMPLETE_PROYECT_FIG_0/Y_uq55
+ COMPLETE_PROYECT_FIG_0/Y_uq56 COMPLETE_PROYECT_FIG_0/Y_uq57 COMPLETE_PROYECT_FIG_0/Y_uq62
+ COMPLETE_PROYECT_FIG_0/Y_uq63 COMPLETE_PROYECT_FIG_0/Y_uq64 COMPLETE_PROYECT_FIG_0/Y_uq65
+ COMPLETE_PROYECT_FIG_0/Y_uq66 COMPLETE_PROYECT_FIG_0/Y_uq68 COMPLETE_PROYECT_FIG_0/Y_uq70
+ COMPLETE_PROYECT_FIG_0/Y_uq71 COMPLETE_PROYECT_FIG_0/Y_uq72 COMPLETE_PROYECT_FIG_0/Y_uq73
+ COMPLETE_PROYECT_FIG_0/Y_uq74 COMPLETE_PROYECT_FIG_0/Y_uq75 COMPLETE_PROYECT_FIG_0/Y_uq76
+ COMPLETE_PROYECT_FIG_0/Y_uq80 COMPLETE_PROYECT_FIG_0/Y_uq82 COMPLETE_PROYECT_FIG_0/Y_uq83
+ COMPLETE_PROYECT_FIG_0/Y_uq84 COMPLETE_PROYECT_FIG_0/Y_uq85 COMPLETE_PROYECT_FIG_0/Y_uq86
+ COMPLETE_PROYECT_FIG_0/Y_uq88 COMPLETE_PROYECT_FIG_0/Y_uq89 COMPLETE_PROYECT_FIG_0/Y_uq90
+ COMPLETE_PROYECT_FIG_0/Y_uq91 COMPLETE_PROYECT_FIG_0/Y_uq92 COMPLETE_PROYECT_FIG_0/Y_uq93
+ COMPLETE_PROYECT_FIG_0/Y_uq94 COMPLETE_PROYECT_FIG_0/Y_uq95 COMPLETE_PROYECT_FIG_0/Y_uq97
+ COMPLETE_PROYECT_FIG_0/Y_uq98 COMPLETE_PROYECT_FIG_0/Y_uq103 COMPLETE_PROYECT_FIG_0/Y_uq104
+ COMPLETE_PROYECT_FIG_0/Y_uq105 COMPLETE_PROYECT_FIG_0/Y_uq107 COMPLETE_PROYECT_FIG_0/Y_uq109
+ COMPLETE_PROYECT_FIG_0/Y_uq110 COMPLETE_PROYECT_FIG_0/Y_uq113 COMPLETE_PROYECT_FIG_0/Y_uq116
+ COMPLETE_PROYECT_FIG_0/Y_uq119 COMPLETE_PROYECT_FIG_0/Y_uq122 COMPLETE_PROYECT_FIG_0/Y_uq127
+ COMPLETE_PROYECT_FIG_0/Y_uq129 COMPLETE_PROYECT_FIG_0/Y_uq130 COMPLETE_PROYECT_FIG_0/Y_uq131
+ COMPLETE_PROYECT_FIG_0/Y_uq133 COMPLETE_PROYECT_FIG_0/Y_uq137 COMPLETE_PROYECT_FIG_0/Y_uq139
+ COMPLETE_PROYECT_FIG_0/Y_uq141 COMPLETE_PROYECT_FIG_0/Y_uq142 COMPLETE_PROYECT_FIG_0/Y_uq144
+ COMPLETE_PROYECT_FIG_0/Y_uq146 COMPLETE_PROYECT_FIG_0/Y_uq148 COMPLETE_PROYECT_FIG_0/Y_uq149
+ COMPLETE_PROYECT_FIG_0/Y_uq152 COMPLETE_PROYECT_FIG_0/Y_uq155 COMPLETE_PROYECT_FIG_0/Y_uq159
+ COMPLETE_PROYECT_FIG_0/Y_uq162 COMPLETE_PROYECT_FIG_0/Y_uq163 COMPLETE_PROYECT_FIG_0/Y_uq164
+ COMPLETE_PROYECT_FIG_0/Y_uq165 COMPLETE_PROYECT_FIG_0/Y_uq167 COMPLETE_PROYECT_FIG_0/Y_uq169
+ COMPLETE_PROYECT_FIG_0/Y_uq172 COMPLETE_PROYECT_FIG_0/Y_uq174 COMPLETE_PROYECT_FIG_0/Y_uq176
+ COMPLETE_PROYECT_FIG_0/Y_uq178 COMPLETE_PROYECT_FIG_0/Y_uq180 COMPLETE_PROYECT_FIG_0/Y_uq181
+ COMPLETE_PROYECT_FIG_0/Y_uq185 COMPLETE_PROYECT_FIG_0/Y_uq186 COMPLETE_PROYECT_FIG_0/Y_uq188
+ COMPLETE_PROYECT_FIG_0/Y_uq189 COMPLETE_PROYECT_FIG_0/Y_uq190 COMPLETE_PROYECT_FIG_0/Y_uq192
+ COMPLETE_PROYECT_FIG_0/Y_uq194 COMPLETE_PROYECT_FIG_0/Y_uq195 COMPLETE_PROYECT_FIG_0/Y_uq196
+ COMPLETE_PROYECT_FIG_0/Y_uq197 COMPLETE_PROYECT_FIG_0/Y_uq199 COMPLETE_PROYECT_FIG_0/Y_uq201
+ COMPLETE_PROYECT_FIG_0/Y_uq203 COMPLETE_PROYECT_FIG_0/Y_uq205 COMPLETE_PROYECT_FIG_0/Y_uq206
+ COMPLETE_PROYECT_FIG_0/Y_uq207 COMPLETE_PROYECT_FIG_0/Y_uq208 COMPLETE_PROYECT_FIG_0/Y_uq209
+ COMPLETE_PROYECT_FIG_0/Y_uq210 COMPLETE_PROYECT_FIG_0/Y_uq211 COMPLETE_PROYECT_FIG_0/Y_uq212
+ COMPLETE_PROYECT_FIG_0/Y_uq214 COMPLETE_PROYECT_FIG_0/Y_uq219 COMPLETE_PROYECT_FIG_0/Y_uq228
+ COMPLETE_PROYECT_FIG_0/Y_uq229 COMPLETE_PROYECT_FIG_0/Y_uq230 COMPLETE_PROYECT_FIG_0/Y_uq231
+ COMPLETE_PROYECT_FIG_0/Y_uq232 COMPLETE_PROYECT_FIG_0/Y_uq233 COMPLETE_PROYECT_FIG_0/Y_uq234
+ COMPLETE_PROYECT_FIG_0/Y_uq235 COMPLETE_PROYECT_FIG_0/Y_uq236 COMPLETE_PROYECT_FIG_0/Y_uq237
+ COMPLETE_PROYECT_FIG_0/Y_uq238 COMPLETE_PROYECT_FIG_0/Y_uq239 COMPLETE_PROYECT_FIG_0/Y_uq240
+ COMPLETE_PROYECT_FIG_0/Y_uq242 COMPLETE_PROYECT_FIG_0/Y_uq243 COMPLETE_PROYECT_FIG_0/Y_uq246
+ COMPLETE_PROYECT_FIG_0/Y_uq247 COMPLETE_PROYECT_FIG_0/Y_uq249 COMPLETE_PROYECT_FIG_0/Y_uq250
+ COMPLETE_PROYECT_FIG_0/Y_uq252 COMPLETE_PROYECT_FIG_0/Y_uq253 COMPLETE_PROYECT_FIG_0/Y_uq254
+ COMPLETE_PROYECT_FIG_0/Y_uq256 COMPLETE_PROYECT_FIG_0/Y_uq257 COMPLETE_PROYECT_FIG_0/Y_uq258
+ COMPLETE_PROYECT_FIG_0/Y_uq260 COMPLETE_PROYECT_FIG_0/Y_uq261 COMPLETE_PROYECT_FIG_0/Y_uq263
+ COMPLETE_PROYECT_FIG_0/Y_uq264 COMPLETE_PROYECT_FIG_0/Y_uq265 COMPLETE_PROYECT_FIG_0/Y_uq266
+ COMPLETE_PROYECT_FIG_0/Y_uq267 COMPLETE_PROYECT_FIG_0/Y_uq268 COMPLETE_PROYECT_FIG_0/Y_uq269
+ COMPLETE_PROYECT_FIG_0/Y_uq270 COMPLETE_PROYECT_FIG_0/Y_uq271 COMPLETE_PROYECT_FIG_0/Y_uq272
+ COMPLETE_PROYECT_FIG_0/Y_uq276 COMPLETE_PROYECT_FIG_0/Y_uq277 COMPLETE_PROYECT_FIG_0/Y_uq280
+ COMPLETE_PROYECT_FIG_0/Y_uq281 COMPLETE_PROYECT_FIG_0/Y_uq283 COMPLETE_PROYECT_FIG_0/Y_uq285
+ COMPLETE_PROYECT_FIG_0/Y_uq286 COMPLETE_PROYECT_FIG_0/Y_uq288 COMPLETE_PROYECT_FIG_0/Y_uq289
+ COMPLETE_PROYECT_FIG_0/Y_uq290 COMPLETE_PROYECT_FIG_0/Y_uq291 COMPLETE_PROYECT_FIG_0/Y_uq292
+ COMPLETE_PROYECT_FIG_0/Y_uq293 COMPLETE_PROYECT_FIG_0/Y_uq294 COMPLETE_PROYECT_FIG_0/Y_uq295
+ COMPLETE_PROYECT_FIG_0/Y_uq303 COMPLETE_PROYECT_FIG_0/Y_uq304 COMPLETE_PROYECT_FIG_0/Y_uq306
+ COMPLETE_PROYECT_FIG_0/Y_uq308 COMPLETE_PROYECT_FIG_0/Y_uq309 COMPLETE_PROYECT_FIG_0/Y_uq310
+ COMPLETE_PROYECT_FIG_0/Y_uq311 COMPLETE_PROYECT_FIG_0/Y_uq314 COMPLETE_PROYECT_FIG_0/Y_uq317
+ COMPLETE_PROYECT_FIG_0/Y_uq318 COMPLETE_PROYECT_FIG_0/Y_uq319 COMPLETE_PROYECT_FIG_0/Y_uq322
+ COMPLETE_PROYECT_FIG_0/Y_uq324 COMPLETE_PROYECT_FIG_0/Y_uq326 COMPLETE_PROYECT_FIG_0/Y_uq328
+ COMPLETE_PROYECT_FIG_0/Y_uq329 COMPLETE_PROYECT_FIG_0/Y_uq331 COMPLETE_PROYECT_FIG_0/Y_uq332
+ COMPLETE_PROYECT_FIG_0/Y_uq334 COMPLETE_PROYECT_FIG_0/Y_uq335 COMPLETE_PROYECT_FIG_0/Y_uq337
+ COMPLETE_PROYECT_FIG_0/Y_uq338 COMPLETE_PROYECT_FIG_0/Y_uq339 COMPLETE_PROYECT_FIG_0/Y_uq340
+ COMPLETE_PROYECT_FIG_0/Y_uq342 COMPLETE_PROYECT_FIG_0/Y_uq344 COMPLETE_PROYECT_FIG_0/Y_uq345
+ COMPLETE_PROYECT_FIG_0/Y_uq346 COMPLETE_PROYECT_FIG_0/Y_uq347 COMPLETE_PROYECT_FIG_0/Y_uq349
+ COMPLETE_PROYECT_FIG_0/Y_uq351 COMPLETE_PROYECT_FIG_0/Y_uq352 COMPLETE_PROYECT_FIG_0/Y_uq353
+ COMPLETE_PROYECT_FIG_0/Y_uq356 COMPLETE_PROYECT_FIG_0/Y_uq357 COMPLETE_PROYECT_FIG_0/Y_uq358
+ COMPLETE_PROYECT_FIG_0/Y_uq360 COMPLETE_PROYECT_FIG_0/Y_uq363 COMPLETE_PROYECT_FIG_0/Y_uq364
+ COMPLETE_PROYECT_FIG_0/Y_uq366 COMPLETE_PROYECT_FIG_0/B_uq1 COMPLETE_PROYECT_FIG_0/B_uq2
+ COMPLETE_PROYECT_FIG_0/B_uq3 COMPLETE_PROYECT_FIG_0/B_uq4 COMPLETE_PROYECT_FIG_0/B_uq5
+ COMPLETE_PROYECT_FIG_0/B_uq6 COMPLETE_PROYECT_FIG_0/B_uq7 COMPLETE_PROYECT_FIG_0/B_uq8
+ COMPLETE_PROYECT_FIG_0/B_uq9 COMPLETE_PROYECT_FIG_0/B_uq10 COMPLETE_PROYECT_FIG_0/B_uq11
+ COMPLETE_PROYECT_FIG_0/B_uq12 COMPLETE_PROYECT_FIG_0/B_uq13 COMPLETE_PROYECT_FIG_0/B_uq14
+ COMPLETE_PROYECT_FIG_0/B_uq15 COMPLETE_PROYECT_FIG_0/B_uq16 COMPLETE_PROYECT_FIG_0/B_uq17
+ COMPLETE_PROYECT_FIG_0/B_uq18 COMPLETE_PROYECT_FIG_0/B_uq19 COMPLETE_PROYECT_FIG_0/B_uq20
+ COMPLETE_PROYECT_FIG_0/B_uq21 COMPLETE_PROYECT_FIG_0/B_uq22 COMPLETE_PROYECT_FIG_0/B_uq23
+ COMPLETE_PROYECT_FIG_0/B_uq24 COMPLETE_PROYECT_FIG_0/B_uq25 COMPLETE_PROYECT_FIG_0/B_uq26
+ COMPLETE_PROYECT_FIG_0/B_uq27 COMPLETE_PROYECT_FIG_0/B_uq28 COMPLETE_PROYECT_FIG_0/B_uq29
+ COMPLETE_PROYECT_FIG_0/B_uq30 COMPLETE_PROYECT_FIG_0/B_uq31 COMPLETE_PROYECT_FIG_0/B_uq32
+ COMPLETE_PROYECT_FIG_0/B_uq33 COMPLETE_PROYECT_FIG_0/B_uq38 COMPLETE_PROYECT_FIG_0/B_uq40
+ COMPLETE_PROYECT_FIG_0/B_uq42 COMPLETE_PROYECT_FIG_0/B_uq43 COMPLETE_PROYECT_FIG_0/B_uq48
+ COMPLETE_PROYECT_FIG_0/B_uq49 COMPLETE_PROYECT_FIG_0/B_uq50 COMPLETE_PROYECT_FIG_0/B_uq51
+ COMPLETE_PROYECT_FIG_0/B_uq55 COMPLETE_PROYECT_FIG_0/B_uq58 COMPLETE_PROYECT_FIG_0/B_uq60
+ COMPLETE_PROYECT_FIG_0/B_uq63 COMPLETE_PROYECT_FIG_0/B_uq64 COMPLETE_PROYECT_FIG_0/B_uq65
+ COMPLETE_PROYECT_FIG_0/B_uq66 COMPLETE_PROYECT_FIG_0/B_uq67 COMPLETE_PROYECT_FIG_0/B_uq68
+ COMPLETE_PROYECT_FIG_0/B_uq70 COMPLETE_PROYECT_FIG_0/B_uq73 COMPLETE_PROYECT_FIG_0/B_uq74
+ COMPLETE_PROYECT_FIG_0/B_uq75 COMPLETE_PROYECT_FIG_0/B_uq76 COMPLETE_PROYECT_FIG_0/B_uq77
+ COMPLETE_PROYECT_FIG_0/B_uq78 COMPLETE_PROYECT_FIG_0/B_uq79 COMPLETE_PROYECT_FIG_0/B_uq80
+ COMPLETE_PROYECT_FIG_0/B_uq81 COMPLETE_PROYECT_FIG_0/B_uq83 COMPLETE_PROYECT_FIG_0/B_uq84
+ COMPLETE_PROYECT_FIG_0/B_uq85 COMPLETE_PROYECT_FIG_0/B_uq86 COMPLETE_PROYECT_FIG_0/B_uq87
+ COMPLETE_PROYECT_FIG_0/B_uq88 COMPLETE_PROYECT_FIG_0/B_uq89 COMPLETE_PROYECT_FIG_0/B_uq91
+ COMPLETE_PROYECT_FIG_0/B_uq92 COMPLETE_PROYECT_FIG_0/B_uq93 COMPLETE_PROYECT_FIG_0/B_uq96
+ COMPLETE_PROYECT_FIG_0/C1_uq2 COMPLETE_PROYECT_FIG_0/C1_uq4 COMPLETE_PROYECT_FIG_0/C1_uq5
+ COMPLETE_PROYECT_FIG_0/C1_uq6 COMPLETE_PROYECT_FIG_0/C1_uq7 COMPLETE_PROYECT_FIG_0/C1_uq8
+ COMPLETE_PROYECT_FIG_0/C_uq0 COMPLETE_PROYECT_FIG_0/C_uq1 COMPLETE_PROYECT_FIG_0/C_uq2
+ COMPLETE_PROYECT_FIG_0/C_uq3 COMPLETE_PROYECT_FIG_0/C_uq4 COMPLETE_PROYECT_FIG_0/C_uq5
+ COMPLETE_PROYECT_FIG_0/C_uq6 COMPLETE_PROYECT_FIG_0/C_uq8 COMPLETE_PROYECT_FIG_0/C_uq9
+ COMPLETE_PROYECT_FIG_0/C_uq13 COMPLETE_PROYECT_FIG_0/C_uq14 COMPLETE_PROYECT_FIG_0/C_uq15
+ COMPLETE_PROYECT_FIG_0/C_uq16 COMPLETE_PROYECT_FIG_0/C_uq18 COMPLETE_PROYECT_FIG_0/C_uq19
+ COMPLETE_PROYECT_FIG_0/C_uq20 COMPLETE_PROYECT_FIG_0/C_uq21 COMPLETE_PROYECT_FIG_0/C_uq22
+ COMPLETE_PROYECT_FIG_0/C_uq23 COMPLETE_PROYECT_FIG_0/C_uq24 COMPLETE_PROYECT_FIG_0/C_uq25
+ COMPLETE_PROYECT_FIG_0/C_uq26 COMPLETE_PROYECT_FIG_0/C_uq27 COMPLETE_PROYECT_FIG_0/C_uq28
+ COMPLETE_PROYECT_FIG_0/C_uq29 COMPLETE_PROYECT_FIG_0/C_uq30 COMPLETE_PROYECT_FIG_0/C_uq31
+ COMPLETE_PROYECT_FIG_0/C_uq32 COMPLETE_PROYECT_FIG_0/C_uq33 COMPLETE_PROYECT_FIG_0/C_uq34
+ COMPLETE_PROYECT_FIG_0/C_uq36 COMPLETE_PROYECT_FIG_0/C_uq37 COMPLETE_PROYECT_FIG_0/C_uq39
+ COMPLETE_PROYECT_FIG_0/C_uq42 COMPLETE_PROYECT_FIG_0/C_uq43 COMPLETE_PROYECT_FIG_0/C_uq44
+ COMPLETE_PROYECT_FIG_0/C_uq45 COMPLETE_PROYECT_FIG_0/C_uq46 COMPLETE_PROYECT_FIG_0/C_uq47
+ COMPLETE_PROYECT_FIG_0/C_uq48 COMPLETE_PROYECT_FIG_0/C_uq49 COMPLETE_PROYECT_FIG_0/C_uq50
+ COMPLETE_PROYECT_FIG_0/C_uq51 COMPLETE_PROYECT_FIG_0/C_uq52 COMPLETE_PROYECT_FIG_0/C_uq53
+ COMPLETE_PROYECT_FIG_0/C_uq54 COMPLETE_PROYECT_FIG_0/C_uq55 COMPLETE_PROYECT_FIG_0/C_uq56
+ COMPLETE_PROYECT_FIG_0/C_uq57 COMPLETE_PROYECT_FIG_0/C_uq58 COMPLETE_PROYECT_FIG_0/C_uq59
+ COMPLETE_PROYECT_FIG_0/C_uq60 COMPLETE_PROYECT_FIG_0/C_uq61 COMPLETE_PROYECT_FIG_0/C_uq62
+ COMPLETE_PROYECT_FIG_0/C_uq63 COMPLETE_PROYECT_FIG_0/C_uq64 COMPLETE_PROYECT_FIG_0/C_uq65
+ COMPLETE_PROYECT_FIG_0/C_uq66 COMPLETE_PROYECT_FIG_0/C_uq67 COMPLETE_PROYECT_FIG_0/C_uq68
+ COMPLETE_PROYECT_FIG_0/C_uq69 COMPLETE_PROYECT_FIG_0/C_uq70 COMPLETE_PROYECT_FIG_0/C_uq71
+ COMPLETE_PROYECT_FIG_0/C_uq72 COMPLETE_PROYECT_FIG_0/C_uq73 COMPLETE_PROYECT_FIG_0/B2_uq6
+ COMPLETE_PROYECT_FIG_0/B2_uq7 COMPLETE_PROYECT_FIG_0/B2_uq8 COMPLETE_PROYECT_FIG_0/B2_uq9
+ COMPLETE_PROYECT_FIG_0/A1_uq9 COMPLETE_PROYECT_FIG_0/D_uq0 COMPLETE_PROYECT_FIG_0/D_uq1
+ COMPLETE_PROYECT_FIG_0/D_uq2 COMPLETE_PROYECT_FIG_0/D_uq3 COMPLETE_PROYECT_FIG_0/D_uq4
+ COMPLETE_PROYECT_FIG_0/D_uq5 COMPLETE_PROYECT_FIG_0/D_uq6 COMPLETE_PROYECT_FIG_0/D_uq7
+ COMPLETE_PROYECT_FIG_0/D_uq8 COMPLETE_PROYECT_FIG_0/D_uq9 COMPLETE_PROYECT_FIG_0/D_uq10
+ COMPLETE_PROYECT_FIG_0/D_uq11 COMPLETE_PROYECT_FIG_0/D_uq12 COMPLETE_PROYECT_FIG_0/D_uq13
+ COMPLETE_PROYECT_FIG_0/D_uq14 COMPLETE_PROYECT_FIG_0/D_uq15 COMPLETE_PROYECT_FIG_0/D_uq16
+ COMPLETE_PROYECT_FIG_0/D_uq17 COMPLETE_PROYECT_FIG_0/D_uq18 COMPLETE_PROYECT_FIG_0/D_uq19
+ COMPLETE_PROYECT_FIG_0/D_uq20 COMPLETE_PROYECT_FIG_0/D_uq21 COMPLETE_PROYECT_FIG_0/D_uq22
+ COMPLETE_PROYECT_FIG_0/D_uq23 COMPLETE_PROYECT_FIG_0/D_uq24 COMPLETE_PROYECT_FIG_0/D_uq25
+ COMPLETE_PROYECT_FIG_0/D_uq26 COMPLETE_PROYECT_FIG_0/D_uq27 COMPLETE_PROYECT_FIG_0/D_uq28
+ COMPLETE_PROYECT_FIG_0/D_uq29 COMPLETE_PROYECT_FIG_0/D_uq30 COMPLETE_PROYECT_FIG_0/D_uq31
+ COMPLETE_PROYECT_FIG_0/D_uq32 COMPLETE_PROYECT_FIG_0/D_uq33 COMPLETE_PROYECT_FIG_0/D_uq34
+ COMPLETE_PROYECT_FIG_0/D_uq35 COMPLETE_PROYECT_FIG_0/D_uq36 COMPLETE_PROYECT_FIG_0/D_uq37
+ COMPLETE_PROYECT_FIG_0/D_uq38 COMPLETE_PROYECT_FIG_0/D_uq39 COMPLETE_PROYECT_FIG_0/D_uq40
+ COMPLETE_PROYECT_FIG_0/D_uq41 COMPLETE_PROYECT_FIG_0/D_uq42 COMPLETE_PROYECT_FIG_0/D_uq43
+ COMPLETE_PROYECT_FIG_0/D_uq44 COMPLETE_PROYECT_FIG_0/D_uq45 COMPLETE_PROYECT_FIG_0/D_uq46
+ COMPLETE_PROYECT_FIG_0/D_uq47 COMPLETE_PROYECT_FIG_0/D_uq48 COMPLETE_PROYECT_FIG_0/D_uq49
+ COMPLETE_PROYECT_FIG_0/D_uq50 COMPLETE_PROYECT_FIG_0/D_uq51 COMPLETE_PROYECT_FIG_0/D_uq52
+ COMPLETE_PROYECT_FIG_0/D_uq53 COMPLETE_PROYECT_FIG_0/D_uq54 COMPLETE_PROYECT_FIG_0/D_uq55
+ COMPLETE_PROYECT_FIG_0/D_uq56 COMPLETE_PROYECT_FIG_0/D_uq57 COMPLETE_PROYECT_FIG_0/D_uq58
+ COMPLETE_PROYECT_FIG_0/D_uq59 COMPLETE_PROYECT_FIG_0/D_uq60 COMPLETE_PROYECT_FIG_0/D_uq61
+ COMPLETE_PROYECT_FIG_0/D_uq62 COMPLETE_PROYECT_FIG_0/D_uq63 COMPLETE_PROYECT_FIG_0/D_uq64
+ COMPLETE_PROYECT_FIG_0/D_uq65 COMPLETE_PROYECT_FIG_0/L_HI_uq0 COMPLETE_PROYECT_FIG_0/L_HI_uq1
+ COMPLETE_PROYECT_FIG_0/L_HI_uq2 COMPLETE_PROYECT_FIG_0/L_HI_uq3 COMPLETE_PROYECT_FIG_0/L_HI_uq4
+ COMPLETE_PROYECT_FIG_0/L_HI_uq5 COMPLETE_PROYECT_FIG_0/L_HI_uq6 COMPLETE_PROYECT_FIG_0/L_HI_uq7
+ COMPLETE_PROYECT_FIG_0/L_HI_uq8 COMPLETE_PROYECT_FIG_0/L_HI_uq9 COMPLETE_PROYECT_FIG_0/L_HI_uq10
+ COMPLETE_PROYECT_FIG_0/L_HI_uq11 COMPLETE_PROYECT_FIG_0/L_HI_uq12 COMPLETE_PROYECT_FIG_0/L_HI_uq13
+ COMPLETE_PROYECT_FIG_0/L_HI_uq14 COMPLETE_PROYECT_FIG_0/L_HI_uq15 COMPLETE_PROYECT_FIG_0/L_HI_uq16
+ COMPLETE_PROYECT_FIG_0/L_HI_uq17 COMPLETE_PROYECT_FIG_0/L_HI_uq18 COMPLETE_PROYECT_FIG_0/L_HI_uq19
+ COMPLETE_PROYECT_FIG_0/L_HI_uq20 COMPLETE_PROYECT_FIG_0/L_HI_uq21 COMPLETE_PROYECT_FIG_0/L_HI_uq22
+ COMPLETE_PROYECT_FIG_0/L_HI_uq23 COMPLETE_PROYECT_FIG_0/L_HI_uq24 COMPLETE_PROYECT_FIG_0/L_HI_uq25
+ COMPLETE_PROYECT_FIG_0/L_HI_uq26 COMPLETE_PROYECT_FIG_0/L_HI_uq27 COMPLETE_PROYECT_FIG_0/L_HI_uq28
+ COMPLETE_PROYECT_FIG_0/L_HI_uq29 COMPLETE_PROYECT_FIG_0/L_HI_uq30 COMPLETE_PROYECT_FIG_0/L_HI_uq31
+ COMPLETE_PROYECT_FIG_0/L_HI_uq32 COMPLETE_PROYECT_FIG_0/L_HI_uq33 COMPLETE_PROYECT_FIG_0/L_HI_uq34
+ COMPLETE_PROYECT_FIG_0/L_HI_uq35 COMPLETE_PROYECT_FIG_0/L_HI_uq36 COMPLETE_PROYECT_FIG_0/L_HI_uq37
+ COMPLETE_PROYECT_FIG_0/L_HI_uq38 COMPLETE_PROYECT_FIG_0/L_HI_uq39 COMPLETE_PROYECT_FIG_0/L_HI_uq40
+ COMPLETE_PROYECT_FIG_0/A2_uq1 COMPLETE_PROYECT_FIG_0/A2_uq2 COMPLETE_PROYECT_FIG_0/A2_uq3
+ COMPLETE_PROYECT_FIG_0/A2_uq6 COMPLETE_PROYECT_FIG_0/A2_uq9 COMPLETE_PROYECT_FIG_0/B1_uq1
+ COMPLETE_PROYECT_FIG_0/B1_uq2 COMPLETE_PROYECT_FIG_0/B1_uq5 COMPLETE_PROYECT_FIG_0/B1_uq6
+ COMPLETE_PROYECT_FIG_0/B1_uq7 COMPLETE_PROYECT_FIG_0/Q_uq0 COMPLETE_PROYECT_FIG_0/Q_uq1
+ COMPLETE_PROYECT_FIG_0/Q_uq2 COMPLETE_PROYECT_FIG_0/Q_uq3 COMPLETE_PROYECT_FIG_0/Q_uq4
+ COMPLETE_PROYECT_FIG_0/Q_uq5 COMPLETE_PROYECT_FIG_0/Q_uq6 COMPLETE_PROYECT_FIG_0/Q_uq7
+ COMPLETE_PROYECT_FIG_0/Q_uq8 COMPLETE_PROYECT_FIG_0/Q_uq9 COMPLETE_PROYECT_FIG_0/Q_uq10
+ COMPLETE_PROYECT_FIG_0/Q_uq11 COMPLETE_PROYECT_FIG_0/Q_uq12 COMPLETE_PROYECT_FIG_0/Q_uq13
+ COMPLETE_PROYECT_FIG_0/Q_uq14 COMPLETE_PROYECT_FIG_0/Q_uq15 COMPLETE_PROYECT_FIG_0/Q_uq16
+ COMPLETE_PROYECT_FIG_0/Q_uq17 COMPLETE_PROYECT_FIG_0/Q_uq18 COMPLETE_PROYECT_FIG_0/Q_uq19
+ COMPLETE_PROYECT_FIG_0/Q_uq21 COMPLETE_PROYECT_FIG_0/Q_uq22 COMPLETE_PROYECT_FIG_0/Q_uq23
+ COMPLETE_PROYECT_FIG_0/Q_uq24 COMPLETE_PROYECT_FIG_0/Q_uq25 COMPLETE_PROYECT_FIG_0/Q_uq26
+ COMPLETE_PROYECT_FIG_0/Q_uq27 COMPLETE_PROYECT_FIG_0/Q_uq28 COMPLETE_PROYECT_FIG_0/Q_uq29
+ COMPLETE_PROYECT_FIG_0/Q_uq30 COMPLETE_PROYECT_FIG_0/Q_uq31 COMPLETE_PROYECT_FIG_0/Q_uq32
+ COMPLETE_PROYECT_FIG_0/Q_uq33 COMPLETE_PROYECT_FIG_0/Q_uq34 COMPLETE_PROYECT_FIG_0/Q_uq35
+ COMPLETE_PROYECT_FIG_0/Q_uq36 COMPLETE_PROYECT_FIG_0/Q_uq37 COMPLETE_PROYECT_FIG_0/Q_uq38
+ COMPLETE_PROYECT_FIG_0/Q_uq39 COMPLETE_PROYECT_FIG_0/Q_uq40 COMPLETE_PROYECT_FIG_0/Q_uq41
+ COMPLETE_PROYECT_FIG_0/Q_uq42 COMPLETE_PROYECT_FIG_0/Q_uq43 COMPLETE_PROYECT_FIG_0/Q_uq44
+ COMPLETE_PROYECT_FIG_0/Q_uq45 COMPLETE_PROYECT_FIG_0/Q_uq46 COMPLETE_PROYECT_FIG_0/Q_uq47
+ COMPLETE_PROYECT_FIG_0/Q_uq48 COMPLETE_PROYECT_FIG_0/Q_uq49 COMPLETE_PROYECT_FIG_0/Q_uq50
+ COMPLETE_PROYECT_FIG_0/Q_uq51 COMPLETE_PROYECT_FIG_0/Q_uq52 COMPLETE_PROYECT_FIG_0/Q_uq53
+ COMPLETE_PROYECT_FIG_0/Q_uq54 COMPLETE_PROYECT_FIG_0/Q_uq55 COMPLETE_PROYECT_FIG_0/Q_uq56
+ COMPLETE_PROYECT_FIG_0/Q_uq57 COMPLETE_PROYECT_FIG_0/Q_uq58 COMPLETE_PROYECT_FIG_0/Q_uq59
+ COMPLETE_PROYECT_FIG_0/Q_uq60 COMPLETE_PROYECT_FIG_0/S_uq0 COMPLETE_PROYECT_FIG_0/A0_uq0
+ COMPLETE_PROYECT_FIG
Xsg13cmos5l_decap_8_1281 VSS VDD sg13cmos5l_decap_8
Xsg13cmos5l_decap_8_1292 VSS VDD sg13cmos5l_decap_8
Xsg13cmos5l_decap_8_1270 VSS VDD sg13cmos5l_decap_8
Xsg13cmos5l_decap_8_806 VSS VDD sg13cmos5l_decap_8
Xsg13cmos5l_decap_8_828 VSS VDD sg13cmos5l_decap_8
Xsg13cmos5l_decap_8_817 VSS VDD sg13cmos5l_decap_8
Xsg13cmos5l_decap_8_839 VSS VDD sg13cmos5l_decap_8
Xsg13cmos5l_decap_8_3419 VSS VDD sg13cmos5l_decap_8
Xsg13cmos5l_decap_8_3408 VSS VDD sg13cmos5l_decap_8
Xsg13cmos5l_decap_8_2729 VSS VDD sg13cmos5l_decap_8
Xsg13cmos5l_decap_8_2718 VSS VDD sg13cmos5l_decap_8
Xsg13cmos5l_decap_8_2707 VSS VDD sg13cmos5l_decap_8
Xsg13cmos5l_decap_4_70 VSS VDD sg13cmos5l_decap_4
Xsg13cmos5l_decap_4_92 VSS VDD sg13cmos5l_decap_4
Xsg13cmos5l_decap_4_81 VSS VDD sg13cmos5l_decap_4
Xsg13cmos5l_decap_8_603 VSS VDD sg13cmos5l_decap_8
Xsg13cmos5l_decap_8_636 VSS VDD sg13cmos5l_decap_8
Xsg13cmos5l_decap_8_625 VSS VDD sg13cmos5l_decap_8
Xsg13cmos5l_decap_8_614 VSS VDD sg13cmos5l_decap_8
Xsg13cmos5l_decap_8_658 VSS VDD sg13cmos5l_decap_8
Xsg13cmos5l_decap_8_647 VSS VDD sg13cmos5l_decap_8
Xsg13cmos5l_decap_8_669 VSS VDD sg13cmos5l_decap_8
Xsg13cmos5l_decap_8_3205 VSS VDD sg13cmos5l_decap_8
Xsg13cmos5l_decap_8_3216 VSS VDD sg13cmos5l_decap_8
Xsg13cmos5l_decap_8_3227 VSS VDD sg13cmos5l_decap_8
Xsg13cmos5l_decap_8_3238 VSS VDD sg13cmos5l_decap_8
Xsg13cmos5l_decap_8_3249 VSS VDD sg13cmos5l_decap_8
Xsg13cmos5l_decap_8_2537 VSS VDD sg13cmos5l_decap_8
Xsg13cmos5l_decap_8_2504 VSS VDD sg13cmos5l_decap_8
Xsg13cmos5l_decap_8_2526 VSS VDD sg13cmos5l_decap_8
Xsg13cmos5l_decap_8_2515 VSS VDD sg13cmos5l_decap_8
Xsg13cmos5l_decap_8_2559 VSS VDD sg13cmos5l_decap_8
Xsg13cmos5l_decap_8_2548 VSS VDD sg13cmos5l_decap_8
Xsg13cmos5l_decap_8_1825 VSS VDD sg13cmos5l_decap_8
Xsg13cmos5l_decap_8_1814 VSS VDD sg13cmos5l_decap_8
Xsg13cmos5l_decap_8_1803 VSS VDD sg13cmos5l_decap_8
Xsg13cmos5l_decap_8_1858 VSS VDD sg13cmos5l_decap_8
Xsg13cmos5l_decap_8_1836 VSS VDD sg13cmos5l_decap_8
Xsg13cmos5l_decap_8_1847 VSS VDD sg13cmos5l_decap_8
Xsg13cmos5l_decap_8_1869 VSS VDD sg13cmos5l_decap_8
Xsg13cmos5l_decap_4_105 VSS VDD sg13cmos5l_decap_4
Xsg13cmos5l_decap_4_116 VSS VDD sg13cmos5l_decap_4
Xsg13cmos5l_decap_8_411 VSS VDD sg13cmos5l_decap_8
Xsg13cmos5l_decap_8_400 VSS VDD sg13cmos5l_decap_8
Xsg13cmos5l_decap_8_444 VSS VDD sg13cmos5l_decap_8
Xsg13cmos5l_decap_8_455 VSS VDD sg13cmos5l_decap_8
Xsg13cmos5l_decap_8_433 VSS VDD sg13cmos5l_decap_8
Xsg13cmos5l_decap_8_422 VSS VDD sg13cmos5l_decap_8
Xsg13cmos5l_decap_8_466 VSS VDD sg13cmos5l_decap_8
Xsg13cmos5l_decap_8_477 VSS VDD sg13cmos5l_decap_8
Xsg13cmos5l_decap_8_488 VSS VDD sg13cmos5l_decap_8
Xsg13cmos5l_decap_8_499 VSS VDD sg13cmos5l_decap_8
Xsg13cmos5l_decap_8_3002 VSS VDD sg13cmos5l_decap_8
Xsg13cmos5l_decap_8_3013 VSS VDD sg13cmos5l_decap_8
Xsg13cmos5l_decap_8_3046 VSS VDD sg13cmos5l_decap_8
Xsg13cmos5l_decap_8_3024 VSS VDD sg13cmos5l_decap_8
Xsg13cmos5l_decap_8_3035 VSS VDD sg13cmos5l_decap_8
Xsg13cmos5l_decap_8_2301 VSS VDD sg13cmos5l_decap_8
Xsg13cmos5l_decap_8_2312 VSS VDD sg13cmos5l_decap_8
Xsg13cmos5l_decap_8_3057 VSS VDD sg13cmos5l_decap_8
Xsg13cmos5l_decap_8_3068 VSS VDD sg13cmos5l_decap_8
Xsg13cmos5l_decap_8_3079 VSS VDD sg13cmos5l_decap_8
Xsg13cmos5l_decap_8_2323 VSS VDD sg13cmos5l_decap_8
Xsg13cmos5l_decap_8_2334 VSS VDD sg13cmos5l_decap_8
Xsg13cmos5l_decap_8_2345 VSS VDD sg13cmos5l_decap_8
Xsg13cmos5l_decap_8_1600 VSS VDD sg13cmos5l_decap_8
Xsg13cmos5l_decap_8_2367 VSS VDD sg13cmos5l_decap_8
Xsg13cmos5l_decap_8_2378 VSS VDD sg13cmos5l_decap_8
Xsg13cmos5l_decap_8_2356 VSS VDD sg13cmos5l_decap_8
Xsg13cmos5l_decap_8_1622 VSS VDD sg13cmos5l_decap_8
Xsg13cmos5l_decap_8_1611 VSS VDD sg13cmos5l_decap_8
Xsg13cmos5l_decap_8_1633 VSS VDD sg13cmos5l_decap_8
Xsg13cmos5l_decap_8_2389 VSS VDD sg13cmos5l_decap_8
Xsg13cmos5l_decap_8_1677 VSS VDD sg13cmos5l_decap_8
Xsg13cmos5l_decap_8_1666 VSS VDD sg13cmos5l_decap_8
Xsg13cmos5l_decap_8_1644 VSS VDD sg13cmos5l_decap_8
Xsg13cmos5l_decap_8_1655 VSS VDD sg13cmos5l_decap_8
Xsg13cmos5l_decap_8_1699 VSS VDD sg13cmos5l_decap_8
Xsg13cmos5l_decap_8_1688 VSS VDD sg13cmos5l_decap_8
Xsg13cmos5l_decap_8_2890 VSS VDD sg13cmos5l_decap_8
Xsg13cmos5l_decap_8_230 VSS VDD sg13cmos5l_decap_8
Xsg13cmos5l_decap_8_252 VSS VDD sg13cmos5l_decap_8
Xsg13cmos5l_decap_8_263 VSS VDD sg13cmos5l_decap_8
Xsg13cmos5l_decap_8_241 VSS VDD sg13cmos5l_decap_8
Xsg13cmos5l_decap_8_296 VSS VDD sg13cmos5l_decap_8
Xsg13cmos5l_decap_8_285 VSS VDD sg13cmos5l_decap_8
Xsg13cmos5l_decap_8_274 VSS VDD sg13cmos5l_decap_8
Xsg13cmos5l_decap_8_2120 VSS VDD sg13cmos5l_decap_8
Xsg13cmos5l_decap_8_2131 VSS VDD sg13cmos5l_decap_8
Xsg13cmos5l_decap_8_2142 VSS VDD sg13cmos5l_decap_8
Xsg13cmos5l_decap_8_2153 VSS VDD sg13cmos5l_decap_8
Xsg13cmos5l_decap_8_2175 VSS VDD sg13cmos5l_decap_8
Xsg13cmos5l_decap_8_2164 VSS VDD sg13cmos5l_decap_8
Xsg13cmos5l_decap_8_2186 VSS VDD sg13cmos5l_decap_8
Xsg13cmos5l_decap_8_1441 VSS VDD sg13cmos5l_decap_8
Xsg13cmos5l_decap_8_1430 VSS VDD sg13cmos5l_decap_8
Xsg13cmos5l_decap_8_1452 VSS VDD sg13cmos5l_decap_8
Xsg13cmos5l_decap_8_2197 VSS VDD sg13cmos5l_decap_8
Xsg13cmos5l_decap_8_1485 VSS VDD sg13cmos5l_decap_8
Xsg13cmos5l_decap_8_1474 VSS VDD sg13cmos5l_decap_8
Xsg13cmos5l_decap_8_1463 VSS VDD sg13cmos5l_decap_8
Xsg13cmos5l_decap_8_1496 VSS VDD sg13cmos5l_decap_8
Xsg13cmos5l_decap_8_1260 VSS VDD sg13cmos5l_decap_8
Xsg13cmos5l_decap_8_1282 VSS VDD sg13cmos5l_decap_8
Xsg13cmos5l_decap_8_1293 VSS VDD sg13cmos5l_decap_8
Xsg13cmos5l_decap_8_1271 VSS VDD sg13cmos5l_decap_8
Xsg13cmos5l_decap_8_807 VSS VDD sg13cmos5l_decap_8
Xsg13cmos5l_decap_8_829 VSS VDD sg13cmos5l_decap_8
Xsg13cmos5l_decap_8_818 VSS VDD sg13cmos5l_decap_8
Xsg13cmos5l_decap_8_1090 VSS VDD sg13cmos5l_decap_8
Xsg13cmos5l_decap_8_3409 VSS VDD sg13cmos5l_decap_8
Xsg13cmos5l_decap_8_2719 VSS VDD sg13cmos5l_decap_8
Xsg13cmos5l_decap_8_2708 VSS VDD sg13cmos5l_decap_8
Xsg13cmos5l_decap_4_60 VSS VDD sg13cmos5l_decap_4
Xsg13cmos5l_decap_4_93 VSS VDD sg13cmos5l_decap_4
Xsg13cmos5l_decap_4_82 VSS VDD sg13cmos5l_decap_4
Xsg13cmos5l_decap_4_71 VSS VDD sg13cmos5l_decap_4
Xsg13cmos5l_decap_8_604 VSS VDD sg13cmos5l_decap_8
Xsg13cmos5l_decap_8_637 VSS VDD sg13cmos5l_decap_8
Xsg13cmos5l_decap_8_626 VSS VDD sg13cmos5l_decap_8
Xsg13cmos5l_decap_8_615 VSS VDD sg13cmos5l_decap_8
Xsg13cmos5l_decap_8_659 VSS VDD sg13cmos5l_decap_8
Xsg13cmos5l_decap_8_648 VSS VDD sg13cmos5l_decap_8
Xsg13cmos5l_decap_8_3217 VSS VDD sg13cmos5l_decap_8
Xsg13cmos5l_decap_8_3228 VSS VDD sg13cmos5l_decap_8
Xsg13cmos5l_decap_8_3206 VSS VDD sg13cmos5l_decap_8
Xsg13cmos5l_decap_8_3239 VSS VDD sg13cmos5l_decap_8
Xsg13cmos5l_decap_8_2516 VSS VDD sg13cmos5l_decap_8
Xsg13cmos5l_decap_8_2527 VSS VDD sg13cmos5l_decap_8
Xsg13cmos5l_decap_8_2505 VSS VDD sg13cmos5l_decap_8
Xsg13cmos5l_decap_8_2538 VSS VDD sg13cmos5l_decap_8
Xsg13cmos5l_decap_8_2549 VSS VDD sg13cmos5l_decap_8
Xsg13cmos5l_decap_8_1826 VSS VDD sg13cmos5l_decap_8
Xsg13cmos5l_decap_8_1815 VSS VDD sg13cmos5l_decap_8
Xsg13cmos5l_decap_8_1804 VSS VDD sg13cmos5l_decap_8
Xsg13cmos5l_decap_8_1859 VSS VDD sg13cmos5l_decap_8
Xsg13cmos5l_decap_8_1848 VSS VDD sg13cmos5l_decap_8
Xsg13cmos5l_decap_8_1837 VSS VDD sg13cmos5l_decap_8
Xsg13cmos5l_decap_4_106 VSS VDD sg13cmos5l_decap_4
Xsg13cmos5l_decap_4_117 VSS VDD sg13cmos5l_decap_4
Xsg13cmos5l_decap_8_412 VSS VDD sg13cmos5l_decap_8
Xsg13cmos5l_decap_8_401 VSS VDD sg13cmos5l_decap_8
Xsg13cmos5l_decap_8_445 VSS VDD sg13cmos5l_decap_8
Xsg13cmos5l_decap_8_434 VSS VDD sg13cmos5l_decap_8
Xsg13cmos5l_decap_8_423 VSS VDD sg13cmos5l_decap_8
Xsg13cmos5l_decap_8_467 VSS VDD sg13cmos5l_decap_8
Xsg13cmos5l_decap_8_456 VSS VDD sg13cmos5l_decap_8
Xsg13cmos5l_decap_8_478 VSS VDD sg13cmos5l_decap_8
Xsg13cmos5l_decap_8_489 VSS VDD sg13cmos5l_decap_8
Xsg13cmos5l_decap_8_3003 VSS VDD sg13cmos5l_decap_8
Xsg13cmos5l_decap_8_3014 VSS VDD sg13cmos5l_decap_8
Xsg13cmos5l_decap_8_3047 VSS VDD sg13cmos5l_decap_8
Xsg13cmos5l_decap_8_3025 VSS VDD sg13cmos5l_decap_8
Xsg13cmos5l_decap_8_3036 VSS VDD sg13cmos5l_decap_8
Xsg13cmos5l_decap_8_2302 VSS VDD sg13cmos5l_decap_8
Xsg13cmos5l_decap_8_3069 VSS VDD sg13cmos5l_decap_8
Xsg13cmos5l_decap_8_3058 VSS VDD sg13cmos5l_decap_8
Xsg13cmos5l_decap_8_2335 VSS VDD sg13cmos5l_decap_8
Xsg13cmos5l_decap_8_2324 VSS VDD sg13cmos5l_decap_8
Xsg13cmos5l_decap_8_2313 VSS VDD sg13cmos5l_decap_8
Xsg13cmos5l_decap_8_1601 VSS VDD sg13cmos5l_decap_8
Xsg13cmos5l_decap_8_2368 VSS VDD sg13cmos5l_decap_8
Xsg13cmos5l_decap_8_2346 VSS VDD sg13cmos5l_decap_8
Xsg13cmos5l_decap_8_2379 VSS VDD sg13cmos5l_decap_8
Xsg13cmos5l_decap_8_2357 VSS VDD sg13cmos5l_decap_8
Xsg13cmos5l_decap_8_1623 VSS VDD sg13cmos5l_decap_8
Xsg13cmos5l_decap_8_1612 VSS VDD sg13cmos5l_decap_8
Xsg13cmos5l_decap_8_1634 VSS VDD sg13cmos5l_decap_8
Xsg13cmos5l_decap_8_1667 VSS VDD sg13cmos5l_decap_8
Xsg13cmos5l_decap_8_1656 VSS VDD sg13cmos5l_decap_8
Xsg13cmos5l_decap_8_1645 VSS VDD sg13cmos5l_decap_8
Xsg13cmos5l_decap_8_1689 VSS VDD sg13cmos5l_decap_8
Xsg13cmos5l_decap_8_1678 VSS VDD sg13cmos5l_decap_8
Xsg13cmos5l_decap_8_990 VSS VDD sg13cmos5l_decap_8
Xsg13cmos5l_decap_8_3570 VSS VDD sg13cmos5l_decap_8
Xsg13cmos5l_decap_8_2891 VSS VDD sg13cmos5l_decap_8
Xsg13cmos5l_decap_8_2880 VSS VDD sg13cmos5l_decap_8
Xsg13cmos5l_decap_8_220 VSS VDD sg13cmos5l_decap_8
Xsg13cmos5l_decap_8_253 VSS VDD sg13cmos5l_decap_8
Xsg13cmos5l_decap_8_242 VSS VDD sg13cmos5l_decap_8
Xsg13cmos5l_decap_8_231 VSS VDD sg13cmos5l_decap_8
Xsg13cmos5l_decap_8_297 VSS VDD sg13cmos5l_decap_8
Xsg13cmos5l_decap_8_286 VSS VDD sg13cmos5l_decap_8
Xsg13cmos5l_decap_8_264 VSS VDD sg13cmos5l_decap_8
Xsg13cmos5l_decap_8_275 VSS VDD sg13cmos5l_decap_8
Xsg13cmos5l_IOPadIn_0 input_PAD[3] sg13cmos5l_IOPadIn_0/p2c VDD VSS IOVDD IOVDD sg13cmos5l_IOPadIn
Xsg13cmos5l_decap_8_2110 VSS VDD sg13cmos5l_decap_8
Xsg13cmos5l_decap_8_2132 VSS VDD sg13cmos5l_decap_8
Xsg13cmos5l_decap_8_2154 VSS VDD sg13cmos5l_decap_8
Xsg13cmos5l_decap_8_2143 VSS VDD sg13cmos5l_decap_8
Xsg13cmos5l_decap_8_2121 VSS VDD sg13cmos5l_decap_8
Xsg13cmos5l_decap_8_2165 VSS VDD sg13cmos5l_decap_8
Xsg13cmos5l_decap_8_2176 VSS VDD sg13cmos5l_decap_8
Xsg13cmos5l_decap_8_2187 VSS VDD sg13cmos5l_decap_8
Xsg13cmos5l_decap_8_1442 VSS VDD sg13cmos5l_decap_8
Xsg13cmos5l_decap_8_1431 VSS VDD sg13cmos5l_decap_8
Xsg13cmos5l_decap_8_1420 VSS VDD sg13cmos5l_decap_8
Xsg13cmos5l_decap_8_2198 VSS VDD sg13cmos5l_decap_8
Xsg13cmos5l_decap_8_1475 VSS VDD sg13cmos5l_decap_8
Xsg13cmos5l_decap_8_1464 VSS VDD sg13cmos5l_decap_8
Xsg13cmos5l_decap_8_1453 VSS VDD sg13cmos5l_decap_8
Xsg13cmos5l_decap_8_1486 VSS VDD sg13cmos5l_decap_8
Xsg13cmos5l_decap_8_1497 VSS VDD sg13cmos5l_decap_8
Xsg13cmos5l_decap_8_1250 VSS VDD sg13cmos5l_decap_8
Xsg13cmos5l_decap_8_1283 VSS VDD sg13cmos5l_decap_8
Xsg13cmos5l_decap_8_1294 VSS VDD sg13cmos5l_decap_8
Xsg13cmos5l_decap_8_1261 VSS VDD sg13cmos5l_decap_8
Xsg13cmos5l_decap_8_1272 VSS VDD sg13cmos5l_decap_8
.ends
