* ======================================================================
* SoC6169 - reference netlist for the KLayout LVS (IHP SG13CMOS5L)
* Generated by tools/gen_chip_top_lvs.py
*  - IO: sg13cmos5l_io.cdl (PDK 456dd2d); sub! -> pin 'vsub' (= VSS at the top level)
*  - decaps: sg13cmos5l_stdcell.cdl
*  - core: COMPLETE_PROYECT_FIG_lvs.spice with the 11 ports added
* Cell count taken from the Magic chip_top.spice: COMPLETE_PROYECT_FIG=1, bondpad_70x70_5L=19, sg13cmos5l_Corner=4, sg13cmos5l_Filler1000=23, sg13cmos5l_Filler200=23, sg13cmos5l_Filler400=11, sg13cmos5l_Filler4000=28, sg13cmos5l_IOPadAnalog=1, sg13cmos5l_IOPadIOVdd=3, sg13cmos5l_IOPadIOVss=2, sg13cmos5l_IOPadIn=7, sg13cmos5l_IOPadOut30mA=1, sg13cmos5l_IOPadVdd=3, sg13cmos5l_IOPadVss=2, sg13cmos5l_decap_4=123, sg13cmos5l_decap_8=3577, sg13cmos5l_fill_1=123, sg13cmos5l_fill_2=104
* ======================================================================

.subckt SoC6169 IOVDD IOVSS VDD VSS analog_PAD clk_PAD input_PAD[0] input_PAD[1] input_PAD[2] input_PAD[3]
+ input_PAD[4] output_PAD rst_n_PAD

* ---- Core CAM 32x32 ----
Xi_chip_core en_write_core en_reference_core en_search_core reset_core clk_core serial_in_addr_core
+ output_core serial_in_data_core veval_in_core VDD VSS COMPLETE_PROYECT_FIG

* ---- Input pads (pad p2c vdd vss iovdd iovss sub) ----
Xinputs_0_pad input_PAD[0] en_write_core VDD VSS IOVDD IOVSS VSS sg13cmos5l_IOPadIn
Xinputs_1_pad input_PAD[1] en_reference_core VDD VSS IOVDD IOVSS VSS sg13cmos5l_IOPadIn
Xinputs_2_pad input_PAD[2] en_search_core VDD VSS IOVDD IOVSS VSS sg13cmos5l_IOPadIn
Xinputs_3_pad input_PAD[3] serial_in_addr_core VDD VSS IOVDD IOVSS VSS sg13cmos5l_IOPadIn
Xinputs_4_pad input_PAD[4] serial_in_data_core VDD VSS IOVDD IOVSS VSS sg13cmos5l_IOPadIn
Xrst_n_pad rst_n_PAD reset_core VDD VSS IOVDD IOVSS VSS sg13cmos5l_IOPadIn
Xclk_pad clk_PAD clk_core VDD VSS IOVDD IOVSS VSS sg13cmos5l_IOPadIn
* ---- Output pad (pad c2p vdd vss iovdd iovss sub) ----
Xoutputs_0_pad output_PAD output_core VDD VSS IOVDD IOVSS VSS sg13cmos5l_IOPadOut30mA
* ---- Analog pad VEVAL_IN (pad padres vdd vss iovdd iovss sub) ----
Xanalogs_0_pad analog_PAD veval_in_core VDD VSS IOVDD IOVSS VSS sg13cmos5l_IOPadAnalog
* ---- Power pads ----
Xvdd_pads_0 VDD VSS IOVDD IOVSS VSS sg13cmos5l_IOPadVdd
Xvdd_pads_1 VDD VSS IOVDD IOVSS VSS sg13cmos5l_IOPadVdd
Xvdd_pads_2 VDD VSS IOVDD IOVSS VSS sg13cmos5l_IOPadVdd
Xvss_pads_0 VDD VSS IOVDD IOVSS VSS sg13cmos5l_IOPadVss
Xvss_pads_1 VDD VSS IOVDD IOVSS VSS sg13cmos5l_IOPadVss
Xiovdd_pads_0 VDD VSS IOVDD IOVSS VSS sg13cmos5l_IOPadIOVdd
Xiovdd_pads_1 VDD VSS IOVDD IOVSS VSS sg13cmos5l_IOPadIOVdd
Xiovdd_pads_2 VDD VSS IOVDD IOVSS VSS sg13cmos5l_IOPadIOVdd
Xiovss_pads_0 VDD VSS IOVDD IOVSS VSS sg13cmos5l_IOPadIOVss
Xiovss_pads_1 VDD VSS IOVDD IOVSS VSS sg13cmos5l_IOPadIOVss
* ---- Pad-ring corners and fillers ----
XCorner_0 VDD VSS IOVDD IOVSS sg13cmos5l_Corner
XCorner_1 VDD VSS IOVDD IOVSS sg13cmos5l_Corner
XCorner_2 VDD VSS IOVDD IOVSS sg13cmos5l_Corner
XCorner_3 VDD VSS IOVDD IOVSS sg13cmos5l_Corner
XFiller4000_0 VDD VSS IOVDD IOVSS sg13cmos5l_Filler4000
XFiller4000_1 VDD VSS IOVDD IOVSS sg13cmos5l_Filler4000
XFiller4000_2 VDD VSS IOVDD IOVSS sg13cmos5l_Filler4000
XFiller4000_3 VDD VSS IOVDD IOVSS sg13cmos5l_Filler4000
XFiller4000_4 VDD VSS IOVDD IOVSS sg13cmos5l_Filler4000
XFiller4000_5 VDD VSS IOVDD IOVSS sg13cmos5l_Filler4000
XFiller4000_6 VDD VSS IOVDD IOVSS sg13cmos5l_Filler4000
XFiller4000_7 VDD VSS IOVDD IOVSS sg13cmos5l_Filler4000
XFiller4000_8 VDD VSS IOVDD IOVSS sg13cmos5l_Filler4000
XFiller4000_9 VDD VSS IOVDD IOVSS sg13cmos5l_Filler4000
XFiller4000_10 VDD VSS IOVDD IOVSS sg13cmos5l_Filler4000
XFiller4000_11 VDD VSS IOVDD IOVSS sg13cmos5l_Filler4000
XFiller4000_12 VDD VSS IOVDD IOVSS sg13cmos5l_Filler4000
XFiller4000_13 VDD VSS IOVDD IOVSS sg13cmos5l_Filler4000
XFiller4000_14 VDD VSS IOVDD IOVSS sg13cmos5l_Filler4000
XFiller4000_15 VDD VSS IOVDD IOVSS sg13cmos5l_Filler4000
XFiller4000_16 VDD VSS IOVDD IOVSS sg13cmos5l_Filler4000
XFiller4000_17 VDD VSS IOVDD IOVSS sg13cmos5l_Filler4000
XFiller4000_18 VDD VSS IOVDD IOVSS sg13cmos5l_Filler4000
XFiller4000_19 VDD VSS IOVDD IOVSS sg13cmos5l_Filler4000
XFiller4000_20 VDD VSS IOVDD IOVSS sg13cmos5l_Filler4000
XFiller4000_21 VDD VSS IOVDD IOVSS sg13cmos5l_Filler4000
XFiller4000_22 VDD VSS IOVDD IOVSS sg13cmos5l_Filler4000
XFiller4000_23 VDD VSS IOVDD IOVSS sg13cmos5l_Filler4000
XFiller4000_24 VDD VSS IOVDD IOVSS sg13cmos5l_Filler4000
XFiller4000_25 VDD VSS IOVDD IOVSS sg13cmos5l_Filler4000
XFiller4000_26 VDD VSS IOVDD IOVSS sg13cmos5l_Filler4000
XFiller4000_27 VDD VSS IOVDD IOVSS sg13cmos5l_Filler4000
XFiller1000_0 VDD VSS IOVDD IOVSS sg13cmos5l_Filler1000
XFiller1000_1 VDD VSS IOVDD IOVSS sg13cmos5l_Filler1000
XFiller1000_2 VDD VSS IOVDD IOVSS sg13cmos5l_Filler1000
XFiller1000_3 VDD VSS IOVDD IOVSS sg13cmos5l_Filler1000
XFiller1000_4 VDD VSS IOVDD IOVSS sg13cmos5l_Filler1000
XFiller1000_5 VDD VSS IOVDD IOVSS sg13cmos5l_Filler1000
XFiller1000_6 VDD VSS IOVDD IOVSS sg13cmos5l_Filler1000
XFiller1000_7 VDD VSS IOVDD IOVSS sg13cmos5l_Filler1000
XFiller1000_8 VDD VSS IOVDD IOVSS sg13cmos5l_Filler1000
XFiller1000_9 VDD VSS IOVDD IOVSS sg13cmos5l_Filler1000
XFiller1000_10 VDD VSS IOVDD IOVSS sg13cmos5l_Filler1000
XFiller1000_11 VDD VSS IOVDD IOVSS sg13cmos5l_Filler1000
XFiller1000_12 VDD VSS IOVDD IOVSS sg13cmos5l_Filler1000
XFiller1000_13 VDD VSS IOVDD IOVSS sg13cmos5l_Filler1000
XFiller1000_14 VDD VSS IOVDD IOVSS sg13cmos5l_Filler1000
XFiller1000_15 VDD VSS IOVDD IOVSS sg13cmos5l_Filler1000
XFiller1000_16 VDD VSS IOVDD IOVSS sg13cmos5l_Filler1000
XFiller1000_17 VDD VSS IOVDD IOVSS sg13cmos5l_Filler1000
XFiller1000_18 VDD VSS IOVDD IOVSS sg13cmos5l_Filler1000
XFiller1000_19 VDD VSS IOVDD IOVSS sg13cmos5l_Filler1000
XFiller1000_20 VDD VSS IOVDD IOVSS sg13cmos5l_Filler1000
XFiller1000_21 VDD VSS IOVDD IOVSS sg13cmos5l_Filler1000
XFiller1000_22 VDD VSS IOVDD IOVSS sg13cmos5l_Filler1000
XFiller400_0 VDD VSS IOVDD IOVSS sg13cmos5l_Filler400
XFiller400_1 VDD VSS IOVDD IOVSS sg13cmos5l_Filler400
XFiller400_2 VDD VSS IOVDD IOVSS sg13cmos5l_Filler400
XFiller400_3 VDD VSS IOVDD IOVSS sg13cmos5l_Filler400
XFiller400_4 VDD VSS IOVDD IOVSS sg13cmos5l_Filler400
XFiller400_5 VDD VSS IOVDD IOVSS sg13cmos5l_Filler400
XFiller400_6 VDD VSS IOVDD IOVSS sg13cmos5l_Filler400
XFiller400_7 VDD VSS IOVDD IOVSS sg13cmos5l_Filler400
XFiller400_8 VDD VSS IOVDD IOVSS sg13cmos5l_Filler400
XFiller400_9 VDD VSS IOVDD IOVSS sg13cmos5l_Filler400
XFiller400_10 VDD VSS IOVDD IOVSS sg13cmos5l_Filler400
XFiller200_0 VDD VSS IOVDD IOVSS sg13cmos5l_Filler200
XFiller200_1 VDD VSS IOVDD IOVSS sg13cmos5l_Filler200
XFiller200_2 VDD VSS IOVDD IOVSS sg13cmos5l_Filler200
XFiller200_3 VDD VSS IOVDD IOVSS sg13cmos5l_Filler200
XFiller200_4 VDD VSS IOVDD IOVSS sg13cmos5l_Filler200
XFiller200_5 VDD VSS IOVDD IOVSS sg13cmos5l_Filler200
XFiller200_6 VDD VSS IOVDD IOVSS sg13cmos5l_Filler200
XFiller200_7 VDD VSS IOVDD IOVSS sg13cmos5l_Filler200
XFiller200_8 VDD VSS IOVDD IOVSS sg13cmos5l_Filler200
XFiller200_9 VDD VSS IOVDD IOVSS sg13cmos5l_Filler200
XFiller200_10 VDD VSS IOVDD IOVSS sg13cmos5l_Filler200
XFiller200_11 VDD VSS IOVDD IOVSS sg13cmos5l_Filler200
XFiller200_12 VDD VSS IOVDD IOVSS sg13cmos5l_Filler200
XFiller200_13 VDD VSS IOVDD IOVSS sg13cmos5l_Filler200
XFiller200_14 VDD VSS IOVDD IOVSS sg13cmos5l_Filler200
XFiller200_15 VDD VSS IOVDD IOVSS sg13cmos5l_Filler200
XFiller200_16 VDD VSS IOVDD IOVSS sg13cmos5l_Filler200
XFiller200_17 VDD VSS IOVDD IOVSS sg13cmos5l_Filler200
XFiller200_18 VDD VSS IOVDD IOVSS sg13cmos5l_Filler200
XFiller200_19 VDD VSS IOVDD IOVSS sg13cmos5l_Filler200
XFiller200_20 VDD VSS IOVDD IOVSS sg13cmos5l_Filler200
XFiller200_21 VDD VSS IOVDD IOVSS sg13cmos5l_Filler200
XFiller200_22 VDD VSS IOVDD IOVSS sg13cmos5l_Filler200
* ---- Core-area decaps (fill_1/fill_2 and bondpads have no devices) ----
Xdecap_8_0 VDD VSS sg13cmos5l_decap_8
Xdecap_8_1 VDD VSS sg13cmos5l_decap_8
Xdecap_8_2 VDD VSS sg13cmos5l_decap_8
Xdecap_8_3 VDD VSS sg13cmos5l_decap_8
Xdecap_8_4 VDD VSS sg13cmos5l_decap_8
Xdecap_8_5 VDD VSS sg13cmos5l_decap_8
Xdecap_8_6 VDD VSS sg13cmos5l_decap_8
Xdecap_8_7 VDD VSS sg13cmos5l_decap_8
Xdecap_8_8 VDD VSS sg13cmos5l_decap_8
Xdecap_8_9 VDD VSS sg13cmos5l_decap_8
Xdecap_8_10 VDD VSS sg13cmos5l_decap_8
Xdecap_8_11 VDD VSS sg13cmos5l_decap_8
Xdecap_8_12 VDD VSS sg13cmos5l_decap_8
Xdecap_8_13 VDD VSS sg13cmos5l_decap_8
Xdecap_8_14 VDD VSS sg13cmos5l_decap_8
Xdecap_8_15 VDD VSS sg13cmos5l_decap_8
Xdecap_8_16 VDD VSS sg13cmos5l_decap_8
Xdecap_8_17 VDD VSS sg13cmos5l_decap_8
Xdecap_8_18 VDD VSS sg13cmos5l_decap_8
Xdecap_8_19 VDD VSS sg13cmos5l_decap_8
Xdecap_8_20 VDD VSS sg13cmos5l_decap_8
Xdecap_8_21 VDD VSS sg13cmos5l_decap_8
Xdecap_8_22 VDD VSS sg13cmos5l_decap_8
Xdecap_8_23 VDD VSS sg13cmos5l_decap_8
Xdecap_8_24 VDD VSS sg13cmos5l_decap_8
Xdecap_8_25 VDD VSS sg13cmos5l_decap_8
Xdecap_8_26 VDD VSS sg13cmos5l_decap_8
Xdecap_8_27 VDD VSS sg13cmos5l_decap_8
Xdecap_8_28 VDD VSS sg13cmos5l_decap_8
Xdecap_8_29 VDD VSS sg13cmos5l_decap_8
Xdecap_8_30 VDD VSS sg13cmos5l_decap_8
Xdecap_8_31 VDD VSS sg13cmos5l_decap_8
Xdecap_8_32 VDD VSS sg13cmos5l_decap_8
Xdecap_8_33 VDD VSS sg13cmos5l_decap_8
Xdecap_8_34 VDD VSS sg13cmos5l_decap_8
Xdecap_8_35 VDD VSS sg13cmos5l_decap_8
Xdecap_8_36 VDD VSS sg13cmos5l_decap_8
Xdecap_8_37 VDD VSS sg13cmos5l_decap_8
Xdecap_8_38 VDD VSS sg13cmos5l_decap_8
Xdecap_8_39 VDD VSS sg13cmos5l_decap_8
Xdecap_8_40 VDD VSS sg13cmos5l_decap_8
Xdecap_8_41 VDD VSS sg13cmos5l_decap_8
Xdecap_8_42 VDD VSS sg13cmos5l_decap_8
Xdecap_8_43 VDD VSS sg13cmos5l_decap_8
Xdecap_8_44 VDD VSS sg13cmos5l_decap_8
Xdecap_8_45 VDD VSS sg13cmos5l_decap_8
Xdecap_8_46 VDD VSS sg13cmos5l_decap_8
Xdecap_8_47 VDD VSS sg13cmos5l_decap_8
Xdecap_8_48 VDD VSS sg13cmos5l_decap_8
Xdecap_8_49 VDD VSS sg13cmos5l_decap_8
Xdecap_8_50 VDD VSS sg13cmos5l_decap_8
Xdecap_8_51 VDD VSS sg13cmos5l_decap_8
Xdecap_8_52 VDD VSS sg13cmos5l_decap_8
Xdecap_8_53 VDD VSS sg13cmos5l_decap_8
Xdecap_8_54 VDD VSS sg13cmos5l_decap_8
Xdecap_8_55 VDD VSS sg13cmos5l_decap_8
Xdecap_8_56 VDD VSS sg13cmos5l_decap_8
Xdecap_8_57 VDD VSS sg13cmos5l_decap_8
Xdecap_8_58 VDD VSS sg13cmos5l_decap_8
Xdecap_8_59 VDD VSS sg13cmos5l_decap_8
Xdecap_8_60 VDD VSS sg13cmos5l_decap_8
Xdecap_8_61 VDD VSS sg13cmos5l_decap_8
Xdecap_8_62 VDD VSS sg13cmos5l_decap_8
Xdecap_8_63 VDD VSS sg13cmos5l_decap_8
Xdecap_8_64 VDD VSS sg13cmos5l_decap_8
Xdecap_8_65 VDD VSS sg13cmos5l_decap_8
Xdecap_8_66 VDD VSS sg13cmos5l_decap_8
Xdecap_8_67 VDD VSS sg13cmos5l_decap_8
Xdecap_8_68 VDD VSS sg13cmos5l_decap_8
Xdecap_8_69 VDD VSS sg13cmos5l_decap_8
Xdecap_8_70 VDD VSS sg13cmos5l_decap_8
Xdecap_8_71 VDD VSS sg13cmos5l_decap_8
Xdecap_8_72 VDD VSS sg13cmos5l_decap_8
Xdecap_8_73 VDD VSS sg13cmos5l_decap_8
Xdecap_8_74 VDD VSS sg13cmos5l_decap_8
Xdecap_8_75 VDD VSS sg13cmos5l_decap_8
Xdecap_8_76 VDD VSS sg13cmos5l_decap_8
Xdecap_8_77 VDD VSS sg13cmos5l_decap_8
Xdecap_8_78 VDD VSS sg13cmos5l_decap_8
Xdecap_8_79 VDD VSS sg13cmos5l_decap_8
Xdecap_8_80 VDD VSS sg13cmos5l_decap_8
Xdecap_8_81 VDD VSS sg13cmos5l_decap_8
Xdecap_8_82 VDD VSS sg13cmos5l_decap_8
Xdecap_8_83 VDD VSS sg13cmos5l_decap_8
Xdecap_8_84 VDD VSS sg13cmos5l_decap_8
Xdecap_8_85 VDD VSS sg13cmos5l_decap_8
Xdecap_8_86 VDD VSS sg13cmos5l_decap_8
Xdecap_8_87 VDD VSS sg13cmos5l_decap_8
Xdecap_8_88 VDD VSS sg13cmos5l_decap_8
Xdecap_8_89 VDD VSS sg13cmos5l_decap_8
Xdecap_8_90 VDD VSS sg13cmos5l_decap_8
Xdecap_8_91 VDD VSS sg13cmos5l_decap_8
Xdecap_8_92 VDD VSS sg13cmos5l_decap_8
Xdecap_8_93 VDD VSS sg13cmos5l_decap_8
Xdecap_8_94 VDD VSS sg13cmos5l_decap_8
Xdecap_8_95 VDD VSS sg13cmos5l_decap_8
Xdecap_8_96 VDD VSS sg13cmos5l_decap_8
Xdecap_8_97 VDD VSS sg13cmos5l_decap_8
Xdecap_8_98 VDD VSS sg13cmos5l_decap_8
Xdecap_8_99 VDD VSS sg13cmos5l_decap_8
Xdecap_8_100 VDD VSS sg13cmos5l_decap_8
Xdecap_8_101 VDD VSS sg13cmos5l_decap_8
Xdecap_8_102 VDD VSS sg13cmos5l_decap_8
Xdecap_8_103 VDD VSS sg13cmos5l_decap_8
Xdecap_8_104 VDD VSS sg13cmos5l_decap_8
Xdecap_8_105 VDD VSS sg13cmos5l_decap_8
Xdecap_8_106 VDD VSS sg13cmos5l_decap_8
Xdecap_8_107 VDD VSS sg13cmos5l_decap_8
Xdecap_8_108 VDD VSS sg13cmos5l_decap_8
Xdecap_8_109 VDD VSS sg13cmos5l_decap_8
Xdecap_8_110 VDD VSS sg13cmos5l_decap_8
Xdecap_8_111 VDD VSS sg13cmos5l_decap_8
Xdecap_8_112 VDD VSS sg13cmos5l_decap_8
Xdecap_8_113 VDD VSS sg13cmos5l_decap_8
Xdecap_8_114 VDD VSS sg13cmos5l_decap_8
Xdecap_8_115 VDD VSS sg13cmos5l_decap_8
Xdecap_8_116 VDD VSS sg13cmos5l_decap_8
Xdecap_8_117 VDD VSS sg13cmos5l_decap_8
Xdecap_8_118 VDD VSS sg13cmos5l_decap_8
Xdecap_8_119 VDD VSS sg13cmos5l_decap_8
Xdecap_8_120 VDD VSS sg13cmos5l_decap_8
Xdecap_8_121 VDD VSS sg13cmos5l_decap_8
Xdecap_8_122 VDD VSS sg13cmos5l_decap_8
Xdecap_8_123 VDD VSS sg13cmos5l_decap_8
Xdecap_8_124 VDD VSS sg13cmos5l_decap_8
Xdecap_8_125 VDD VSS sg13cmos5l_decap_8
Xdecap_8_126 VDD VSS sg13cmos5l_decap_8
Xdecap_8_127 VDD VSS sg13cmos5l_decap_8
Xdecap_8_128 VDD VSS sg13cmos5l_decap_8
Xdecap_8_129 VDD VSS sg13cmos5l_decap_8
Xdecap_8_130 VDD VSS sg13cmos5l_decap_8
Xdecap_8_131 VDD VSS sg13cmos5l_decap_8
Xdecap_8_132 VDD VSS sg13cmos5l_decap_8
Xdecap_8_133 VDD VSS sg13cmos5l_decap_8
Xdecap_8_134 VDD VSS sg13cmos5l_decap_8
Xdecap_8_135 VDD VSS sg13cmos5l_decap_8
Xdecap_8_136 VDD VSS sg13cmos5l_decap_8
Xdecap_8_137 VDD VSS sg13cmos5l_decap_8
Xdecap_8_138 VDD VSS sg13cmos5l_decap_8
Xdecap_8_139 VDD VSS sg13cmos5l_decap_8
Xdecap_8_140 VDD VSS sg13cmos5l_decap_8
Xdecap_8_141 VDD VSS sg13cmos5l_decap_8
Xdecap_8_142 VDD VSS sg13cmos5l_decap_8
Xdecap_8_143 VDD VSS sg13cmos5l_decap_8
Xdecap_8_144 VDD VSS sg13cmos5l_decap_8
Xdecap_8_145 VDD VSS sg13cmos5l_decap_8
Xdecap_8_146 VDD VSS sg13cmos5l_decap_8
Xdecap_8_147 VDD VSS sg13cmos5l_decap_8
Xdecap_8_148 VDD VSS sg13cmos5l_decap_8
Xdecap_8_149 VDD VSS sg13cmos5l_decap_8
Xdecap_8_150 VDD VSS sg13cmos5l_decap_8
Xdecap_8_151 VDD VSS sg13cmos5l_decap_8
Xdecap_8_152 VDD VSS sg13cmos5l_decap_8
Xdecap_8_153 VDD VSS sg13cmos5l_decap_8
Xdecap_8_154 VDD VSS sg13cmos5l_decap_8
Xdecap_8_155 VDD VSS sg13cmos5l_decap_8
Xdecap_8_156 VDD VSS sg13cmos5l_decap_8
Xdecap_8_157 VDD VSS sg13cmos5l_decap_8
Xdecap_8_158 VDD VSS sg13cmos5l_decap_8
Xdecap_8_159 VDD VSS sg13cmos5l_decap_8
Xdecap_8_160 VDD VSS sg13cmos5l_decap_8
Xdecap_8_161 VDD VSS sg13cmos5l_decap_8
Xdecap_8_162 VDD VSS sg13cmos5l_decap_8
Xdecap_8_163 VDD VSS sg13cmos5l_decap_8
Xdecap_8_164 VDD VSS sg13cmos5l_decap_8
Xdecap_8_165 VDD VSS sg13cmos5l_decap_8
Xdecap_8_166 VDD VSS sg13cmos5l_decap_8
Xdecap_8_167 VDD VSS sg13cmos5l_decap_8
Xdecap_8_168 VDD VSS sg13cmos5l_decap_8
Xdecap_8_169 VDD VSS sg13cmos5l_decap_8
Xdecap_8_170 VDD VSS sg13cmos5l_decap_8
Xdecap_8_171 VDD VSS sg13cmos5l_decap_8
Xdecap_8_172 VDD VSS sg13cmos5l_decap_8
Xdecap_8_173 VDD VSS sg13cmos5l_decap_8
Xdecap_8_174 VDD VSS sg13cmos5l_decap_8
Xdecap_8_175 VDD VSS sg13cmos5l_decap_8
Xdecap_8_176 VDD VSS sg13cmos5l_decap_8
Xdecap_8_177 VDD VSS sg13cmos5l_decap_8
Xdecap_8_178 VDD VSS sg13cmos5l_decap_8
Xdecap_8_179 VDD VSS sg13cmos5l_decap_8
Xdecap_8_180 VDD VSS sg13cmos5l_decap_8
Xdecap_8_181 VDD VSS sg13cmos5l_decap_8
Xdecap_8_182 VDD VSS sg13cmos5l_decap_8
Xdecap_8_183 VDD VSS sg13cmos5l_decap_8
Xdecap_8_184 VDD VSS sg13cmos5l_decap_8
Xdecap_8_185 VDD VSS sg13cmos5l_decap_8
Xdecap_8_186 VDD VSS sg13cmos5l_decap_8
Xdecap_8_187 VDD VSS sg13cmos5l_decap_8
Xdecap_8_188 VDD VSS sg13cmos5l_decap_8
Xdecap_8_189 VDD VSS sg13cmos5l_decap_8
Xdecap_8_190 VDD VSS sg13cmos5l_decap_8
Xdecap_8_191 VDD VSS sg13cmos5l_decap_8
Xdecap_8_192 VDD VSS sg13cmos5l_decap_8
Xdecap_8_193 VDD VSS sg13cmos5l_decap_8
Xdecap_8_194 VDD VSS sg13cmos5l_decap_8
Xdecap_8_195 VDD VSS sg13cmos5l_decap_8
Xdecap_8_196 VDD VSS sg13cmos5l_decap_8
Xdecap_8_197 VDD VSS sg13cmos5l_decap_8
Xdecap_8_198 VDD VSS sg13cmos5l_decap_8
Xdecap_8_199 VDD VSS sg13cmos5l_decap_8
Xdecap_8_200 VDD VSS sg13cmos5l_decap_8
Xdecap_8_201 VDD VSS sg13cmos5l_decap_8
Xdecap_8_202 VDD VSS sg13cmos5l_decap_8
Xdecap_8_203 VDD VSS sg13cmos5l_decap_8
Xdecap_8_204 VDD VSS sg13cmos5l_decap_8
Xdecap_8_205 VDD VSS sg13cmos5l_decap_8
Xdecap_8_206 VDD VSS sg13cmos5l_decap_8
Xdecap_8_207 VDD VSS sg13cmos5l_decap_8
Xdecap_8_208 VDD VSS sg13cmos5l_decap_8
Xdecap_8_209 VDD VSS sg13cmos5l_decap_8
Xdecap_8_210 VDD VSS sg13cmos5l_decap_8
Xdecap_8_211 VDD VSS sg13cmos5l_decap_8
Xdecap_8_212 VDD VSS sg13cmos5l_decap_8
Xdecap_8_213 VDD VSS sg13cmos5l_decap_8
Xdecap_8_214 VDD VSS sg13cmos5l_decap_8
Xdecap_8_215 VDD VSS sg13cmos5l_decap_8
Xdecap_8_216 VDD VSS sg13cmos5l_decap_8
Xdecap_8_217 VDD VSS sg13cmos5l_decap_8
Xdecap_8_218 VDD VSS sg13cmos5l_decap_8
Xdecap_8_219 VDD VSS sg13cmos5l_decap_8
Xdecap_8_220 VDD VSS sg13cmos5l_decap_8
Xdecap_8_221 VDD VSS sg13cmos5l_decap_8
Xdecap_8_222 VDD VSS sg13cmos5l_decap_8
Xdecap_8_223 VDD VSS sg13cmos5l_decap_8
Xdecap_8_224 VDD VSS sg13cmos5l_decap_8
Xdecap_8_225 VDD VSS sg13cmos5l_decap_8
Xdecap_8_226 VDD VSS sg13cmos5l_decap_8
Xdecap_8_227 VDD VSS sg13cmos5l_decap_8
Xdecap_8_228 VDD VSS sg13cmos5l_decap_8
Xdecap_8_229 VDD VSS sg13cmos5l_decap_8
Xdecap_8_230 VDD VSS sg13cmos5l_decap_8
Xdecap_8_231 VDD VSS sg13cmos5l_decap_8
Xdecap_8_232 VDD VSS sg13cmos5l_decap_8
Xdecap_8_233 VDD VSS sg13cmos5l_decap_8
Xdecap_8_234 VDD VSS sg13cmos5l_decap_8
Xdecap_8_235 VDD VSS sg13cmos5l_decap_8
Xdecap_8_236 VDD VSS sg13cmos5l_decap_8
Xdecap_8_237 VDD VSS sg13cmos5l_decap_8
Xdecap_8_238 VDD VSS sg13cmos5l_decap_8
Xdecap_8_239 VDD VSS sg13cmos5l_decap_8
Xdecap_8_240 VDD VSS sg13cmos5l_decap_8
Xdecap_8_241 VDD VSS sg13cmos5l_decap_8
Xdecap_8_242 VDD VSS sg13cmos5l_decap_8
Xdecap_8_243 VDD VSS sg13cmos5l_decap_8
Xdecap_8_244 VDD VSS sg13cmos5l_decap_8
Xdecap_8_245 VDD VSS sg13cmos5l_decap_8
Xdecap_8_246 VDD VSS sg13cmos5l_decap_8
Xdecap_8_247 VDD VSS sg13cmos5l_decap_8
Xdecap_8_248 VDD VSS sg13cmos5l_decap_8
Xdecap_8_249 VDD VSS sg13cmos5l_decap_8
Xdecap_8_250 VDD VSS sg13cmos5l_decap_8
Xdecap_8_251 VDD VSS sg13cmos5l_decap_8
Xdecap_8_252 VDD VSS sg13cmos5l_decap_8
Xdecap_8_253 VDD VSS sg13cmos5l_decap_8
Xdecap_8_254 VDD VSS sg13cmos5l_decap_8
Xdecap_8_255 VDD VSS sg13cmos5l_decap_8
Xdecap_8_256 VDD VSS sg13cmos5l_decap_8
Xdecap_8_257 VDD VSS sg13cmos5l_decap_8
Xdecap_8_258 VDD VSS sg13cmos5l_decap_8
Xdecap_8_259 VDD VSS sg13cmos5l_decap_8
Xdecap_8_260 VDD VSS sg13cmos5l_decap_8
Xdecap_8_261 VDD VSS sg13cmos5l_decap_8
Xdecap_8_262 VDD VSS sg13cmos5l_decap_8
Xdecap_8_263 VDD VSS sg13cmos5l_decap_8
Xdecap_8_264 VDD VSS sg13cmos5l_decap_8
Xdecap_8_265 VDD VSS sg13cmos5l_decap_8
Xdecap_8_266 VDD VSS sg13cmos5l_decap_8
Xdecap_8_267 VDD VSS sg13cmos5l_decap_8
Xdecap_8_268 VDD VSS sg13cmos5l_decap_8
Xdecap_8_269 VDD VSS sg13cmos5l_decap_8
Xdecap_8_270 VDD VSS sg13cmos5l_decap_8
Xdecap_8_271 VDD VSS sg13cmos5l_decap_8
Xdecap_8_272 VDD VSS sg13cmos5l_decap_8
Xdecap_8_273 VDD VSS sg13cmos5l_decap_8
Xdecap_8_274 VDD VSS sg13cmos5l_decap_8
Xdecap_8_275 VDD VSS sg13cmos5l_decap_8
Xdecap_8_276 VDD VSS sg13cmos5l_decap_8
Xdecap_8_277 VDD VSS sg13cmos5l_decap_8
Xdecap_8_278 VDD VSS sg13cmos5l_decap_8
Xdecap_8_279 VDD VSS sg13cmos5l_decap_8
Xdecap_8_280 VDD VSS sg13cmos5l_decap_8
Xdecap_8_281 VDD VSS sg13cmos5l_decap_8
Xdecap_8_282 VDD VSS sg13cmos5l_decap_8
Xdecap_8_283 VDD VSS sg13cmos5l_decap_8
Xdecap_8_284 VDD VSS sg13cmos5l_decap_8
Xdecap_8_285 VDD VSS sg13cmos5l_decap_8
Xdecap_8_286 VDD VSS sg13cmos5l_decap_8
Xdecap_8_287 VDD VSS sg13cmos5l_decap_8
Xdecap_8_288 VDD VSS sg13cmos5l_decap_8
Xdecap_8_289 VDD VSS sg13cmos5l_decap_8
Xdecap_8_290 VDD VSS sg13cmos5l_decap_8
Xdecap_8_291 VDD VSS sg13cmos5l_decap_8
Xdecap_8_292 VDD VSS sg13cmos5l_decap_8
Xdecap_8_293 VDD VSS sg13cmos5l_decap_8
Xdecap_8_294 VDD VSS sg13cmos5l_decap_8
Xdecap_8_295 VDD VSS sg13cmos5l_decap_8
Xdecap_8_296 VDD VSS sg13cmos5l_decap_8
Xdecap_8_297 VDD VSS sg13cmos5l_decap_8
Xdecap_8_298 VDD VSS sg13cmos5l_decap_8
Xdecap_8_299 VDD VSS sg13cmos5l_decap_8
Xdecap_8_300 VDD VSS sg13cmos5l_decap_8
Xdecap_8_301 VDD VSS sg13cmos5l_decap_8
Xdecap_8_302 VDD VSS sg13cmos5l_decap_8
Xdecap_8_303 VDD VSS sg13cmos5l_decap_8
Xdecap_8_304 VDD VSS sg13cmos5l_decap_8
Xdecap_8_305 VDD VSS sg13cmos5l_decap_8
Xdecap_8_306 VDD VSS sg13cmos5l_decap_8
Xdecap_8_307 VDD VSS sg13cmos5l_decap_8
Xdecap_8_308 VDD VSS sg13cmos5l_decap_8
Xdecap_8_309 VDD VSS sg13cmos5l_decap_8
Xdecap_8_310 VDD VSS sg13cmos5l_decap_8
Xdecap_8_311 VDD VSS sg13cmos5l_decap_8
Xdecap_8_312 VDD VSS sg13cmos5l_decap_8
Xdecap_8_313 VDD VSS sg13cmos5l_decap_8
Xdecap_8_314 VDD VSS sg13cmos5l_decap_8
Xdecap_8_315 VDD VSS sg13cmos5l_decap_8
Xdecap_8_316 VDD VSS sg13cmos5l_decap_8
Xdecap_8_317 VDD VSS sg13cmos5l_decap_8
Xdecap_8_318 VDD VSS sg13cmos5l_decap_8
Xdecap_8_319 VDD VSS sg13cmos5l_decap_8
Xdecap_8_320 VDD VSS sg13cmos5l_decap_8
Xdecap_8_321 VDD VSS sg13cmos5l_decap_8
Xdecap_8_322 VDD VSS sg13cmos5l_decap_8
Xdecap_8_323 VDD VSS sg13cmos5l_decap_8
Xdecap_8_324 VDD VSS sg13cmos5l_decap_8
Xdecap_8_325 VDD VSS sg13cmos5l_decap_8
Xdecap_8_326 VDD VSS sg13cmos5l_decap_8
Xdecap_8_327 VDD VSS sg13cmos5l_decap_8
Xdecap_8_328 VDD VSS sg13cmos5l_decap_8
Xdecap_8_329 VDD VSS sg13cmos5l_decap_8
Xdecap_8_330 VDD VSS sg13cmos5l_decap_8
Xdecap_8_331 VDD VSS sg13cmos5l_decap_8
Xdecap_8_332 VDD VSS sg13cmos5l_decap_8
Xdecap_8_333 VDD VSS sg13cmos5l_decap_8
Xdecap_8_334 VDD VSS sg13cmos5l_decap_8
Xdecap_8_335 VDD VSS sg13cmos5l_decap_8
Xdecap_8_336 VDD VSS sg13cmos5l_decap_8
Xdecap_8_337 VDD VSS sg13cmos5l_decap_8
Xdecap_8_338 VDD VSS sg13cmos5l_decap_8
Xdecap_8_339 VDD VSS sg13cmos5l_decap_8
Xdecap_8_340 VDD VSS sg13cmos5l_decap_8
Xdecap_8_341 VDD VSS sg13cmos5l_decap_8
Xdecap_8_342 VDD VSS sg13cmos5l_decap_8
Xdecap_8_343 VDD VSS sg13cmos5l_decap_8
Xdecap_8_344 VDD VSS sg13cmos5l_decap_8
Xdecap_8_345 VDD VSS sg13cmos5l_decap_8
Xdecap_8_346 VDD VSS sg13cmos5l_decap_8
Xdecap_8_347 VDD VSS sg13cmos5l_decap_8
Xdecap_8_348 VDD VSS sg13cmos5l_decap_8
Xdecap_8_349 VDD VSS sg13cmos5l_decap_8
Xdecap_8_350 VDD VSS sg13cmos5l_decap_8
Xdecap_8_351 VDD VSS sg13cmos5l_decap_8
Xdecap_8_352 VDD VSS sg13cmos5l_decap_8
Xdecap_8_353 VDD VSS sg13cmos5l_decap_8
Xdecap_8_354 VDD VSS sg13cmos5l_decap_8
Xdecap_8_355 VDD VSS sg13cmos5l_decap_8
Xdecap_8_356 VDD VSS sg13cmos5l_decap_8
Xdecap_8_357 VDD VSS sg13cmos5l_decap_8
Xdecap_8_358 VDD VSS sg13cmos5l_decap_8
Xdecap_8_359 VDD VSS sg13cmos5l_decap_8
Xdecap_8_360 VDD VSS sg13cmos5l_decap_8
Xdecap_8_361 VDD VSS sg13cmos5l_decap_8
Xdecap_8_362 VDD VSS sg13cmos5l_decap_8
Xdecap_8_363 VDD VSS sg13cmos5l_decap_8
Xdecap_8_364 VDD VSS sg13cmos5l_decap_8
Xdecap_8_365 VDD VSS sg13cmos5l_decap_8
Xdecap_8_366 VDD VSS sg13cmos5l_decap_8
Xdecap_8_367 VDD VSS sg13cmos5l_decap_8
Xdecap_8_368 VDD VSS sg13cmos5l_decap_8
Xdecap_8_369 VDD VSS sg13cmos5l_decap_8
Xdecap_8_370 VDD VSS sg13cmos5l_decap_8
Xdecap_8_371 VDD VSS sg13cmos5l_decap_8
Xdecap_8_372 VDD VSS sg13cmos5l_decap_8
Xdecap_8_373 VDD VSS sg13cmos5l_decap_8
Xdecap_8_374 VDD VSS sg13cmos5l_decap_8
Xdecap_8_375 VDD VSS sg13cmos5l_decap_8
Xdecap_8_376 VDD VSS sg13cmos5l_decap_8
Xdecap_8_377 VDD VSS sg13cmos5l_decap_8
Xdecap_8_378 VDD VSS sg13cmos5l_decap_8
Xdecap_8_379 VDD VSS sg13cmos5l_decap_8
Xdecap_8_380 VDD VSS sg13cmos5l_decap_8
Xdecap_8_381 VDD VSS sg13cmos5l_decap_8
Xdecap_8_382 VDD VSS sg13cmos5l_decap_8
Xdecap_8_383 VDD VSS sg13cmos5l_decap_8
Xdecap_8_384 VDD VSS sg13cmos5l_decap_8
Xdecap_8_385 VDD VSS sg13cmos5l_decap_8
Xdecap_8_386 VDD VSS sg13cmos5l_decap_8
Xdecap_8_387 VDD VSS sg13cmos5l_decap_8
Xdecap_8_388 VDD VSS sg13cmos5l_decap_8
Xdecap_8_389 VDD VSS sg13cmos5l_decap_8
Xdecap_8_390 VDD VSS sg13cmos5l_decap_8
Xdecap_8_391 VDD VSS sg13cmos5l_decap_8
Xdecap_8_392 VDD VSS sg13cmos5l_decap_8
Xdecap_8_393 VDD VSS sg13cmos5l_decap_8
Xdecap_8_394 VDD VSS sg13cmos5l_decap_8
Xdecap_8_395 VDD VSS sg13cmos5l_decap_8
Xdecap_8_396 VDD VSS sg13cmos5l_decap_8
Xdecap_8_397 VDD VSS sg13cmos5l_decap_8
Xdecap_8_398 VDD VSS sg13cmos5l_decap_8
Xdecap_8_399 VDD VSS sg13cmos5l_decap_8
Xdecap_8_400 VDD VSS sg13cmos5l_decap_8
Xdecap_8_401 VDD VSS sg13cmos5l_decap_8
Xdecap_8_402 VDD VSS sg13cmos5l_decap_8
Xdecap_8_403 VDD VSS sg13cmos5l_decap_8
Xdecap_8_404 VDD VSS sg13cmos5l_decap_8
Xdecap_8_405 VDD VSS sg13cmos5l_decap_8
Xdecap_8_406 VDD VSS sg13cmos5l_decap_8
Xdecap_8_407 VDD VSS sg13cmos5l_decap_8
Xdecap_8_408 VDD VSS sg13cmos5l_decap_8
Xdecap_8_409 VDD VSS sg13cmos5l_decap_8
Xdecap_8_410 VDD VSS sg13cmos5l_decap_8
Xdecap_8_411 VDD VSS sg13cmos5l_decap_8
Xdecap_8_412 VDD VSS sg13cmos5l_decap_8
Xdecap_8_413 VDD VSS sg13cmos5l_decap_8
Xdecap_8_414 VDD VSS sg13cmos5l_decap_8
Xdecap_8_415 VDD VSS sg13cmos5l_decap_8
Xdecap_8_416 VDD VSS sg13cmos5l_decap_8
Xdecap_8_417 VDD VSS sg13cmos5l_decap_8
Xdecap_8_418 VDD VSS sg13cmos5l_decap_8
Xdecap_8_419 VDD VSS sg13cmos5l_decap_8
Xdecap_8_420 VDD VSS sg13cmos5l_decap_8
Xdecap_8_421 VDD VSS sg13cmos5l_decap_8
Xdecap_8_422 VDD VSS sg13cmos5l_decap_8
Xdecap_8_423 VDD VSS sg13cmos5l_decap_8
Xdecap_8_424 VDD VSS sg13cmos5l_decap_8
Xdecap_8_425 VDD VSS sg13cmos5l_decap_8
Xdecap_8_426 VDD VSS sg13cmos5l_decap_8
Xdecap_8_427 VDD VSS sg13cmos5l_decap_8
Xdecap_8_428 VDD VSS sg13cmos5l_decap_8
Xdecap_8_429 VDD VSS sg13cmos5l_decap_8
Xdecap_8_430 VDD VSS sg13cmos5l_decap_8
Xdecap_8_431 VDD VSS sg13cmos5l_decap_8
Xdecap_8_432 VDD VSS sg13cmos5l_decap_8
Xdecap_8_433 VDD VSS sg13cmos5l_decap_8
Xdecap_8_434 VDD VSS sg13cmos5l_decap_8
Xdecap_8_435 VDD VSS sg13cmos5l_decap_8
Xdecap_8_436 VDD VSS sg13cmos5l_decap_8
Xdecap_8_437 VDD VSS sg13cmos5l_decap_8
Xdecap_8_438 VDD VSS sg13cmos5l_decap_8
Xdecap_8_439 VDD VSS sg13cmos5l_decap_8
Xdecap_8_440 VDD VSS sg13cmos5l_decap_8
Xdecap_8_441 VDD VSS sg13cmos5l_decap_8
Xdecap_8_442 VDD VSS sg13cmos5l_decap_8
Xdecap_8_443 VDD VSS sg13cmos5l_decap_8
Xdecap_8_444 VDD VSS sg13cmos5l_decap_8
Xdecap_8_445 VDD VSS sg13cmos5l_decap_8
Xdecap_8_446 VDD VSS sg13cmos5l_decap_8
Xdecap_8_447 VDD VSS sg13cmos5l_decap_8
Xdecap_8_448 VDD VSS sg13cmos5l_decap_8
Xdecap_8_449 VDD VSS sg13cmos5l_decap_8
Xdecap_8_450 VDD VSS sg13cmos5l_decap_8
Xdecap_8_451 VDD VSS sg13cmos5l_decap_8
Xdecap_8_452 VDD VSS sg13cmos5l_decap_8
Xdecap_8_453 VDD VSS sg13cmos5l_decap_8
Xdecap_8_454 VDD VSS sg13cmos5l_decap_8
Xdecap_8_455 VDD VSS sg13cmos5l_decap_8
Xdecap_8_456 VDD VSS sg13cmos5l_decap_8
Xdecap_8_457 VDD VSS sg13cmos5l_decap_8
Xdecap_8_458 VDD VSS sg13cmos5l_decap_8
Xdecap_8_459 VDD VSS sg13cmos5l_decap_8
Xdecap_8_460 VDD VSS sg13cmos5l_decap_8
Xdecap_8_461 VDD VSS sg13cmos5l_decap_8
Xdecap_8_462 VDD VSS sg13cmos5l_decap_8
Xdecap_8_463 VDD VSS sg13cmos5l_decap_8
Xdecap_8_464 VDD VSS sg13cmos5l_decap_8
Xdecap_8_465 VDD VSS sg13cmos5l_decap_8
Xdecap_8_466 VDD VSS sg13cmos5l_decap_8
Xdecap_8_467 VDD VSS sg13cmos5l_decap_8
Xdecap_8_468 VDD VSS sg13cmos5l_decap_8
Xdecap_8_469 VDD VSS sg13cmos5l_decap_8
Xdecap_8_470 VDD VSS sg13cmos5l_decap_8
Xdecap_8_471 VDD VSS sg13cmos5l_decap_8
Xdecap_8_472 VDD VSS sg13cmos5l_decap_8
Xdecap_8_473 VDD VSS sg13cmos5l_decap_8
Xdecap_8_474 VDD VSS sg13cmos5l_decap_8
Xdecap_8_475 VDD VSS sg13cmos5l_decap_8
Xdecap_8_476 VDD VSS sg13cmos5l_decap_8
Xdecap_8_477 VDD VSS sg13cmos5l_decap_8
Xdecap_8_478 VDD VSS sg13cmos5l_decap_8
Xdecap_8_479 VDD VSS sg13cmos5l_decap_8
Xdecap_8_480 VDD VSS sg13cmos5l_decap_8
Xdecap_8_481 VDD VSS sg13cmos5l_decap_8
Xdecap_8_482 VDD VSS sg13cmos5l_decap_8
Xdecap_8_483 VDD VSS sg13cmos5l_decap_8
Xdecap_8_484 VDD VSS sg13cmos5l_decap_8
Xdecap_8_485 VDD VSS sg13cmos5l_decap_8
Xdecap_8_486 VDD VSS sg13cmos5l_decap_8
Xdecap_8_487 VDD VSS sg13cmos5l_decap_8
Xdecap_8_488 VDD VSS sg13cmos5l_decap_8
Xdecap_8_489 VDD VSS sg13cmos5l_decap_8
Xdecap_8_490 VDD VSS sg13cmos5l_decap_8
Xdecap_8_491 VDD VSS sg13cmos5l_decap_8
Xdecap_8_492 VDD VSS sg13cmos5l_decap_8
Xdecap_8_493 VDD VSS sg13cmos5l_decap_8
Xdecap_8_494 VDD VSS sg13cmos5l_decap_8
Xdecap_8_495 VDD VSS sg13cmos5l_decap_8
Xdecap_8_496 VDD VSS sg13cmos5l_decap_8
Xdecap_8_497 VDD VSS sg13cmos5l_decap_8
Xdecap_8_498 VDD VSS sg13cmos5l_decap_8
Xdecap_8_499 VDD VSS sg13cmos5l_decap_8
Xdecap_8_500 VDD VSS sg13cmos5l_decap_8
Xdecap_8_501 VDD VSS sg13cmos5l_decap_8
Xdecap_8_502 VDD VSS sg13cmos5l_decap_8
Xdecap_8_503 VDD VSS sg13cmos5l_decap_8
Xdecap_8_504 VDD VSS sg13cmos5l_decap_8
Xdecap_8_505 VDD VSS sg13cmos5l_decap_8
Xdecap_8_506 VDD VSS sg13cmos5l_decap_8
Xdecap_8_507 VDD VSS sg13cmos5l_decap_8
Xdecap_8_508 VDD VSS sg13cmos5l_decap_8
Xdecap_8_509 VDD VSS sg13cmos5l_decap_8
Xdecap_8_510 VDD VSS sg13cmos5l_decap_8
Xdecap_8_511 VDD VSS sg13cmos5l_decap_8
Xdecap_8_512 VDD VSS sg13cmos5l_decap_8
Xdecap_8_513 VDD VSS sg13cmos5l_decap_8
Xdecap_8_514 VDD VSS sg13cmos5l_decap_8
Xdecap_8_515 VDD VSS sg13cmos5l_decap_8
Xdecap_8_516 VDD VSS sg13cmos5l_decap_8
Xdecap_8_517 VDD VSS sg13cmos5l_decap_8
Xdecap_8_518 VDD VSS sg13cmos5l_decap_8
Xdecap_8_519 VDD VSS sg13cmos5l_decap_8
Xdecap_8_520 VDD VSS sg13cmos5l_decap_8
Xdecap_8_521 VDD VSS sg13cmos5l_decap_8
Xdecap_8_522 VDD VSS sg13cmos5l_decap_8
Xdecap_8_523 VDD VSS sg13cmos5l_decap_8
Xdecap_8_524 VDD VSS sg13cmos5l_decap_8
Xdecap_8_525 VDD VSS sg13cmos5l_decap_8
Xdecap_8_526 VDD VSS sg13cmos5l_decap_8
Xdecap_8_527 VDD VSS sg13cmos5l_decap_8
Xdecap_8_528 VDD VSS sg13cmos5l_decap_8
Xdecap_8_529 VDD VSS sg13cmos5l_decap_8
Xdecap_8_530 VDD VSS sg13cmos5l_decap_8
Xdecap_8_531 VDD VSS sg13cmos5l_decap_8
Xdecap_8_532 VDD VSS sg13cmos5l_decap_8
Xdecap_8_533 VDD VSS sg13cmos5l_decap_8
Xdecap_8_534 VDD VSS sg13cmos5l_decap_8
Xdecap_8_535 VDD VSS sg13cmos5l_decap_8
Xdecap_8_536 VDD VSS sg13cmos5l_decap_8
Xdecap_8_537 VDD VSS sg13cmos5l_decap_8
Xdecap_8_538 VDD VSS sg13cmos5l_decap_8
Xdecap_8_539 VDD VSS sg13cmos5l_decap_8
Xdecap_8_540 VDD VSS sg13cmos5l_decap_8
Xdecap_8_541 VDD VSS sg13cmos5l_decap_8
Xdecap_8_542 VDD VSS sg13cmos5l_decap_8
Xdecap_8_543 VDD VSS sg13cmos5l_decap_8
Xdecap_8_544 VDD VSS sg13cmos5l_decap_8
Xdecap_8_545 VDD VSS sg13cmos5l_decap_8
Xdecap_8_546 VDD VSS sg13cmos5l_decap_8
Xdecap_8_547 VDD VSS sg13cmos5l_decap_8
Xdecap_8_548 VDD VSS sg13cmos5l_decap_8
Xdecap_8_549 VDD VSS sg13cmos5l_decap_8
Xdecap_8_550 VDD VSS sg13cmos5l_decap_8
Xdecap_8_551 VDD VSS sg13cmos5l_decap_8
Xdecap_8_552 VDD VSS sg13cmos5l_decap_8
Xdecap_8_553 VDD VSS sg13cmos5l_decap_8
Xdecap_8_554 VDD VSS sg13cmos5l_decap_8
Xdecap_8_555 VDD VSS sg13cmos5l_decap_8
Xdecap_8_556 VDD VSS sg13cmos5l_decap_8
Xdecap_8_557 VDD VSS sg13cmos5l_decap_8
Xdecap_8_558 VDD VSS sg13cmos5l_decap_8
Xdecap_8_559 VDD VSS sg13cmos5l_decap_8
Xdecap_8_560 VDD VSS sg13cmos5l_decap_8
Xdecap_8_561 VDD VSS sg13cmos5l_decap_8
Xdecap_8_562 VDD VSS sg13cmos5l_decap_8
Xdecap_8_563 VDD VSS sg13cmos5l_decap_8
Xdecap_8_564 VDD VSS sg13cmos5l_decap_8
Xdecap_8_565 VDD VSS sg13cmos5l_decap_8
Xdecap_8_566 VDD VSS sg13cmos5l_decap_8
Xdecap_8_567 VDD VSS sg13cmos5l_decap_8
Xdecap_8_568 VDD VSS sg13cmos5l_decap_8
Xdecap_8_569 VDD VSS sg13cmos5l_decap_8
Xdecap_8_570 VDD VSS sg13cmos5l_decap_8
Xdecap_8_571 VDD VSS sg13cmos5l_decap_8
Xdecap_8_572 VDD VSS sg13cmos5l_decap_8
Xdecap_8_573 VDD VSS sg13cmos5l_decap_8
Xdecap_8_574 VDD VSS sg13cmos5l_decap_8
Xdecap_8_575 VDD VSS sg13cmos5l_decap_8
Xdecap_8_576 VDD VSS sg13cmos5l_decap_8
Xdecap_8_577 VDD VSS sg13cmos5l_decap_8
Xdecap_8_578 VDD VSS sg13cmos5l_decap_8
Xdecap_8_579 VDD VSS sg13cmos5l_decap_8
Xdecap_8_580 VDD VSS sg13cmos5l_decap_8
Xdecap_8_581 VDD VSS sg13cmos5l_decap_8
Xdecap_8_582 VDD VSS sg13cmos5l_decap_8
Xdecap_8_583 VDD VSS sg13cmos5l_decap_8
Xdecap_8_584 VDD VSS sg13cmos5l_decap_8
Xdecap_8_585 VDD VSS sg13cmos5l_decap_8
Xdecap_8_586 VDD VSS sg13cmos5l_decap_8
Xdecap_8_587 VDD VSS sg13cmos5l_decap_8
Xdecap_8_588 VDD VSS sg13cmos5l_decap_8
Xdecap_8_589 VDD VSS sg13cmos5l_decap_8
Xdecap_8_590 VDD VSS sg13cmos5l_decap_8
Xdecap_8_591 VDD VSS sg13cmos5l_decap_8
Xdecap_8_592 VDD VSS sg13cmos5l_decap_8
Xdecap_8_593 VDD VSS sg13cmos5l_decap_8
Xdecap_8_594 VDD VSS sg13cmos5l_decap_8
Xdecap_8_595 VDD VSS sg13cmos5l_decap_8
Xdecap_8_596 VDD VSS sg13cmos5l_decap_8
Xdecap_8_597 VDD VSS sg13cmos5l_decap_8
Xdecap_8_598 VDD VSS sg13cmos5l_decap_8
Xdecap_8_599 VDD VSS sg13cmos5l_decap_8
Xdecap_8_600 VDD VSS sg13cmos5l_decap_8
Xdecap_8_601 VDD VSS sg13cmos5l_decap_8
Xdecap_8_602 VDD VSS sg13cmos5l_decap_8
Xdecap_8_603 VDD VSS sg13cmos5l_decap_8
Xdecap_8_604 VDD VSS sg13cmos5l_decap_8
Xdecap_8_605 VDD VSS sg13cmos5l_decap_8
Xdecap_8_606 VDD VSS sg13cmos5l_decap_8
Xdecap_8_607 VDD VSS sg13cmos5l_decap_8
Xdecap_8_608 VDD VSS sg13cmos5l_decap_8
Xdecap_8_609 VDD VSS sg13cmos5l_decap_8
Xdecap_8_610 VDD VSS sg13cmos5l_decap_8
Xdecap_8_611 VDD VSS sg13cmos5l_decap_8
Xdecap_8_612 VDD VSS sg13cmos5l_decap_8
Xdecap_8_613 VDD VSS sg13cmos5l_decap_8
Xdecap_8_614 VDD VSS sg13cmos5l_decap_8
Xdecap_8_615 VDD VSS sg13cmos5l_decap_8
Xdecap_8_616 VDD VSS sg13cmos5l_decap_8
Xdecap_8_617 VDD VSS sg13cmos5l_decap_8
Xdecap_8_618 VDD VSS sg13cmos5l_decap_8
Xdecap_8_619 VDD VSS sg13cmos5l_decap_8
Xdecap_8_620 VDD VSS sg13cmos5l_decap_8
Xdecap_8_621 VDD VSS sg13cmos5l_decap_8
Xdecap_8_622 VDD VSS sg13cmos5l_decap_8
Xdecap_8_623 VDD VSS sg13cmos5l_decap_8
Xdecap_8_624 VDD VSS sg13cmos5l_decap_8
Xdecap_8_625 VDD VSS sg13cmos5l_decap_8
Xdecap_8_626 VDD VSS sg13cmos5l_decap_8
Xdecap_8_627 VDD VSS sg13cmos5l_decap_8
Xdecap_8_628 VDD VSS sg13cmos5l_decap_8
Xdecap_8_629 VDD VSS sg13cmos5l_decap_8
Xdecap_8_630 VDD VSS sg13cmos5l_decap_8
Xdecap_8_631 VDD VSS sg13cmos5l_decap_8
Xdecap_8_632 VDD VSS sg13cmos5l_decap_8
Xdecap_8_633 VDD VSS sg13cmos5l_decap_8
Xdecap_8_634 VDD VSS sg13cmos5l_decap_8
Xdecap_8_635 VDD VSS sg13cmos5l_decap_8
Xdecap_8_636 VDD VSS sg13cmos5l_decap_8
Xdecap_8_637 VDD VSS sg13cmos5l_decap_8
Xdecap_8_638 VDD VSS sg13cmos5l_decap_8
Xdecap_8_639 VDD VSS sg13cmos5l_decap_8
Xdecap_8_640 VDD VSS sg13cmos5l_decap_8
Xdecap_8_641 VDD VSS sg13cmos5l_decap_8
Xdecap_8_642 VDD VSS sg13cmos5l_decap_8
Xdecap_8_643 VDD VSS sg13cmos5l_decap_8
Xdecap_8_644 VDD VSS sg13cmos5l_decap_8
Xdecap_8_645 VDD VSS sg13cmos5l_decap_8
Xdecap_8_646 VDD VSS sg13cmos5l_decap_8
Xdecap_8_647 VDD VSS sg13cmos5l_decap_8
Xdecap_8_648 VDD VSS sg13cmos5l_decap_8
Xdecap_8_649 VDD VSS sg13cmos5l_decap_8
Xdecap_8_650 VDD VSS sg13cmos5l_decap_8
Xdecap_8_651 VDD VSS sg13cmos5l_decap_8
Xdecap_8_652 VDD VSS sg13cmos5l_decap_8
Xdecap_8_653 VDD VSS sg13cmos5l_decap_8
Xdecap_8_654 VDD VSS sg13cmos5l_decap_8
Xdecap_8_655 VDD VSS sg13cmos5l_decap_8
Xdecap_8_656 VDD VSS sg13cmos5l_decap_8
Xdecap_8_657 VDD VSS sg13cmos5l_decap_8
Xdecap_8_658 VDD VSS sg13cmos5l_decap_8
Xdecap_8_659 VDD VSS sg13cmos5l_decap_8
Xdecap_8_660 VDD VSS sg13cmos5l_decap_8
Xdecap_8_661 VDD VSS sg13cmos5l_decap_8
Xdecap_8_662 VDD VSS sg13cmos5l_decap_8
Xdecap_8_663 VDD VSS sg13cmos5l_decap_8
Xdecap_8_664 VDD VSS sg13cmos5l_decap_8
Xdecap_8_665 VDD VSS sg13cmos5l_decap_8
Xdecap_8_666 VDD VSS sg13cmos5l_decap_8
Xdecap_8_667 VDD VSS sg13cmos5l_decap_8
Xdecap_8_668 VDD VSS sg13cmos5l_decap_8
Xdecap_8_669 VDD VSS sg13cmos5l_decap_8
Xdecap_8_670 VDD VSS sg13cmos5l_decap_8
Xdecap_8_671 VDD VSS sg13cmos5l_decap_8
Xdecap_8_672 VDD VSS sg13cmos5l_decap_8
Xdecap_8_673 VDD VSS sg13cmos5l_decap_8
Xdecap_8_674 VDD VSS sg13cmos5l_decap_8
Xdecap_8_675 VDD VSS sg13cmos5l_decap_8
Xdecap_8_676 VDD VSS sg13cmos5l_decap_8
Xdecap_8_677 VDD VSS sg13cmos5l_decap_8
Xdecap_8_678 VDD VSS sg13cmos5l_decap_8
Xdecap_8_679 VDD VSS sg13cmos5l_decap_8
Xdecap_8_680 VDD VSS sg13cmos5l_decap_8
Xdecap_8_681 VDD VSS sg13cmos5l_decap_8
Xdecap_8_682 VDD VSS sg13cmos5l_decap_8
Xdecap_8_683 VDD VSS sg13cmos5l_decap_8
Xdecap_8_684 VDD VSS sg13cmos5l_decap_8
Xdecap_8_685 VDD VSS sg13cmos5l_decap_8
Xdecap_8_686 VDD VSS sg13cmos5l_decap_8
Xdecap_8_687 VDD VSS sg13cmos5l_decap_8
Xdecap_8_688 VDD VSS sg13cmos5l_decap_8
Xdecap_8_689 VDD VSS sg13cmos5l_decap_8
Xdecap_8_690 VDD VSS sg13cmos5l_decap_8
Xdecap_8_691 VDD VSS sg13cmos5l_decap_8
Xdecap_8_692 VDD VSS sg13cmos5l_decap_8
Xdecap_8_693 VDD VSS sg13cmos5l_decap_8
Xdecap_8_694 VDD VSS sg13cmos5l_decap_8
Xdecap_8_695 VDD VSS sg13cmos5l_decap_8
Xdecap_8_696 VDD VSS sg13cmos5l_decap_8
Xdecap_8_697 VDD VSS sg13cmos5l_decap_8
Xdecap_8_698 VDD VSS sg13cmos5l_decap_8
Xdecap_8_699 VDD VSS sg13cmos5l_decap_8
Xdecap_8_700 VDD VSS sg13cmos5l_decap_8
Xdecap_8_701 VDD VSS sg13cmos5l_decap_8
Xdecap_8_702 VDD VSS sg13cmos5l_decap_8
Xdecap_8_703 VDD VSS sg13cmos5l_decap_8
Xdecap_8_704 VDD VSS sg13cmos5l_decap_8
Xdecap_8_705 VDD VSS sg13cmos5l_decap_8
Xdecap_8_706 VDD VSS sg13cmos5l_decap_8
Xdecap_8_707 VDD VSS sg13cmos5l_decap_8
Xdecap_8_708 VDD VSS sg13cmos5l_decap_8
Xdecap_8_709 VDD VSS sg13cmos5l_decap_8
Xdecap_8_710 VDD VSS sg13cmos5l_decap_8
Xdecap_8_711 VDD VSS sg13cmos5l_decap_8
Xdecap_8_712 VDD VSS sg13cmos5l_decap_8
Xdecap_8_713 VDD VSS sg13cmos5l_decap_8
Xdecap_8_714 VDD VSS sg13cmos5l_decap_8
Xdecap_8_715 VDD VSS sg13cmos5l_decap_8
Xdecap_8_716 VDD VSS sg13cmos5l_decap_8
Xdecap_8_717 VDD VSS sg13cmos5l_decap_8
Xdecap_8_718 VDD VSS sg13cmos5l_decap_8
Xdecap_8_719 VDD VSS sg13cmos5l_decap_8
Xdecap_8_720 VDD VSS sg13cmos5l_decap_8
Xdecap_8_721 VDD VSS sg13cmos5l_decap_8
Xdecap_8_722 VDD VSS sg13cmos5l_decap_8
Xdecap_8_723 VDD VSS sg13cmos5l_decap_8
Xdecap_8_724 VDD VSS sg13cmos5l_decap_8
Xdecap_8_725 VDD VSS sg13cmos5l_decap_8
Xdecap_8_726 VDD VSS sg13cmos5l_decap_8
Xdecap_8_727 VDD VSS sg13cmos5l_decap_8
Xdecap_8_728 VDD VSS sg13cmos5l_decap_8
Xdecap_8_729 VDD VSS sg13cmos5l_decap_8
Xdecap_8_730 VDD VSS sg13cmos5l_decap_8
Xdecap_8_731 VDD VSS sg13cmos5l_decap_8
Xdecap_8_732 VDD VSS sg13cmos5l_decap_8
Xdecap_8_733 VDD VSS sg13cmos5l_decap_8
Xdecap_8_734 VDD VSS sg13cmos5l_decap_8
Xdecap_8_735 VDD VSS sg13cmos5l_decap_8
Xdecap_8_736 VDD VSS sg13cmos5l_decap_8
Xdecap_8_737 VDD VSS sg13cmos5l_decap_8
Xdecap_8_738 VDD VSS sg13cmos5l_decap_8
Xdecap_8_739 VDD VSS sg13cmos5l_decap_8
Xdecap_8_740 VDD VSS sg13cmos5l_decap_8
Xdecap_8_741 VDD VSS sg13cmos5l_decap_8
Xdecap_8_742 VDD VSS sg13cmos5l_decap_8
Xdecap_8_743 VDD VSS sg13cmos5l_decap_8
Xdecap_8_744 VDD VSS sg13cmos5l_decap_8
Xdecap_8_745 VDD VSS sg13cmos5l_decap_8
Xdecap_8_746 VDD VSS sg13cmos5l_decap_8
Xdecap_8_747 VDD VSS sg13cmos5l_decap_8
Xdecap_8_748 VDD VSS sg13cmos5l_decap_8
Xdecap_8_749 VDD VSS sg13cmos5l_decap_8
Xdecap_8_750 VDD VSS sg13cmos5l_decap_8
Xdecap_8_751 VDD VSS sg13cmos5l_decap_8
Xdecap_8_752 VDD VSS sg13cmos5l_decap_8
Xdecap_8_753 VDD VSS sg13cmos5l_decap_8
Xdecap_8_754 VDD VSS sg13cmos5l_decap_8
Xdecap_8_755 VDD VSS sg13cmos5l_decap_8
Xdecap_8_756 VDD VSS sg13cmos5l_decap_8
Xdecap_8_757 VDD VSS sg13cmos5l_decap_8
Xdecap_8_758 VDD VSS sg13cmos5l_decap_8
Xdecap_8_759 VDD VSS sg13cmos5l_decap_8
Xdecap_8_760 VDD VSS sg13cmos5l_decap_8
Xdecap_8_761 VDD VSS sg13cmos5l_decap_8
Xdecap_8_762 VDD VSS sg13cmos5l_decap_8
Xdecap_8_763 VDD VSS sg13cmos5l_decap_8
Xdecap_8_764 VDD VSS sg13cmos5l_decap_8
Xdecap_8_765 VDD VSS sg13cmos5l_decap_8
Xdecap_8_766 VDD VSS sg13cmos5l_decap_8
Xdecap_8_767 VDD VSS sg13cmos5l_decap_8
Xdecap_8_768 VDD VSS sg13cmos5l_decap_8
Xdecap_8_769 VDD VSS sg13cmos5l_decap_8
Xdecap_8_770 VDD VSS sg13cmos5l_decap_8
Xdecap_8_771 VDD VSS sg13cmos5l_decap_8
Xdecap_8_772 VDD VSS sg13cmos5l_decap_8
Xdecap_8_773 VDD VSS sg13cmos5l_decap_8
Xdecap_8_774 VDD VSS sg13cmos5l_decap_8
Xdecap_8_775 VDD VSS sg13cmos5l_decap_8
Xdecap_8_776 VDD VSS sg13cmos5l_decap_8
Xdecap_8_777 VDD VSS sg13cmos5l_decap_8
Xdecap_8_778 VDD VSS sg13cmos5l_decap_8
Xdecap_8_779 VDD VSS sg13cmos5l_decap_8
Xdecap_8_780 VDD VSS sg13cmos5l_decap_8
Xdecap_8_781 VDD VSS sg13cmos5l_decap_8
Xdecap_8_782 VDD VSS sg13cmos5l_decap_8
Xdecap_8_783 VDD VSS sg13cmos5l_decap_8
Xdecap_8_784 VDD VSS sg13cmos5l_decap_8
Xdecap_8_785 VDD VSS sg13cmos5l_decap_8
Xdecap_8_786 VDD VSS sg13cmos5l_decap_8
Xdecap_8_787 VDD VSS sg13cmos5l_decap_8
Xdecap_8_788 VDD VSS sg13cmos5l_decap_8
Xdecap_8_789 VDD VSS sg13cmos5l_decap_8
Xdecap_8_790 VDD VSS sg13cmos5l_decap_8
Xdecap_8_791 VDD VSS sg13cmos5l_decap_8
Xdecap_8_792 VDD VSS sg13cmos5l_decap_8
Xdecap_8_793 VDD VSS sg13cmos5l_decap_8
Xdecap_8_794 VDD VSS sg13cmos5l_decap_8
Xdecap_8_795 VDD VSS sg13cmos5l_decap_8
Xdecap_8_796 VDD VSS sg13cmos5l_decap_8
Xdecap_8_797 VDD VSS sg13cmos5l_decap_8
Xdecap_8_798 VDD VSS sg13cmos5l_decap_8
Xdecap_8_799 VDD VSS sg13cmos5l_decap_8
Xdecap_8_800 VDD VSS sg13cmos5l_decap_8
Xdecap_8_801 VDD VSS sg13cmos5l_decap_8
Xdecap_8_802 VDD VSS sg13cmos5l_decap_8
Xdecap_8_803 VDD VSS sg13cmos5l_decap_8
Xdecap_8_804 VDD VSS sg13cmos5l_decap_8
Xdecap_8_805 VDD VSS sg13cmos5l_decap_8
Xdecap_8_806 VDD VSS sg13cmos5l_decap_8
Xdecap_8_807 VDD VSS sg13cmos5l_decap_8
Xdecap_8_808 VDD VSS sg13cmos5l_decap_8
Xdecap_8_809 VDD VSS sg13cmos5l_decap_8
Xdecap_8_810 VDD VSS sg13cmos5l_decap_8
Xdecap_8_811 VDD VSS sg13cmos5l_decap_8
Xdecap_8_812 VDD VSS sg13cmos5l_decap_8
Xdecap_8_813 VDD VSS sg13cmos5l_decap_8
Xdecap_8_814 VDD VSS sg13cmos5l_decap_8
Xdecap_8_815 VDD VSS sg13cmos5l_decap_8
Xdecap_8_816 VDD VSS sg13cmos5l_decap_8
Xdecap_8_817 VDD VSS sg13cmos5l_decap_8
Xdecap_8_818 VDD VSS sg13cmos5l_decap_8
Xdecap_8_819 VDD VSS sg13cmos5l_decap_8
Xdecap_8_820 VDD VSS sg13cmos5l_decap_8
Xdecap_8_821 VDD VSS sg13cmos5l_decap_8
Xdecap_8_822 VDD VSS sg13cmos5l_decap_8
Xdecap_8_823 VDD VSS sg13cmos5l_decap_8
Xdecap_8_824 VDD VSS sg13cmos5l_decap_8
Xdecap_8_825 VDD VSS sg13cmos5l_decap_8
Xdecap_8_826 VDD VSS sg13cmos5l_decap_8
Xdecap_8_827 VDD VSS sg13cmos5l_decap_8
Xdecap_8_828 VDD VSS sg13cmos5l_decap_8
Xdecap_8_829 VDD VSS sg13cmos5l_decap_8
Xdecap_8_830 VDD VSS sg13cmos5l_decap_8
Xdecap_8_831 VDD VSS sg13cmos5l_decap_8
Xdecap_8_832 VDD VSS sg13cmos5l_decap_8
Xdecap_8_833 VDD VSS sg13cmos5l_decap_8
Xdecap_8_834 VDD VSS sg13cmos5l_decap_8
Xdecap_8_835 VDD VSS sg13cmos5l_decap_8
Xdecap_8_836 VDD VSS sg13cmos5l_decap_8
Xdecap_8_837 VDD VSS sg13cmos5l_decap_8
Xdecap_8_838 VDD VSS sg13cmos5l_decap_8
Xdecap_8_839 VDD VSS sg13cmos5l_decap_8
Xdecap_8_840 VDD VSS sg13cmos5l_decap_8
Xdecap_8_841 VDD VSS sg13cmos5l_decap_8
Xdecap_8_842 VDD VSS sg13cmos5l_decap_8
Xdecap_8_843 VDD VSS sg13cmos5l_decap_8
Xdecap_8_844 VDD VSS sg13cmos5l_decap_8
Xdecap_8_845 VDD VSS sg13cmos5l_decap_8
Xdecap_8_846 VDD VSS sg13cmos5l_decap_8
Xdecap_8_847 VDD VSS sg13cmos5l_decap_8
Xdecap_8_848 VDD VSS sg13cmos5l_decap_8
Xdecap_8_849 VDD VSS sg13cmos5l_decap_8
Xdecap_8_850 VDD VSS sg13cmos5l_decap_8
Xdecap_8_851 VDD VSS sg13cmos5l_decap_8
Xdecap_8_852 VDD VSS sg13cmos5l_decap_8
Xdecap_8_853 VDD VSS sg13cmos5l_decap_8
Xdecap_8_854 VDD VSS sg13cmos5l_decap_8
Xdecap_8_855 VDD VSS sg13cmos5l_decap_8
Xdecap_8_856 VDD VSS sg13cmos5l_decap_8
Xdecap_8_857 VDD VSS sg13cmos5l_decap_8
Xdecap_8_858 VDD VSS sg13cmos5l_decap_8
Xdecap_8_859 VDD VSS sg13cmos5l_decap_8
Xdecap_8_860 VDD VSS sg13cmos5l_decap_8
Xdecap_8_861 VDD VSS sg13cmos5l_decap_8
Xdecap_8_862 VDD VSS sg13cmos5l_decap_8
Xdecap_8_863 VDD VSS sg13cmos5l_decap_8
Xdecap_8_864 VDD VSS sg13cmos5l_decap_8
Xdecap_8_865 VDD VSS sg13cmos5l_decap_8
Xdecap_8_866 VDD VSS sg13cmos5l_decap_8
Xdecap_8_867 VDD VSS sg13cmos5l_decap_8
Xdecap_8_868 VDD VSS sg13cmos5l_decap_8
Xdecap_8_869 VDD VSS sg13cmos5l_decap_8
Xdecap_8_870 VDD VSS sg13cmos5l_decap_8
Xdecap_8_871 VDD VSS sg13cmos5l_decap_8
Xdecap_8_872 VDD VSS sg13cmos5l_decap_8
Xdecap_8_873 VDD VSS sg13cmos5l_decap_8
Xdecap_8_874 VDD VSS sg13cmos5l_decap_8
Xdecap_8_875 VDD VSS sg13cmos5l_decap_8
Xdecap_8_876 VDD VSS sg13cmos5l_decap_8
Xdecap_8_877 VDD VSS sg13cmos5l_decap_8
Xdecap_8_878 VDD VSS sg13cmos5l_decap_8
Xdecap_8_879 VDD VSS sg13cmos5l_decap_8
Xdecap_8_880 VDD VSS sg13cmos5l_decap_8
Xdecap_8_881 VDD VSS sg13cmos5l_decap_8
Xdecap_8_882 VDD VSS sg13cmos5l_decap_8
Xdecap_8_883 VDD VSS sg13cmos5l_decap_8
Xdecap_8_884 VDD VSS sg13cmos5l_decap_8
Xdecap_8_885 VDD VSS sg13cmos5l_decap_8
Xdecap_8_886 VDD VSS sg13cmos5l_decap_8
Xdecap_8_887 VDD VSS sg13cmos5l_decap_8
Xdecap_8_888 VDD VSS sg13cmos5l_decap_8
Xdecap_8_889 VDD VSS sg13cmos5l_decap_8
Xdecap_8_890 VDD VSS sg13cmos5l_decap_8
Xdecap_8_891 VDD VSS sg13cmos5l_decap_8
Xdecap_8_892 VDD VSS sg13cmos5l_decap_8
Xdecap_8_893 VDD VSS sg13cmos5l_decap_8
Xdecap_8_894 VDD VSS sg13cmos5l_decap_8
Xdecap_8_895 VDD VSS sg13cmos5l_decap_8
Xdecap_8_896 VDD VSS sg13cmos5l_decap_8
Xdecap_8_897 VDD VSS sg13cmos5l_decap_8
Xdecap_8_898 VDD VSS sg13cmos5l_decap_8
Xdecap_8_899 VDD VSS sg13cmos5l_decap_8
Xdecap_8_900 VDD VSS sg13cmos5l_decap_8
Xdecap_8_901 VDD VSS sg13cmos5l_decap_8
Xdecap_8_902 VDD VSS sg13cmos5l_decap_8
Xdecap_8_903 VDD VSS sg13cmos5l_decap_8
Xdecap_8_904 VDD VSS sg13cmos5l_decap_8
Xdecap_8_905 VDD VSS sg13cmos5l_decap_8
Xdecap_8_906 VDD VSS sg13cmos5l_decap_8
Xdecap_8_907 VDD VSS sg13cmos5l_decap_8
Xdecap_8_908 VDD VSS sg13cmos5l_decap_8
Xdecap_8_909 VDD VSS sg13cmos5l_decap_8
Xdecap_8_910 VDD VSS sg13cmos5l_decap_8
Xdecap_8_911 VDD VSS sg13cmos5l_decap_8
Xdecap_8_912 VDD VSS sg13cmos5l_decap_8
Xdecap_8_913 VDD VSS sg13cmos5l_decap_8
Xdecap_8_914 VDD VSS sg13cmos5l_decap_8
Xdecap_8_915 VDD VSS sg13cmos5l_decap_8
Xdecap_8_916 VDD VSS sg13cmos5l_decap_8
Xdecap_8_917 VDD VSS sg13cmos5l_decap_8
Xdecap_8_918 VDD VSS sg13cmos5l_decap_8
Xdecap_8_919 VDD VSS sg13cmos5l_decap_8
Xdecap_8_920 VDD VSS sg13cmos5l_decap_8
Xdecap_8_921 VDD VSS sg13cmos5l_decap_8
Xdecap_8_922 VDD VSS sg13cmos5l_decap_8
Xdecap_8_923 VDD VSS sg13cmos5l_decap_8
Xdecap_8_924 VDD VSS sg13cmos5l_decap_8
Xdecap_8_925 VDD VSS sg13cmos5l_decap_8
Xdecap_8_926 VDD VSS sg13cmos5l_decap_8
Xdecap_8_927 VDD VSS sg13cmos5l_decap_8
Xdecap_8_928 VDD VSS sg13cmos5l_decap_8
Xdecap_8_929 VDD VSS sg13cmos5l_decap_8
Xdecap_8_930 VDD VSS sg13cmos5l_decap_8
Xdecap_8_931 VDD VSS sg13cmos5l_decap_8
Xdecap_8_932 VDD VSS sg13cmos5l_decap_8
Xdecap_8_933 VDD VSS sg13cmos5l_decap_8
Xdecap_8_934 VDD VSS sg13cmos5l_decap_8
Xdecap_8_935 VDD VSS sg13cmos5l_decap_8
Xdecap_8_936 VDD VSS sg13cmos5l_decap_8
Xdecap_8_937 VDD VSS sg13cmos5l_decap_8
Xdecap_8_938 VDD VSS sg13cmos5l_decap_8
Xdecap_8_939 VDD VSS sg13cmos5l_decap_8
Xdecap_8_940 VDD VSS sg13cmos5l_decap_8
Xdecap_8_941 VDD VSS sg13cmos5l_decap_8
Xdecap_8_942 VDD VSS sg13cmos5l_decap_8
Xdecap_8_943 VDD VSS sg13cmos5l_decap_8
Xdecap_8_944 VDD VSS sg13cmos5l_decap_8
Xdecap_8_945 VDD VSS sg13cmos5l_decap_8
Xdecap_8_946 VDD VSS sg13cmos5l_decap_8
Xdecap_8_947 VDD VSS sg13cmos5l_decap_8
Xdecap_8_948 VDD VSS sg13cmos5l_decap_8
Xdecap_8_949 VDD VSS sg13cmos5l_decap_8
Xdecap_8_950 VDD VSS sg13cmos5l_decap_8
Xdecap_8_951 VDD VSS sg13cmos5l_decap_8
Xdecap_8_952 VDD VSS sg13cmos5l_decap_8
Xdecap_8_953 VDD VSS sg13cmos5l_decap_8
Xdecap_8_954 VDD VSS sg13cmos5l_decap_8
Xdecap_8_955 VDD VSS sg13cmos5l_decap_8
Xdecap_8_956 VDD VSS sg13cmos5l_decap_8
Xdecap_8_957 VDD VSS sg13cmos5l_decap_8
Xdecap_8_958 VDD VSS sg13cmos5l_decap_8
Xdecap_8_959 VDD VSS sg13cmos5l_decap_8
Xdecap_8_960 VDD VSS sg13cmos5l_decap_8
Xdecap_8_961 VDD VSS sg13cmos5l_decap_8
Xdecap_8_962 VDD VSS sg13cmos5l_decap_8
Xdecap_8_963 VDD VSS sg13cmos5l_decap_8
Xdecap_8_964 VDD VSS sg13cmos5l_decap_8
Xdecap_8_965 VDD VSS sg13cmos5l_decap_8
Xdecap_8_966 VDD VSS sg13cmos5l_decap_8
Xdecap_8_967 VDD VSS sg13cmos5l_decap_8
Xdecap_8_968 VDD VSS sg13cmos5l_decap_8
Xdecap_8_969 VDD VSS sg13cmos5l_decap_8
Xdecap_8_970 VDD VSS sg13cmos5l_decap_8
Xdecap_8_971 VDD VSS sg13cmos5l_decap_8
Xdecap_8_972 VDD VSS sg13cmos5l_decap_8
Xdecap_8_973 VDD VSS sg13cmos5l_decap_8
Xdecap_8_974 VDD VSS sg13cmos5l_decap_8
Xdecap_8_975 VDD VSS sg13cmos5l_decap_8
Xdecap_8_976 VDD VSS sg13cmos5l_decap_8
Xdecap_8_977 VDD VSS sg13cmos5l_decap_8
Xdecap_8_978 VDD VSS sg13cmos5l_decap_8
Xdecap_8_979 VDD VSS sg13cmos5l_decap_8
Xdecap_8_980 VDD VSS sg13cmos5l_decap_8
Xdecap_8_981 VDD VSS sg13cmos5l_decap_8
Xdecap_8_982 VDD VSS sg13cmos5l_decap_8
Xdecap_8_983 VDD VSS sg13cmos5l_decap_8
Xdecap_8_984 VDD VSS sg13cmos5l_decap_8
Xdecap_8_985 VDD VSS sg13cmos5l_decap_8
Xdecap_8_986 VDD VSS sg13cmos5l_decap_8
Xdecap_8_987 VDD VSS sg13cmos5l_decap_8
Xdecap_8_988 VDD VSS sg13cmos5l_decap_8
Xdecap_8_989 VDD VSS sg13cmos5l_decap_8
Xdecap_8_990 VDD VSS sg13cmos5l_decap_8
Xdecap_8_991 VDD VSS sg13cmos5l_decap_8
Xdecap_8_992 VDD VSS sg13cmos5l_decap_8
Xdecap_8_993 VDD VSS sg13cmos5l_decap_8
Xdecap_8_994 VDD VSS sg13cmos5l_decap_8
Xdecap_8_995 VDD VSS sg13cmos5l_decap_8
Xdecap_8_996 VDD VSS sg13cmos5l_decap_8
Xdecap_8_997 VDD VSS sg13cmos5l_decap_8
Xdecap_8_998 VDD VSS sg13cmos5l_decap_8
Xdecap_8_999 VDD VSS sg13cmos5l_decap_8
Xdecap_8_1000 VDD VSS sg13cmos5l_decap_8
Xdecap_8_1001 VDD VSS sg13cmos5l_decap_8
Xdecap_8_1002 VDD VSS sg13cmos5l_decap_8
Xdecap_8_1003 VDD VSS sg13cmos5l_decap_8
Xdecap_8_1004 VDD VSS sg13cmos5l_decap_8
Xdecap_8_1005 VDD VSS sg13cmos5l_decap_8
Xdecap_8_1006 VDD VSS sg13cmos5l_decap_8
Xdecap_8_1007 VDD VSS sg13cmos5l_decap_8
Xdecap_8_1008 VDD VSS sg13cmos5l_decap_8
Xdecap_8_1009 VDD VSS sg13cmos5l_decap_8
Xdecap_8_1010 VDD VSS sg13cmos5l_decap_8
Xdecap_8_1011 VDD VSS sg13cmos5l_decap_8
Xdecap_8_1012 VDD VSS sg13cmos5l_decap_8
Xdecap_8_1013 VDD VSS sg13cmos5l_decap_8
Xdecap_8_1014 VDD VSS sg13cmos5l_decap_8
Xdecap_8_1015 VDD VSS sg13cmos5l_decap_8
Xdecap_8_1016 VDD VSS sg13cmos5l_decap_8
Xdecap_8_1017 VDD VSS sg13cmos5l_decap_8
Xdecap_8_1018 VDD VSS sg13cmos5l_decap_8
Xdecap_8_1019 VDD VSS sg13cmos5l_decap_8
Xdecap_8_1020 VDD VSS sg13cmos5l_decap_8
Xdecap_8_1021 VDD VSS sg13cmos5l_decap_8
Xdecap_8_1022 VDD VSS sg13cmos5l_decap_8
Xdecap_8_1023 VDD VSS sg13cmos5l_decap_8
Xdecap_8_1024 VDD VSS sg13cmos5l_decap_8
Xdecap_8_1025 VDD VSS sg13cmos5l_decap_8
Xdecap_8_1026 VDD VSS sg13cmos5l_decap_8
Xdecap_8_1027 VDD VSS sg13cmos5l_decap_8
Xdecap_8_1028 VDD VSS sg13cmos5l_decap_8
Xdecap_8_1029 VDD VSS sg13cmos5l_decap_8
Xdecap_8_1030 VDD VSS sg13cmos5l_decap_8
Xdecap_8_1031 VDD VSS sg13cmos5l_decap_8
Xdecap_8_1032 VDD VSS sg13cmos5l_decap_8
Xdecap_8_1033 VDD VSS sg13cmos5l_decap_8
Xdecap_8_1034 VDD VSS sg13cmos5l_decap_8
Xdecap_8_1035 VDD VSS sg13cmos5l_decap_8
Xdecap_8_1036 VDD VSS sg13cmos5l_decap_8
Xdecap_8_1037 VDD VSS sg13cmos5l_decap_8
Xdecap_8_1038 VDD VSS sg13cmos5l_decap_8
Xdecap_8_1039 VDD VSS sg13cmos5l_decap_8
Xdecap_8_1040 VDD VSS sg13cmos5l_decap_8
Xdecap_8_1041 VDD VSS sg13cmos5l_decap_8
Xdecap_8_1042 VDD VSS sg13cmos5l_decap_8
Xdecap_8_1043 VDD VSS sg13cmos5l_decap_8
Xdecap_8_1044 VDD VSS sg13cmos5l_decap_8
Xdecap_8_1045 VDD VSS sg13cmos5l_decap_8
Xdecap_8_1046 VDD VSS sg13cmos5l_decap_8
Xdecap_8_1047 VDD VSS sg13cmos5l_decap_8
Xdecap_8_1048 VDD VSS sg13cmos5l_decap_8
Xdecap_8_1049 VDD VSS sg13cmos5l_decap_8
Xdecap_8_1050 VDD VSS sg13cmos5l_decap_8
Xdecap_8_1051 VDD VSS sg13cmos5l_decap_8
Xdecap_8_1052 VDD VSS sg13cmos5l_decap_8
Xdecap_8_1053 VDD VSS sg13cmos5l_decap_8
Xdecap_8_1054 VDD VSS sg13cmos5l_decap_8
Xdecap_8_1055 VDD VSS sg13cmos5l_decap_8
Xdecap_8_1056 VDD VSS sg13cmos5l_decap_8
Xdecap_8_1057 VDD VSS sg13cmos5l_decap_8
Xdecap_8_1058 VDD VSS sg13cmos5l_decap_8
Xdecap_8_1059 VDD VSS sg13cmos5l_decap_8
Xdecap_8_1060 VDD VSS sg13cmos5l_decap_8
Xdecap_8_1061 VDD VSS sg13cmos5l_decap_8
Xdecap_8_1062 VDD VSS sg13cmos5l_decap_8
Xdecap_8_1063 VDD VSS sg13cmos5l_decap_8
Xdecap_8_1064 VDD VSS sg13cmos5l_decap_8
Xdecap_8_1065 VDD VSS sg13cmos5l_decap_8
Xdecap_8_1066 VDD VSS sg13cmos5l_decap_8
Xdecap_8_1067 VDD VSS sg13cmos5l_decap_8
Xdecap_8_1068 VDD VSS sg13cmos5l_decap_8
Xdecap_8_1069 VDD VSS sg13cmos5l_decap_8
Xdecap_8_1070 VDD VSS sg13cmos5l_decap_8
Xdecap_8_1071 VDD VSS sg13cmos5l_decap_8
Xdecap_8_1072 VDD VSS sg13cmos5l_decap_8
Xdecap_8_1073 VDD VSS sg13cmos5l_decap_8
Xdecap_8_1074 VDD VSS sg13cmos5l_decap_8
Xdecap_8_1075 VDD VSS sg13cmos5l_decap_8
Xdecap_8_1076 VDD VSS sg13cmos5l_decap_8
Xdecap_8_1077 VDD VSS sg13cmos5l_decap_8
Xdecap_8_1078 VDD VSS sg13cmos5l_decap_8
Xdecap_8_1079 VDD VSS sg13cmos5l_decap_8
Xdecap_8_1080 VDD VSS sg13cmos5l_decap_8
Xdecap_8_1081 VDD VSS sg13cmos5l_decap_8
Xdecap_8_1082 VDD VSS sg13cmos5l_decap_8
Xdecap_8_1083 VDD VSS sg13cmos5l_decap_8
Xdecap_8_1084 VDD VSS sg13cmos5l_decap_8
Xdecap_8_1085 VDD VSS sg13cmos5l_decap_8
Xdecap_8_1086 VDD VSS sg13cmos5l_decap_8
Xdecap_8_1087 VDD VSS sg13cmos5l_decap_8
Xdecap_8_1088 VDD VSS sg13cmos5l_decap_8
Xdecap_8_1089 VDD VSS sg13cmos5l_decap_8
Xdecap_8_1090 VDD VSS sg13cmos5l_decap_8
Xdecap_8_1091 VDD VSS sg13cmos5l_decap_8
Xdecap_8_1092 VDD VSS sg13cmos5l_decap_8
Xdecap_8_1093 VDD VSS sg13cmos5l_decap_8
Xdecap_8_1094 VDD VSS sg13cmos5l_decap_8
Xdecap_8_1095 VDD VSS sg13cmos5l_decap_8
Xdecap_8_1096 VDD VSS sg13cmos5l_decap_8
Xdecap_8_1097 VDD VSS sg13cmos5l_decap_8
Xdecap_8_1098 VDD VSS sg13cmos5l_decap_8
Xdecap_8_1099 VDD VSS sg13cmos5l_decap_8
Xdecap_8_1100 VDD VSS sg13cmos5l_decap_8
Xdecap_8_1101 VDD VSS sg13cmos5l_decap_8
Xdecap_8_1102 VDD VSS sg13cmos5l_decap_8
Xdecap_8_1103 VDD VSS sg13cmos5l_decap_8
Xdecap_8_1104 VDD VSS sg13cmos5l_decap_8
Xdecap_8_1105 VDD VSS sg13cmos5l_decap_8
Xdecap_8_1106 VDD VSS sg13cmos5l_decap_8
Xdecap_8_1107 VDD VSS sg13cmos5l_decap_8
Xdecap_8_1108 VDD VSS sg13cmos5l_decap_8
Xdecap_8_1109 VDD VSS sg13cmos5l_decap_8
Xdecap_8_1110 VDD VSS sg13cmos5l_decap_8
Xdecap_8_1111 VDD VSS sg13cmos5l_decap_8
Xdecap_8_1112 VDD VSS sg13cmos5l_decap_8
Xdecap_8_1113 VDD VSS sg13cmos5l_decap_8
Xdecap_8_1114 VDD VSS sg13cmos5l_decap_8
Xdecap_8_1115 VDD VSS sg13cmos5l_decap_8
Xdecap_8_1116 VDD VSS sg13cmos5l_decap_8
Xdecap_8_1117 VDD VSS sg13cmos5l_decap_8
Xdecap_8_1118 VDD VSS sg13cmos5l_decap_8
Xdecap_8_1119 VDD VSS sg13cmos5l_decap_8
Xdecap_8_1120 VDD VSS sg13cmos5l_decap_8
Xdecap_8_1121 VDD VSS sg13cmos5l_decap_8
Xdecap_8_1122 VDD VSS sg13cmos5l_decap_8
Xdecap_8_1123 VDD VSS sg13cmos5l_decap_8
Xdecap_8_1124 VDD VSS sg13cmos5l_decap_8
Xdecap_8_1125 VDD VSS sg13cmos5l_decap_8
Xdecap_8_1126 VDD VSS sg13cmos5l_decap_8
Xdecap_8_1127 VDD VSS sg13cmos5l_decap_8
Xdecap_8_1128 VDD VSS sg13cmos5l_decap_8
Xdecap_8_1129 VDD VSS sg13cmos5l_decap_8
Xdecap_8_1130 VDD VSS sg13cmos5l_decap_8
Xdecap_8_1131 VDD VSS sg13cmos5l_decap_8
Xdecap_8_1132 VDD VSS sg13cmos5l_decap_8
Xdecap_8_1133 VDD VSS sg13cmos5l_decap_8
Xdecap_8_1134 VDD VSS sg13cmos5l_decap_8
Xdecap_8_1135 VDD VSS sg13cmos5l_decap_8
Xdecap_8_1136 VDD VSS sg13cmos5l_decap_8
Xdecap_8_1137 VDD VSS sg13cmos5l_decap_8
Xdecap_8_1138 VDD VSS sg13cmos5l_decap_8
Xdecap_8_1139 VDD VSS sg13cmos5l_decap_8
Xdecap_8_1140 VDD VSS sg13cmos5l_decap_8
Xdecap_8_1141 VDD VSS sg13cmos5l_decap_8
Xdecap_8_1142 VDD VSS sg13cmos5l_decap_8
Xdecap_8_1143 VDD VSS sg13cmos5l_decap_8
Xdecap_8_1144 VDD VSS sg13cmos5l_decap_8
Xdecap_8_1145 VDD VSS sg13cmos5l_decap_8
Xdecap_8_1146 VDD VSS sg13cmos5l_decap_8
Xdecap_8_1147 VDD VSS sg13cmos5l_decap_8
Xdecap_8_1148 VDD VSS sg13cmos5l_decap_8
Xdecap_8_1149 VDD VSS sg13cmos5l_decap_8
Xdecap_8_1150 VDD VSS sg13cmos5l_decap_8
Xdecap_8_1151 VDD VSS sg13cmos5l_decap_8
Xdecap_8_1152 VDD VSS sg13cmos5l_decap_8
Xdecap_8_1153 VDD VSS sg13cmos5l_decap_8
Xdecap_8_1154 VDD VSS sg13cmos5l_decap_8
Xdecap_8_1155 VDD VSS sg13cmos5l_decap_8
Xdecap_8_1156 VDD VSS sg13cmos5l_decap_8
Xdecap_8_1157 VDD VSS sg13cmos5l_decap_8
Xdecap_8_1158 VDD VSS sg13cmos5l_decap_8
Xdecap_8_1159 VDD VSS sg13cmos5l_decap_8
Xdecap_8_1160 VDD VSS sg13cmos5l_decap_8
Xdecap_8_1161 VDD VSS sg13cmos5l_decap_8
Xdecap_8_1162 VDD VSS sg13cmos5l_decap_8
Xdecap_8_1163 VDD VSS sg13cmos5l_decap_8
Xdecap_8_1164 VDD VSS sg13cmos5l_decap_8
Xdecap_8_1165 VDD VSS sg13cmos5l_decap_8
Xdecap_8_1166 VDD VSS sg13cmos5l_decap_8
Xdecap_8_1167 VDD VSS sg13cmos5l_decap_8
Xdecap_8_1168 VDD VSS sg13cmos5l_decap_8
Xdecap_8_1169 VDD VSS sg13cmos5l_decap_8
Xdecap_8_1170 VDD VSS sg13cmos5l_decap_8
Xdecap_8_1171 VDD VSS sg13cmos5l_decap_8
Xdecap_8_1172 VDD VSS sg13cmos5l_decap_8
Xdecap_8_1173 VDD VSS sg13cmos5l_decap_8
Xdecap_8_1174 VDD VSS sg13cmos5l_decap_8
Xdecap_8_1175 VDD VSS sg13cmos5l_decap_8
Xdecap_8_1176 VDD VSS sg13cmos5l_decap_8
Xdecap_8_1177 VDD VSS sg13cmos5l_decap_8
Xdecap_8_1178 VDD VSS sg13cmos5l_decap_8
Xdecap_8_1179 VDD VSS sg13cmos5l_decap_8
Xdecap_8_1180 VDD VSS sg13cmos5l_decap_8
Xdecap_8_1181 VDD VSS sg13cmos5l_decap_8
Xdecap_8_1182 VDD VSS sg13cmos5l_decap_8
Xdecap_8_1183 VDD VSS sg13cmos5l_decap_8
Xdecap_8_1184 VDD VSS sg13cmos5l_decap_8
Xdecap_8_1185 VDD VSS sg13cmos5l_decap_8
Xdecap_8_1186 VDD VSS sg13cmos5l_decap_8
Xdecap_8_1187 VDD VSS sg13cmos5l_decap_8
Xdecap_8_1188 VDD VSS sg13cmos5l_decap_8
Xdecap_8_1189 VDD VSS sg13cmos5l_decap_8
Xdecap_8_1190 VDD VSS sg13cmos5l_decap_8
Xdecap_8_1191 VDD VSS sg13cmos5l_decap_8
Xdecap_8_1192 VDD VSS sg13cmos5l_decap_8
Xdecap_8_1193 VDD VSS sg13cmos5l_decap_8
Xdecap_8_1194 VDD VSS sg13cmos5l_decap_8
Xdecap_8_1195 VDD VSS sg13cmos5l_decap_8
Xdecap_8_1196 VDD VSS sg13cmos5l_decap_8
Xdecap_8_1197 VDD VSS sg13cmos5l_decap_8
Xdecap_8_1198 VDD VSS sg13cmos5l_decap_8
Xdecap_8_1199 VDD VSS sg13cmos5l_decap_8
Xdecap_8_1200 VDD VSS sg13cmos5l_decap_8
Xdecap_8_1201 VDD VSS sg13cmos5l_decap_8
Xdecap_8_1202 VDD VSS sg13cmos5l_decap_8
Xdecap_8_1203 VDD VSS sg13cmos5l_decap_8
Xdecap_8_1204 VDD VSS sg13cmos5l_decap_8
Xdecap_8_1205 VDD VSS sg13cmos5l_decap_8
Xdecap_8_1206 VDD VSS sg13cmos5l_decap_8
Xdecap_8_1207 VDD VSS sg13cmos5l_decap_8
Xdecap_8_1208 VDD VSS sg13cmos5l_decap_8
Xdecap_8_1209 VDD VSS sg13cmos5l_decap_8
Xdecap_8_1210 VDD VSS sg13cmos5l_decap_8
Xdecap_8_1211 VDD VSS sg13cmos5l_decap_8
Xdecap_8_1212 VDD VSS sg13cmos5l_decap_8
Xdecap_8_1213 VDD VSS sg13cmos5l_decap_8
Xdecap_8_1214 VDD VSS sg13cmos5l_decap_8
Xdecap_8_1215 VDD VSS sg13cmos5l_decap_8
Xdecap_8_1216 VDD VSS sg13cmos5l_decap_8
Xdecap_8_1217 VDD VSS sg13cmos5l_decap_8
Xdecap_8_1218 VDD VSS sg13cmos5l_decap_8
Xdecap_8_1219 VDD VSS sg13cmos5l_decap_8
Xdecap_8_1220 VDD VSS sg13cmos5l_decap_8
Xdecap_8_1221 VDD VSS sg13cmos5l_decap_8
Xdecap_8_1222 VDD VSS sg13cmos5l_decap_8
Xdecap_8_1223 VDD VSS sg13cmos5l_decap_8
Xdecap_8_1224 VDD VSS sg13cmos5l_decap_8
Xdecap_8_1225 VDD VSS sg13cmos5l_decap_8
Xdecap_8_1226 VDD VSS sg13cmos5l_decap_8
Xdecap_8_1227 VDD VSS sg13cmos5l_decap_8
Xdecap_8_1228 VDD VSS sg13cmos5l_decap_8
Xdecap_8_1229 VDD VSS sg13cmos5l_decap_8
Xdecap_8_1230 VDD VSS sg13cmos5l_decap_8
Xdecap_8_1231 VDD VSS sg13cmos5l_decap_8
Xdecap_8_1232 VDD VSS sg13cmos5l_decap_8
Xdecap_8_1233 VDD VSS sg13cmos5l_decap_8
Xdecap_8_1234 VDD VSS sg13cmos5l_decap_8
Xdecap_8_1235 VDD VSS sg13cmos5l_decap_8
Xdecap_8_1236 VDD VSS sg13cmos5l_decap_8
Xdecap_8_1237 VDD VSS sg13cmos5l_decap_8
Xdecap_8_1238 VDD VSS sg13cmos5l_decap_8
Xdecap_8_1239 VDD VSS sg13cmos5l_decap_8
Xdecap_8_1240 VDD VSS sg13cmos5l_decap_8
Xdecap_8_1241 VDD VSS sg13cmos5l_decap_8
Xdecap_8_1242 VDD VSS sg13cmos5l_decap_8
Xdecap_8_1243 VDD VSS sg13cmos5l_decap_8
Xdecap_8_1244 VDD VSS sg13cmos5l_decap_8
Xdecap_8_1245 VDD VSS sg13cmos5l_decap_8
Xdecap_8_1246 VDD VSS sg13cmos5l_decap_8
Xdecap_8_1247 VDD VSS sg13cmos5l_decap_8
Xdecap_8_1248 VDD VSS sg13cmos5l_decap_8
Xdecap_8_1249 VDD VSS sg13cmos5l_decap_8
Xdecap_8_1250 VDD VSS sg13cmos5l_decap_8
Xdecap_8_1251 VDD VSS sg13cmos5l_decap_8
Xdecap_8_1252 VDD VSS sg13cmos5l_decap_8
Xdecap_8_1253 VDD VSS sg13cmos5l_decap_8
Xdecap_8_1254 VDD VSS sg13cmos5l_decap_8
Xdecap_8_1255 VDD VSS sg13cmos5l_decap_8
Xdecap_8_1256 VDD VSS sg13cmos5l_decap_8
Xdecap_8_1257 VDD VSS sg13cmos5l_decap_8
Xdecap_8_1258 VDD VSS sg13cmos5l_decap_8
Xdecap_8_1259 VDD VSS sg13cmos5l_decap_8
Xdecap_8_1260 VDD VSS sg13cmos5l_decap_8
Xdecap_8_1261 VDD VSS sg13cmos5l_decap_8
Xdecap_8_1262 VDD VSS sg13cmos5l_decap_8
Xdecap_8_1263 VDD VSS sg13cmos5l_decap_8
Xdecap_8_1264 VDD VSS sg13cmos5l_decap_8
Xdecap_8_1265 VDD VSS sg13cmos5l_decap_8
Xdecap_8_1266 VDD VSS sg13cmos5l_decap_8
Xdecap_8_1267 VDD VSS sg13cmos5l_decap_8
Xdecap_8_1268 VDD VSS sg13cmos5l_decap_8
Xdecap_8_1269 VDD VSS sg13cmos5l_decap_8
Xdecap_8_1270 VDD VSS sg13cmos5l_decap_8
Xdecap_8_1271 VDD VSS sg13cmos5l_decap_8
Xdecap_8_1272 VDD VSS sg13cmos5l_decap_8
Xdecap_8_1273 VDD VSS sg13cmos5l_decap_8
Xdecap_8_1274 VDD VSS sg13cmos5l_decap_8
Xdecap_8_1275 VDD VSS sg13cmos5l_decap_8
Xdecap_8_1276 VDD VSS sg13cmos5l_decap_8
Xdecap_8_1277 VDD VSS sg13cmos5l_decap_8
Xdecap_8_1278 VDD VSS sg13cmos5l_decap_8
Xdecap_8_1279 VDD VSS sg13cmos5l_decap_8
Xdecap_8_1280 VDD VSS sg13cmos5l_decap_8
Xdecap_8_1281 VDD VSS sg13cmos5l_decap_8
Xdecap_8_1282 VDD VSS sg13cmos5l_decap_8
Xdecap_8_1283 VDD VSS sg13cmos5l_decap_8
Xdecap_8_1284 VDD VSS sg13cmos5l_decap_8
Xdecap_8_1285 VDD VSS sg13cmos5l_decap_8
Xdecap_8_1286 VDD VSS sg13cmos5l_decap_8
Xdecap_8_1287 VDD VSS sg13cmos5l_decap_8
Xdecap_8_1288 VDD VSS sg13cmos5l_decap_8
Xdecap_8_1289 VDD VSS sg13cmos5l_decap_8
Xdecap_8_1290 VDD VSS sg13cmos5l_decap_8
Xdecap_8_1291 VDD VSS sg13cmos5l_decap_8
Xdecap_8_1292 VDD VSS sg13cmos5l_decap_8
Xdecap_8_1293 VDD VSS sg13cmos5l_decap_8
Xdecap_8_1294 VDD VSS sg13cmos5l_decap_8
Xdecap_8_1295 VDD VSS sg13cmos5l_decap_8
Xdecap_8_1296 VDD VSS sg13cmos5l_decap_8
Xdecap_8_1297 VDD VSS sg13cmos5l_decap_8
Xdecap_8_1298 VDD VSS sg13cmos5l_decap_8
Xdecap_8_1299 VDD VSS sg13cmos5l_decap_8
Xdecap_8_1300 VDD VSS sg13cmos5l_decap_8
Xdecap_8_1301 VDD VSS sg13cmos5l_decap_8
Xdecap_8_1302 VDD VSS sg13cmos5l_decap_8
Xdecap_8_1303 VDD VSS sg13cmos5l_decap_8
Xdecap_8_1304 VDD VSS sg13cmos5l_decap_8
Xdecap_8_1305 VDD VSS sg13cmos5l_decap_8
Xdecap_8_1306 VDD VSS sg13cmos5l_decap_8
Xdecap_8_1307 VDD VSS sg13cmos5l_decap_8
Xdecap_8_1308 VDD VSS sg13cmos5l_decap_8
Xdecap_8_1309 VDD VSS sg13cmos5l_decap_8
Xdecap_8_1310 VDD VSS sg13cmos5l_decap_8
Xdecap_8_1311 VDD VSS sg13cmos5l_decap_8
Xdecap_8_1312 VDD VSS sg13cmos5l_decap_8
Xdecap_8_1313 VDD VSS sg13cmos5l_decap_8
Xdecap_8_1314 VDD VSS sg13cmos5l_decap_8
Xdecap_8_1315 VDD VSS sg13cmos5l_decap_8
Xdecap_8_1316 VDD VSS sg13cmos5l_decap_8
Xdecap_8_1317 VDD VSS sg13cmos5l_decap_8
Xdecap_8_1318 VDD VSS sg13cmos5l_decap_8
Xdecap_8_1319 VDD VSS sg13cmos5l_decap_8
Xdecap_8_1320 VDD VSS sg13cmos5l_decap_8
Xdecap_8_1321 VDD VSS sg13cmos5l_decap_8
Xdecap_8_1322 VDD VSS sg13cmos5l_decap_8
Xdecap_8_1323 VDD VSS sg13cmos5l_decap_8
Xdecap_8_1324 VDD VSS sg13cmos5l_decap_8
Xdecap_8_1325 VDD VSS sg13cmos5l_decap_8
Xdecap_8_1326 VDD VSS sg13cmos5l_decap_8
Xdecap_8_1327 VDD VSS sg13cmos5l_decap_8
Xdecap_8_1328 VDD VSS sg13cmos5l_decap_8
Xdecap_8_1329 VDD VSS sg13cmos5l_decap_8
Xdecap_8_1330 VDD VSS sg13cmos5l_decap_8
Xdecap_8_1331 VDD VSS sg13cmos5l_decap_8
Xdecap_8_1332 VDD VSS sg13cmos5l_decap_8
Xdecap_8_1333 VDD VSS sg13cmos5l_decap_8
Xdecap_8_1334 VDD VSS sg13cmos5l_decap_8
Xdecap_8_1335 VDD VSS sg13cmos5l_decap_8
Xdecap_8_1336 VDD VSS sg13cmos5l_decap_8
Xdecap_8_1337 VDD VSS sg13cmos5l_decap_8
Xdecap_8_1338 VDD VSS sg13cmos5l_decap_8
Xdecap_8_1339 VDD VSS sg13cmos5l_decap_8
Xdecap_8_1340 VDD VSS sg13cmos5l_decap_8
Xdecap_8_1341 VDD VSS sg13cmos5l_decap_8
Xdecap_8_1342 VDD VSS sg13cmos5l_decap_8
Xdecap_8_1343 VDD VSS sg13cmos5l_decap_8
Xdecap_8_1344 VDD VSS sg13cmos5l_decap_8
Xdecap_8_1345 VDD VSS sg13cmos5l_decap_8
Xdecap_8_1346 VDD VSS sg13cmos5l_decap_8
Xdecap_8_1347 VDD VSS sg13cmos5l_decap_8
Xdecap_8_1348 VDD VSS sg13cmos5l_decap_8
Xdecap_8_1349 VDD VSS sg13cmos5l_decap_8
Xdecap_8_1350 VDD VSS sg13cmos5l_decap_8
Xdecap_8_1351 VDD VSS sg13cmos5l_decap_8
Xdecap_8_1352 VDD VSS sg13cmos5l_decap_8
Xdecap_8_1353 VDD VSS sg13cmos5l_decap_8
Xdecap_8_1354 VDD VSS sg13cmos5l_decap_8
Xdecap_8_1355 VDD VSS sg13cmos5l_decap_8
Xdecap_8_1356 VDD VSS sg13cmos5l_decap_8
Xdecap_8_1357 VDD VSS sg13cmos5l_decap_8
Xdecap_8_1358 VDD VSS sg13cmos5l_decap_8
Xdecap_8_1359 VDD VSS sg13cmos5l_decap_8
Xdecap_8_1360 VDD VSS sg13cmos5l_decap_8
Xdecap_8_1361 VDD VSS sg13cmos5l_decap_8
Xdecap_8_1362 VDD VSS sg13cmos5l_decap_8
Xdecap_8_1363 VDD VSS sg13cmos5l_decap_8
Xdecap_8_1364 VDD VSS sg13cmos5l_decap_8
Xdecap_8_1365 VDD VSS sg13cmos5l_decap_8
Xdecap_8_1366 VDD VSS sg13cmos5l_decap_8
Xdecap_8_1367 VDD VSS sg13cmos5l_decap_8
Xdecap_8_1368 VDD VSS sg13cmos5l_decap_8
Xdecap_8_1369 VDD VSS sg13cmos5l_decap_8
Xdecap_8_1370 VDD VSS sg13cmos5l_decap_8
Xdecap_8_1371 VDD VSS sg13cmos5l_decap_8
Xdecap_8_1372 VDD VSS sg13cmos5l_decap_8
Xdecap_8_1373 VDD VSS sg13cmos5l_decap_8
Xdecap_8_1374 VDD VSS sg13cmos5l_decap_8
Xdecap_8_1375 VDD VSS sg13cmos5l_decap_8
Xdecap_8_1376 VDD VSS sg13cmos5l_decap_8
Xdecap_8_1377 VDD VSS sg13cmos5l_decap_8
Xdecap_8_1378 VDD VSS sg13cmos5l_decap_8
Xdecap_8_1379 VDD VSS sg13cmos5l_decap_8
Xdecap_8_1380 VDD VSS sg13cmos5l_decap_8
Xdecap_8_1381 VDD VSS sg13cmos5l_decap_8
Xdecap_8_1382 VDD VSS sg13cmos5l_decap_8
Xdecap_8_1383 VDD VSS sg13cmos5l_decap_8
Xdecap_8_1384 VDD VSS sg13cmos5l_decap_8
Xdecap_8_1385 VDD VSS sg13cmos5l_decap_8
Xdecap_8_1386 VDD VSS sg13cmos5l_decap_8
Xdecap_8_1387 VDD VSS sg13cmos5l_decap_8
Xdecap_8_1388 VDD VSS sg13cmos5l_decap_8
Xdecap_8_1389 VDD VSS sg13cmos5l_decap_8
Xdecap_8_1390 VDD VSS sg13cmos5l_decap_8
Xdecap_8_1391 VDD VSS sg13cmos5l_decap_8
Xdecap_8_1392 VDD VSS sg13cmos5l_decap_8
Xdecap_8_1393 VDD VSS sg13cmos5l_decap_8
Xdecap_8_1394 VDD VSS sg13cmos5l_decap_8
Xdecap_8_1395 VDD VSS sg13cmos5l_decap_8
Xdecap_8_1396 VDD VSS sg13cmos5l_decap_8
Xdecap_8_1397 VDD VSS sg13cmos5l_decap_8
Xdecap_8_1398 VDD VSS sg13cmos5l_decap_8
Xdecap_8_1399 VDD VSS sg13cmos5l_decap_8
Xdecap_8_1400 VDD VSS sg13cmos5l_decap_8
Xdecap_8_1401 VDD VSS sg13cmos5l_decap_8
Xdecap_8_1402 VDD VSS sg13cmos5l_decap_8
Xdecap_8_1403 VDD VSS sg13cmos5l_decap_8
Xdecap_8_1404 VDD VSS sg13cmos5l_decap_8
Xdecap_8_1405 VDD VSS sg13cmos5l_decap_8
Xdecap_8_1406 VDD VSS sg13cmos5l_decap_8
Xdecap_8_1407 VDD VSS sg13cmos5l_decap_8
Xdecap_8_1408 VDD VSS sg13cmos5l_decap_8
Xdecap_8_1409 VDD VSS sg13cmos5l_decap_8
Xdecap_8_1410 VDD VSS sg13cmos5l_decap_8
Xdecap_8_1411 VDD VSS sg13cmos5l_decap_8
Xdecap_8_1412 VDD VSS sg13cmos5l_decap_8
Xdecap_8_1413 VDD VSS sg13cmos5l_decap_8
Xdecap_8_1414 VDD VSS sg13cmos5l_decap_8
Xdecap_8_1415 VDD VSS sg13cmos5l_decap_8
Xdecap_8_1416 VDD VSS sg13cmos5l_decap_8
Xdecap_8_1417 VDD VSS sg13cmos5l_decap_8
Xdecap_8_1418 VDD VSS sg13cmos5l_decap_8
Xdecap_8_1419 VDD VSS sg13cmos5l_decap_8
Xdecap_8_1420 VDD VSS sg13cmos5l_decap_8
Xdecap_8_1421 VDD VSS sg13cmos5l_decap_8
Xdecap_8_1422 VDD VSS sg13cmos5l_decap_8
Xdecap_8_1423 VDD VSS sg13cmos5l_decap_8
Xdecap_8_1424 VDD VSS sg13cmos5l_decap_8
Xdecap_8_1425 VDD VSS sg13cmos5l_decap_8
Xdecap_8_1426 VDD VSS sg13cmos5l_decap_8
Xdecap_8_1427 VDD VSS sg13cmos5l_decap_8
Xdecap_8_1428 VDD VSS sg13cmos5l_decap_8
Xdecap_8_1429 VDD VSS sg13cmos5l_decap_8
Xdecap_8_1430 VDD VSS sg13cmos5l_decap_8
Xdecap_8_1431 VDD VSS sg13cmos5l_decap_8
Xdecap_8_1432 VDD VSS sg13cmos5l_decap_8
Xdecap_8_1433 VDD VSS sg13cmos5l_decap_8
Xdecap_8_1434 VDD VSS sg13cmos5l_decap_8
Xdecap_8_1435 VDD VSS sg13cmos5l_decap_8
Xdecap_8_1436 VDD VSS sg13cmos5l_decap_8
Xdecap_8_1437 VDD VSS sg13cmos5l_decap_8
Xdecap_8_1438 VDD VSS sg13cmos5l_decap_8
Xdecap_8_1439 VDD VSS sg13cmos5l_decap_8
Xdecap_8_1440 VDD VSS sg13cmos5l_decap_8
Xdecap_8_1441 VDD VSS sg13cmos5l_decap_8
Xdecap_8_1442 VDD VSS sg13cmos5l_decap_8
Xdecap_8_1443 VDD VSS sg13cmos5l_decap_8
Xdecap_8_1444 VDD VSS sg13cmos5l_decap_8
Xdecap_8_1445 VDD VSS sg13cmos5l_decap_8
Xdecap_8_1446 VDD VSS sg13cmos5l_decap_8
Xdecap_8_1447 VDD VSS sg13cmos5l_decap_8
Xdecap_8_1448 VDD VSS sg13cmos5l_decap_8
Xdecap_8_1449 VDD VSS sg13cmos5l_decap_8
Xdecap_8_1450 VDD VSS sg13cmos5l_decap_8
Xdecap_8_1451 VDD VSS sg13cmos5l_decap_8
Xdecap_8_1452 VDD VSS sg13cmos5l_decap_8
Xdecap_8_1453 VDD VSS sg13cmos5l_decap_8
Xdecap_8_1454 VDD VSS sg13cmos5l_decap_8
Xdecap_8_1455 VDD VSS sg13cmos5l_decap_8
Xdecap_8_1456 VDD VSS sg13cmos5l_decap_8
Xdecap_8_1457 VDD VSS sg13cmos5l_decap_8
Xdecap_8_1458 VDD VSS sg13cmos5l_decap_8
Xdecap_8_1459 VDD VSS sg13cmos5l_decap_8
Xdecap_8_1460 VDD VSS sg13cmos5l_decap_8
Xdecap_8_1461 VDD VSS sg13cmos5l_decap_8
Xdecap_8_1462 VDD VSS sg13cmos5l_decap_8
Xdecap_8_1463 VDD VSS sg13cmos5l_decap_8
Xdecap_8_1464 VDD VSS sg13cmos5l_decap_8
Xdecap_8_1465 VDD VSS sg13cmos5l_decap_8
Xdecap_8_1466 VDD VSS sg13cmos5l_decap_8
Xdecap_8_1467 VDD VSS sg13cmos5l_decap_8
Xdecap_8_1468 VDD VSS sg13cmos5l_decap_8
Xdecap_8_1469 VDD VSS sg13cmos5l_decap_8
Xdecap_8_1470 VDD VSS sg13cmos5l_decap_8
Xdecap_8_1471 VDD VSS sg13cmos5l_decap_8
Xdecap_8_1472 VDD VSS sg13cmos5l_decap_8
Xdecap_8_1473 VDD VSS sg13cmos5l_decap_8
Xdecap_8_1474 VDD VSS sg13cmos5l_decap_8
Xdecap_8_1475 VDD VSS sg13cmos5l_decap_8
Xdecap_8_1476 VDD VSS sg13cmos5l_decap_8
Xdecap_8_1477 VDD VSS sg13cmos5l_decap_8
Xdecap_8_1478 VDD VSS sg13cmos5l_decap_8
Xdecap_8_1479 VDD VSS sg13cmos5l_decap_8
Xdecap_8_1480 VDD VSS sg13cmos5l_decap_8
Xdecap_8_1481 VDD VSS sg13cmos5l_decap_8
Xdecap_8_1482 VDD VSS sg13cmos5l_decap_8
Xdecap_8_1483 VDD VSS sg13cmos5l_decap_8
Xdecap_8_1484 VDD VSS sg13cmos5l_decap_8
Xdecap_8_1485 VDD VSS sg13cmos5l_decap_8
Xdecap_8_1486 VDD VSS sg13cmos5l_decap_8
Xdecap_8_1487 VDD VSS sg13cmos5l_decap_8
Xdecap_8_1488 VDD VSS sg13cmos5l_decap_8
Xdecap_8_1489 VDD VSS sg13cmos5l_decap_8
Xdecap_8_1490 VDD VSS sg13cmos5l_decap_8
Xdecap_8_1491 VDD VSS sg13cmos5l_decap_8
Xdecap_8_1492 VDD VSS sg13cmos5l_decap_8
Xdecap_8_1493 VDD VSS sg13cmos5l_decap_8
Xdecap_8_1494 VDD VSS sg13cmos5l_decap_8
Xdecap_8_1495 VDD VSS sg13cmos5l_decap_8
Xdecap_8_1496 VDD VSS sg13cmos5l_decap_8
Xdecap_8_1497 VDD VSS sg13cmos5l_decap_8
Xdecap_8_1498 VDD VSS sg13cmos5l_decap_8
Xdecap_8_1499 VDD VSS sg13cmos5l_decap_8
Xdecap_8_1500 VDD VSS sg13cmos5l_decap_8
Xdecap_8_1501 VDD VSS sg13cmos5l_decap_8
Xdecap_8_1502 VDD VSS sg13cmos5l_decap_8
Xdecap_8_1503 VDD VSS sg13cmos5l_decap_8
Xdecap_8_1504 VDD VSS sg13cmos5l_decap_8
Xdecap_8_1505 VDD VSS sg13cmos5l_decap_8
Xdecap_8_1506 VDD VSS sg13cmos5l_decap_8
Xdecap_8_1507 VDD VSS sg13cmos5l_decap_8
Xdecap_8_1508 VDD VSS sg13cmos5l_decap_8
Xdecap_8_1509 VDD VSS sg13cmos5l_decap_8
Xdecap_8_1510 VDD VSS sg13cmos5l_decap_8
Xdecap_8_1511 VDD VSS sg13cmos5l_decap_8
Xdecap_8_1512 VDD VSS sg13cmos5l_decap_8
Xdecap_8_1513 VDD VSS sg13cmos5l_decap_8
Xdecap_8_1514 VDD VSS sg13cmos5l_decap_8
Xdecap_8_1515 VDD VSS sg13cmos5l_decap_8
Xdecap_8_1516 VDD VSS sg13cmos5l_decap_8
Xdecap_8_1517 VDD VSS sg13cmos5l_decap_8
Xdecap_8_1518 VDD VSS sg13cmos5l_decap_8
Xdecap_8_1519 VDD VSS sg13cmos5l_decap_8
Xdecap_8_1520 VDD VSS sg13cmos5l_decap_8
Xdecap_8_1521 VDD VSS sg13cmos5l_decap_8
Xdecap_8_1522 VDD VSS sg13cmos5l_decap_8
Xdecap_8_1523 VDD VSS sg13cmos5l_decap_8
Xdecap_8_1524 VDD VSS sg13cmos5l_decap_8
Xdecap_8_1525 VDD VSS sg13cmos5l_decap_8
Xdecap_8_1526 VDD VSS sg13cmos5l_decap_8
Xdecap_8_1527 VDD VSS sg13cmos5l_decap_8
Xdecap_8_1528 VDD VSS sg13cmos5l_decap_8
Xdecap_8_1529 VDD VSS sg13cmos5l_decap_8
Xdecap_8_1530 VDD VSS sg13cmos5l_decap_8
Xdecap_8_1531 VDD VSS sg13cmos5l_decap_8
Xdecap_8_1532 VDD VSS sg13cmos5l_decap_8
Xdecap_8_1533 VDD VSS sg13cmos5l_decap_8
Xdecap_8_1534 VDD VSS sg13cmos5l_decap_8
Xdecap_8_1535 VDD VSS sg13cmos5l_decap_8
Xdecap_8_1536 VDD VSS sg13cmos5l_decap_8
Xdecap_8_1537 VDD VSS sg13cmos5l_decap_8
Xdecap_8_1538 VDD VSS sg13cmos5l_decap_8
Xdecap_8_1539 VDD VSS sg13cmos5l_decap_8
Xdecap_8_1540 VDD VSS sg13cmos5l_decap_8
Xdecap_8_1541 VDD VSS sg13cmos5l_decap_8
Xdecap_8_1542 VDD VSS sg13cmos5l_decap_8
Xdecap_8_1543 VDD VSS sg13cmos5l_decap_8
Xdecap_8_1544 VDD VSS sg13cmos5l_decap_8
Xdecap_8_1545 VDD VSS sg13cmos5l_decap_8
Xdecap_8_1546 VDD VSS sg13cmos5l_decap_8
Xdecap_8_1547 VDD VSS sg13cmos5l_decap_8
Xdecap_8_1548 VDD VSS sg13cmos5l_decap_8
Xdecap_8_1549 VDD VSS sg13cmos5l_decap_8
Xdecap_8_1550 VDD VSS sg13cmos5l_decap_8
Xdecap_8_1551 VDD VSS sg13cmos5l_decap_8
Xdecap_8_1552 VDD VSS sg13cmos5l_decap_8
Xdecap_8_1553 VDD VSS sg13cmos5l_decap_8
Xdecap_8_1554 VDD VSS sg13cmos5l_decap_8
Xdecap_8_1555 VDD VSS sg13cmos5l_decap_8
Xdecap_8_1556 VDD VSS sg13cmos5l_decap_8
Xdecap_8_1557 VDD VSS sg13cmos5l_decap_8
Xdecap_8_1558 VDD VSS sg13cmos5l_decap_8
Xdecap_8_1559 VDD VSS sg13cmos5l_decap_8
Xdecap_8_1560 VDD VSS sg13cmos5l_decap_8
Xdecap_8_1561 VDD VSS sg13cmos5l_decap_8
Xdecap_8_1562 VDD VSS sg13cmos5l_decap_8
Xdecap_8_1563 VDD VSS sg13cmos5l_decap_8
Xdecap_8_1564 VDD VSS sg13cmos5l_decap_8
Xdecap_8_1565 VDD VSS sg13cmos5l_decap_8
Xdecap_8_1566 VDD VSS sg13cmos5l_decap_8
Xdecap_8_1567 VDD VSS sg13cmos5l_decap_8
Xdecap_8_1568 VDD VSS sg13cmos5l_decap_8
Xdecap_8_1569 VDD VSS sg13cmos5l_decap_8
Xdecap_8_1570 VDD VSS sg13cmos5l_decap_8
Xdecap_8_1571 VDD VSS sg13cmos5l_decap_8
Xdecap_8_1572 VDD VSS sg13cmos5l_decap_8
Xdecap_8_1573 VDD VSS sg13cmos5l_decap_8
Xdecap_8_1574 VDD VSS sg13cmos5l_decap_8
Xdecap_8_1575 VDD VSS sg13cmos5l_decap_8
Xdecap_8_1576 VDD VSS sg13cmos5l_decap_8
Xdecap_8_1577 VDD VSS sg13cmos5l_decap_8
Xdecap_8_1578 VDD VSS sg13cmos5l_decap_8
Xdecap_8_1579 VDD VSS sg13cmos5l_decap_8
Xdecap_8_1580 VDD VSS sg13cmos5l_decap_8
Xdecap_8_1581 VDD VSS sg13cmos5l_decap_8
Xdecap_8_1582 VDD VSS sg13cmos5l_decap_8
Xdecap_8_1583 VDD VSS sg13cmos5l_decap_8
Xdecap_8_1584 VDD VSS sg13cmos5l_decap_8
Xdecap_8_1585 VDD VSS sg13cmos5l_decap_8
Xdecap_8_1586 VDD VSS sg13cmos5l_decap_8
Xdecap_8_1587 VDD VSS sg13cmos5l_decap_8
Xdecap_8_1588 VDD VSS sg13cmos5l_decap_8
Xdecap_8_1589 VDD VSS sg13cmos5l_decap_8
Xdecap_8_1590 VDD VSS sg13cmos5l_decap_8
Xdecap_8_1591 VDD VSS sg13cmos5l_decap_8
Xdecap_8_1592 VDD VSS sg13cmos5l_decap_8
Xdecap_8_1593 VDD VSS sg13cmos5l_decap_8
Xdecap_8_1594 VDD VSS sg13cmos5l_decap_8
Xdecap_8_1595 VDD VSS sg13cmos5l_decap_8
Xdecap_8_1596 VDD VSS sg13cmos5l_decap_8
Xdecap_8_1597 VDD VSS sg13cmos5l_decap_8
Xdecap_8_1598 VDD VSS sg13cmos5l_decap_8
Xdecap_8_1599 VDD VSS sg13cmos5l_decap_8
Xdecap_8_1600 VDD VSS sg13cmos5l_decap_8
Xdecap_8_1601 VDD VSS sg13cmos5l_decap_8
Xdecap_8_1602 VDD VSS sg13cmos5l_decap_8
Xdecap_8_1603 VDD VSS sg13cmos5l_decap_8
Xdecap_8_1604 VDD VSS sg13cmos5l_decap_8
Xdecap_8_1605 VDD VSS sg13cmos5l_decap_8
Xdecap_8_1606 VDD VSS sg13cmos5l_decap_8
Xdecap_8_1607 VDD VSS sg13cmos5l_decap_8
Xdecap_8_1608 VDD VSS sg13cmos5l_decap_8
Xdecap_8_1609 VDD VSS sg13cmos5l_decap_8
Xdecap_8_1610 VDD VSS sg13cmos5l_decap_8
Xdecap_8_1611 VDD VSS sg13cmos5l_decap_8
Xdecap_8_1612 VDD VSS sg13cmos5l_decap_8
Xdecap_8_1613 VDD VSS sg13cmos5l_decap_8
Xdecap_8_1614 VDD VSS sg13cmos5l_decap_8
Xdecap_8_1615 VDD VSS sg13cmos5l_decap_8
Xdecap_8_1616 VDD VSS sg13cmos5l_decap_8
Xdecap_8_1617 VDD VSS sg13cmos5l_decap_8
Xdecap_8_1618 VDD VSS sg13cmos5l_decap_8
Xdecap_8_1619 VDD VSS sg13cmos5l_decap_8
Xdecap_8_1620 VDD VSS sg13cmos5l_decap_8
Xdecap_8_1621 VDD VSS sg13cmos5l_decap_8
Xdecap_8_1622 VDD VSS sg13cmos5l_decap_8
Xdecap_8_1623 VDD VSS sg13cmos5l_decap_8
Xdecap_8_1624 VDD VSS sg13cmos5l_decap_8
Xdecap_8_1625 VDD VSS sg13cmos5l_decap_8
Xdecap_8_1626 VDD VSS sg13cmos5l_decap_8
Xdecap_8_1627 VDD VSS sg13cmos5l_decap_8
Xdecap_8_1628 VDD VSS sg13cmos5l_decap_8
Xdecap_8_1629 VDD VSS sg13cmos5l_decap_8
Xdecap_8_1630 VDD VSS sg13cmos5l_decap_8
Xdecap_8_1631 VDD VSS sg13cmos5l_decap_8
Xdecap_8_1632 VDD VSS sg13cmos5l_decap_8
Xdecap_8_1633 VDD VSS sg13cmos5l_decap_8
Xdecap_8_1634 VDD VSS sg13cmos5l_decap_8
Xdecap_8_1635 VDD VSS sg13cmos5l_decap_8
Xdecap_8_1636 VDD VSS sg13cmos5l_decap_8
Xdecap_8_1637 VDD VSS sg13cmos5l_decap_8
Xdecap_8_1638 VDD VSS sg13cmos5l_decap_8
Xdecap_8_1639 VDD VSS sg13cmos5l_decap_8
Xdecap_8_1640 VDD VSS sg13cmos5l_decap_8
Xdecap_8_1641 VDD VSS sg13cmos5l_decap_8
Xdecap_8_1642 VDD VSS sg13cmos5l_decap_8
Xdecap_8_1643 VDD VSS sg13cmos5l_decap_8
Xdecap_8_1644 VDD VSS sg13cmos5l_decap_8
Xdecap_8_1645 VDD VSS sg13cmos5l_decap_8
Xdecap_8_1646 VDD VSS sg13cmos5l_decap_8
Xdecap_8_1647 VDD VSS sg13cmos5l_decap_8
Xdecap_8_1648 VDD VSS sg13cmos5l_decap_8
Xdecap_8_1649 VDD VSS sg13cmos5l_decap_8
Xdecap_8_1650 VDD VSS sg13cmos5l_decap_8
Xdecap_8_1651 VDD VSS sg13cmos5l_decap_8
Xdecap_8_1652 VDD VSS sg13cmos5l_decap_8
Xdecap_8_1653 VDD VSS sg13cmos5l_decap_8
Xdecap_8_1654 VDD VSS sg13cmos5l_decap_8
Xdecap_8_1655 VDD VSS sg13cmos5l_decap_8
Xdecap_8_1656 VDD VSS sg13cmos5l_decap_8
Xdecap_8_1657 VDD VSS sg13cmos5l_decap_8
Xdecap_8_1658 VDD VSS sg13cmos5l_decap_8
Xdecap_8_1659 VDD VSS sg13cmos5l_decap_8
Xdecap_8_1660 VDD VSS sg13cmos5l_decap_8
Xdecap_8_1661 VDD VSS sg13cmos5l_decap_8
Xdecap_8_1662 VDD VSS sg13cmos5l_decap_8
Xdecap_8_1663 VDD VSS sg13cmos5l_decap_8
Xdecap_8_1664 VDD VSS sg13cmos5l_decap_8
Xdecap_8_1665 VDD VSS sg13cmos5l_decap_8
Xdecap_8_1666 VDD VSS sg13cmos5l_decap_8
Xdecap_8_1667 VDD VSS sg13cmos5l_decap_8
Xdecap_8_1668 VDD VSS sg13cmos5l_decap_8
Xdecap_8_1669 VDD VSS sg13cmos5l_decap_8
Xdecap_8_1670 VDD VSS sg13cmos5l_decap_8
Xdecap_8_1671 VDD VSS sg13cmos5l_decap_8
Xdecap_8_1672 VDD VSS sg13cmos5l_decap_8
Xdecap_8_1673 VDD VSS sg13cmos5l_decap_8
Xdecap_8_1674 VDD VSS sg13cmos5l_decap_8
Xdecap_8_1675 VDD VSS sg13cmos5l_decap_8
Xdecap_8_1676 VDD VSS sg13cmos5l_decap_8
Xdecap_8_1677 VDD VSS sg13cmos5l_decap_8
Xdecap_8_1678 VDD VSS sg13cmos5l_decap_8
Xdecap_8_1679 VDD VSS sg13cmos5l_decap_8
Xdecap_8_1680 VDD VSS sg13cmos5l_decap_8
Xdecap_8_1681 VDD VSS sg13cmos5l_decap_8
Xdecap_8_1682 VDD VSS sg13cmos5l_decap_8
Xdecap_8_1683 VDD VSS sg13cmos5l_decap_8
Xdecap_8_1684 VDD VSS sg13cmos5l_decap_8
Xdecap_8_1685 VDD VSS sg13cmos5l_decap_8
Xdecap_8_1686 VDD VSS sg13cmos5l_decap_8
Xdecap_8_1687 VDD VSS sg13cmos5l_decap_8
Xdecap_8_1688 VDD VSS sg13cmos5l_decap_8
Xdecap_8_1689 VDD VSS sg13cmos5l_decap_8
Xdecap_8_1690 VDD VSS sg13cmos5l_decap_8
Xdecap_8_1691 VDD VSS sg13cmos5l_decap_8
Xdecap_8_1692 VDD VSS sg13cmos5l_decap_8
Xdecap_8_1693 VDD VSS sg13cmos5l_decap_8
Xdecap_8_1694 VDD VSS sg13cmos5l_decap_8
Xdecap_8_1695 VDD VSS sg13cmos5l_decap_8
Xdecap_8_1696 VDD VSS sg13cmos5l_decap_8
Xdecap_8_1697 VDD VSS sg13cmos5l_decap_8
Xdecap_8_1698 VDD VSS sg13cmos5l_decap_8
Xdecap_8_1699 VDD VSS sg13cmos5l_decap_8
Xdecap_8_1700 VDD VSS sg13cmos5l_decap_8
Xdecap_8_1701 VDD VSS sg13cmos5l_decap_8
Xdecap_8_1702 VDD VSS sg13cmos5l_decap_8
Xdecap_8_1703 VDD VSS sg13cmos5l_decap_8
Xdecap_8_1704 VDD VSS sg13cmos5l_decap_8
Xdecap_8_1705 VDD VSS sg13cmos5l_decap_8
Xdecap_8_1706 VDD VSS sg13cmos5l_decap_8
Xdecap_8_1707 VDD VSS sg13cmos5l_decap_8
Xdecap_8_1708 VDD VSS sg13cmos5l_decap_8
Xdecap_8_1709 VDD VSS sg13cmos5l_decap_8
Xdecap_8_1710 VDD VSS sg13cmos5l_decap_8
Xdecap_8_1711 VDD VSS sg13cmos5l_decap_8
Xdecap_8_1712 VDD VSS sg13cmos5l_decap_8
Xdecap_8_1713 VDD VSS sg13cmos5l_decap_8
Xdecap_8_1714 VDD VSS sg13cmos5l_decap_8
Xdecap_8_1715 VDD VSS sg13cmos5l_decap_8
Xdecap_8_1716 VDD VSS sg13cmos5l_decap_8
Xdecap_8_1717 VDD VSS sg13cmos5l_decap_8
Xdecap_8_1718 VDD VSS sg13cmos5l_decap_8
Xdecap_8_1719 VDD VSS sg13cmos5l_decap_8
Xdecap_8_1720 VDD VSS sg13cmos5l_decap_8
Xdecap_8_1721 VDD VSS sg13cmos5l_decap_8
Xdecap_8_1722 VDD VSS sg13cmos5l_decap_8
Xdecap_8_1723 VDD VSS sg13cmos5l_decap_8
Xdecap_8_1724 VDD VSS sg13cmos5l_decap_8
Xdecap_8_1725 VDD VSS sg13cmos5l_decap_8
Xdecap_8_1726 VDD VSS sg13cmos5l_decap_8
Xdecap_8_1727 VDD VSS sg13cmos5l_decap_8
Xdecap_8_1728 VDD VSS sg13cmos5l_decap_8
Xdecap_8_1729 VDD VSS sg13cmos5l_decap_8
Xdecap_8_1730 VDD VSS sg13cmos5l_decap_8
Xdecap_8_1731 VDD VSS sg13cmos5l_decap_8
Xdecap_8_1732 VDD VSS sg13cmos5l_decap_8
Xdecap_8_1733 VDD VSS sg13cmos5l_decap_8
Xdecap_8_1734 VDD VSS sg13cmos5l_decap_8
Xdecap_8_1735 VDD VSS sg13cmos5l_decap_8
Xdecap_8_1736 VDD VSS sg13cmos5l_decap_8
Xdecap_8_1737 VDD VSS sg13cmos5l_decap_8
Xdecap_8_1738 VDD VSS sg13cmos5l_decap_8
Xdecap_8_1739 VDD VSS sg13cmos5l_decap_8
Xdecap_8_1740 VDD VSS sg13cmos5l_decap_8
Xdecap_8_1741 VDD VSS sg13cmos5l_decap_8
Xdecap_8_1742 VDD VSS sg13cmos5l_decap_8
Xdecap_8_1743 VDD VSS sg13cmos5l_decap_8
Xdecap_8_1744 VDD VSS sg13cmos5l_decap_8
Xdecap_8_1745 VDD VSS sg13cmos5l_decap_8
Xdecap_8_1746 VDD VSS sg13cmos5l_decap_8
Xdecap_8_1747 VDD VSS sg13cmos5l_decap_8
Xdecap_8_1748 VDD VSS sg13cmos5l_decap_8
Xdecap_8_1749 VDD VSS sg13cmos5l_decap_8
Xdecap_8_1750 VDD VSS sg13cmos5l_decap_8
Xdecap_8_1751 VDD VSS sg13cmos5l_decap_8
Xdecap_8_1752 VDD VSS sg13cmos5l_decap_8
Xdecap_8_1753 VDD VSS sg13cmos5l_decap_8
Xdecap_8_1754 VDD VSS sg13cmos5l_decap_8
Xdecap_8_1755 VDD VSS sg13cmos5l_decap_8
Xdecap_8_1756 VDD VSS sg13cmos5l_decap_8
Xdecap_8_1757 VDD VSS sg13cmos5l_decap_8
Xdecap_8_1758 VDD VSS sg13cmos5l_decap_8
Xdecap_8_1759 VDD VSS sg13cmos5l_decap_8
Xdecap_8_1760 VDD VSS sg13cmos5l_decap_8
Xdecap_8_1761 VDD VSS sg13cmos5l_decap_8
Xdecap_8_1762 VDD VSS sg13cmos5l_decap_8
Xdecap_8_1763 VDD VSS sg13cmos5l_decap_8
Xdecap_8_1764 VDD VSS sg13cmos5l_decap_8
Xdecap_8_1765 VDD VSS sg13cmos5l_decap_8
Xdecap_8_1766 VDD VSS sg13cmos5l_decap_8
Xdecap_8_1767 VDD VSS sg13cmos5l_decap_8
Xdecap_8_1768 VDD VSS sg13cmos5l_decap_8
Xdecap_8_1769 VDD VSS sg13cmos5l_decap_8
Xdecap_8_1770 VDD VSS sg13cmos5l_decap_8
Xdecap_8_1771 VDD VSS sg13cmos5l_decap_8
Xdecap_8_1772 VDD VSS sg13cmos5l_decap_8
Xdecap_8_1773 VDD VSS sg13cmos5l_decap_8
Xdecap_8_1774 VDD VSS sg13cmos5l_decap_8
Xdecap_8_1775 VDD VSS sg13cmos5l_decap_8
Xdecap_8_1776 VDD VSS sg13cmos5l_decap_8
Xdecap_8_1777 VDD VSS sg13cmos5l_decap_8
Xdecap_8_1778 VDD VSS sg13cmos5l_decap_8
Xdecap_8_1779 VDD VSS sg13cmos5l_decap_8
Xdecap_8_1780 VDD VSS sg13cmos5l_decap_8
Xdecap_8_1781 VDD VSS sg13cmos5l_decap_8
Xdecap_8_1782 VDD VSS sg13cmos5l_decap_8
Xdecap_8_1783 VDD VSS sg13cmos5l_decap_8
Xdecap_8_1784 VDD VSS sg13cmos5l_decap_8
Xdecap_8_1785 VDD VSS sg13cmos5l_decap_8
Xdecap_8_1786 VDD VSS sg13cmos5l_decap_8
Xdecap_8_1787 VDD VSS sg13cmos5l_decap_8
Xdecap_8_1788 VDD VSS sg13cmos5l_decap_8
Xdecap_8_1789 VDD VSS sg13cmos5l_decap_8
Xdecap_8_1790 VDD VSS sg13cmos5l_decap_8
Xdecap_8_1791 VDD VSS sg13cmos5l_decap_8
Xdecap_8_1792 VDD VSS sg13cmos5l_decap_8
Xdecap_8_1793 VDD VSS sg13cmos5l_decap_8
Xdecap_8_1794 VDD VSS sg13cmos5l_decap_8
Xdecap_8_1795 VDD VSS sg13cmos5l_decap_8
Xdecap_8_1796 VDD VSS sg13cmos5l_decap_8
Xdecap_8_1797 VDD VSS sg13cmos5l_decap_8
Xdecap_8_1798 VDD VSS sg13cmos5l_decap_8
Xdecap_8_1799 VDD VSS sg13cmos5l_decap_8
Xdecap_8_1800 VDD VSS sg13cmos5l_decap_8
Xdecap_8_1801 VDD VSS sg13cmos5l_decap_8
Xdecap_8_1802 VDD VSS sg13cmos5l_decap_8
Xdecap_8_1803 VDD VSS sg13cmos5l_decap_8
Xdecap_8_1804 VDD VSS sg13cmos5l_decap_8
Xdecap_8_1805 VDD VSS sg13cmos5l_decap_8
Xdecap_8_1806 VDD VSS sg13cmos5l_decap_8
Xdecap_8_1807 VDD VSS sg13cmos5l_decap_8
Xdecap_8_1808 VDD VSS sg13cmos5l_decap_8
Xdecap_8_1809 VDD VSS sg13cmos5l_decap_8
Xdecap_8_1810 VDD VSS sg13cmos5l_decap_8
Xdecap_8_1811 VDD VSS sg13cmos5l_decap_8
Xdecap_8_1812 VDD VSS sg13cmos5l_decap_8
Xdecap_8_1813 VDD VSS sg13cmos5l_decap_8
Xdecap_8_1814 VDD VSS sg13cmos5l_decap_8
Xdecap_8_1815 VDD VSS sg13cmos5l_decap_8
Xdecap_8_1816 VDD VSS sg13cmos5l_decap_8
Xdecap_8_1817 VDD VSS sg13cmos5l_decap_8
Xdecap_8_1818 VDD VSS sg13cmos5l_decap_8
Xdecap_8_1819 VDD VSS sg13cmos5l_decap_8
Xdecap_8_1820 VDD VSS sg13cmos5l_decap_8
Xdecap_8_1821 VDD VSS sg13cmos5l_decap_8
Xdecap_8_1822 VDD VSS sg13cmos5l_decap_8
Xdecap_8_1823 VDD VSS sg13cmos5l_decap_8
Xdecap_8_1824 VDD VSS sg13cmos5l_decap_8
Xdecap_8_1825 VDD VSS sg13cmos5l_decap_8
Xdecap_8_1826 VDD VSS sg13cmos5l_decap_8
Xdecap_8_1827 VDD VSS sg13cmos5l_decap_8
Xdecap_8_1828 VDD VSS sg13cmos5l_decap_8
Xdecap_8_1829 VDD VSS sg13cmos5l_decap_8
Xdecap_8_1830 VDD VSS sg13cmos5l_decap_8
Xdecap_8_1831 VDD VSS sg13cmos5l_decap_8
Xdecap_8_1832 VDD VSS sg13cmos5l_decap_8
Xdecap_8_1833 VDD VSS sg13cmos5l_decap_8
Xdecap_8_1834 VDD VSS sg13cmos5l_decap_8
Xdecap_8_1835 VDD VSS sg13cmos5l_decap_8
Xdecap_8_1836 VDD VSS sg13cmos5l_decap_8
Xdecap_8_1837 VDD VSS sg13cmos5l_decap_8
Xdecap_8_1838 VDD VSS sg13cmos5l_decap_8
Xdecap_8_1839 VDD VSS sg13cmos5l_decap_8
Xdecap_8_1840 VDD VSS sg13cmos5l_decap_8
Xdecap_8_1841 VDD VSS sg13cmos5l_decap_8
Xdecap_8_1842 VDD VSS sg13cmos5l_decap_8
Xdecap_8_1843 VDD VSS sg13cmos5l_decap_8
Xdecap_8_1844 VDD VSS sg13cmos5l_decap_8
Xdecap_8_1845 VDD VSS sg13cmos5l_decap_8
Xdecap_8_1846 VDD VSS sg13cmos5l_decap_8
Xdecap_8_1847 VDD VSS sg13cmos5l_decap_8
Xdecap_8_1848 VDD VSS sg13cmos5l_decap_8
Xdecap_8_1849 VDD VSS sg13cmos5l_decap_8
Xdecap_8_1850 VDD VSS sg13cmos5l_decap_8
Xdecap_8_1851 VDD VSS sg13cmos5l_decap_8
Xdecap_8_1852 VDD VSS sg13cmos5l_decap_8
Xdecap_8_1853 VDD VSS sg13cmos5l_decap_8
Xdecap_8_1854 VDD VSS sg13cmos5l_decap_8
Xdecap_8_1855 VDD VSS sg13cmos5l_decap_8
Xdecap_8_1856 VDD VSS sg13cmos5l_decap_8
Xdecap_8_1857 VDD VSS sg13cmos5l_decap_8
Xdecap_8_1858 VDD VSS sg13cmos5l_decap_8
Xdecap_8_1859 VDD VSS sg13cmos5l_decap_8
Xdecap_8_1860 VDD VSS sg13cmos5l_decap_8
Xdecap_8_1861 VDD VSS sg13cmos5l_decap_8
Xdecap_8_1862 VDD VSS sg13cmos5l_decap_8
Xdecap_8_1863 VDD VSS sg13cmos5l_decap_8
Xdecap_8_1864 VDD VSS sg13cmos5l_decap_8
Xdecap_8_1865 VDD VSS sg13cmos5l_decap_8
Xdecap_8_1866 VDD VSS sg13cmos5l_decap_8
Xdecap_8_1867 VDD VSS sg13cmos5l_decap_8
Xdecap_8_1868 VDD VSS sg13cmos5l_decap_8
Xdecap_8_1869 VDD VSS sg13cmos5l_decap_8
Xdecap_8_1870 VDD VSS sg13cmos5l_decap_8
Xdecap_8_1871 VDD VSS sg13cmos5l_decap_8
Xdecap_8_1872 VDD VSS sg13cmos5l_decap_8
Xdecap_8_1873 VDD VSS sg13cmos5l_decap_8
Xdecap_8_1874 VDD VSS sg13cmos5l_decap_8
Xdecap_8_1875 VDD VSS sg13cmos5l_decap_8
Xdecap_8_1876 VDD VSS sg13cmos5l_decap_8
Xdecap_8_1877 VDD VSS sg13cmos5l_decap_8
Xdecap_8_1878 VDD VSS sg13cmos5l_decap_8
Xdecap_8_1879 VDD VSS sg13cmos5l_decap_8
Xdecap_8_1880 VDD VSS sg13cmos5l_decap_8
Xdecap_8_1881 VDD VSS sg13cmos5l_decap_8
Xdecap_8_1882 VDD VSS sg13cmos5l_decap_8
Xdecap_8_1883 VDD VSS sg13cmos5l_decap_8
Xdecap_8_1884 VDD VSS sg13cmos5l_decap_8
Xdecap_8_1885 VDD VSS sg13cmos5l_decap_8
Xdecap_8_1886 VDD VSS sg13cmos5l_decap_8
Xdecap_8_1887 VDD VSS sg13cmos5l_decap_8
Xdecap_8_1888 VDD VSS sg13cmos5l_decap_8
Xdecap_8_1889 VDD VSS sg13cmos5l_decap_8
Xdecap_8_1890 VDD VSS sg13cmos5l_decap_8
Xdecap_8_1891 VDD VSS sg13cmos5l_decap_8
Xdecap_8_1892 VDD VSS sg13cmos5l_decap_8
Xdecap_8_1893 VDD VSS sg13cmos5l_decap_8
Xdecap_8_1894 VDD VSS sg13cmos5l_decap_8
Xdecap_8_1895 VDD VSS sg13cmos5l_decap_8
Xdecap_8_1896 VDD VSS sg13cmos5l_decap_8
Xdecap_8_1897 VDD VSS sg13cmos5l_decap_8
Xdecap_8_1898 VDD VSS sg13cmos5l_decap_8
Xdecap_8_1899 VDD VSS sg13cmos5l_decap_8
Xdecap_8_1900 VDD VSS sg13cmos5l_decap_8
Xdecap_8_1901 VDD VSS sg13cmos5l_decap_8
Xdecap_8_1902 VDD VSS sg13cmos5l_decap_8
Xdecap_8_1903 VDD VSS sg13cmos5l_decap_8
Xdecap_8_1904 VDD VSS sg13cmos5l_decap_8
Xdecap_8_1905 VDD VSS sg13cmos5l_decap_8
Xdecap_8_1906 VDD VSS sg13cmos5l_decap_8
Xdecap_8_1907 VDD VSS sg13cmos5l_decap_8
Xdecap_8_1908 VDD VSS sg13cmos5l_decap_8
Xdecap_8_1909 VDD VSS sg13cmos5l_decap_8
Xdecap_8_1910 VDD VSS sg13cmos5l_decap_8
Xdecap_8_1911 VDD VSS sg13cmos5l_decap_8
Xdecap_8_1912 VDD VSS sg13cmos5l_decap_8
Xdecap_8_1913 VDD VSS sg13cmos5l_decap_8
Xdecap_8_1914 VDD VSS sg13cmos5l_decap_8
Xdecap_8_1915 VDD VSS sg13cmos5l_decap_8
Xdecap_8_1916 VDD VSS sg13cmos5l_decap_8
Xdecap_8_1917 VDD VSS sg13cmos5l_decap_8
Xdecap_8_1918 VDD VSS sg13cmos5l_decap_8
Xdecap_8_1919 VDD VSS sg13cmos5l_decap_8
Xdecap_8_1920 VDD VSS sg13cmos5l_decap_8
Xdecap_8_1921 VDD VSS sg13cmos5l_decap_8
Xdecap_8_1922 VDD VSS sg13cmos5l_decap_8
Xdecap_8_1923 VDD VSS sg13cmos5l_decap_8
Xdecap_8_1924 VDD VSS sg13cmos5l_decap_8
Xdecap_8_1925 VDD VSS sg13cmos5l_decap_8
Xdecap_8_1926 VDD VSS sg13cmos5l_decap_8
Xdecap_8_1927 VDD VSS sg13cmos5l_decap_8
Xdecap_8_1928 VDD VSS sg13cmos5l_decap_8
Xdecap_8_1929 VDD VSS sg13cmos5l_decap_8
Xdecap_8_1930 VDD VSS sg13cmos5l_decap_8
Xdecap_8_1931 VDD VSS sg13cmos5l_decap_8
Xdecap_8_1932 VDD VSS sg13cmos5l_decap_8
Xdecap_8_1933 VDD VSS sg13cmos5l_decap_8
Xdecap_8_1934 VDD VSS sg13cmos5l_decap_8
Xdecap_8_1935 VDD VSS sg13cmos5l_decap_8
Xdecap_8_1936 VDD VSS sg13cmos5l_decap_8
Xdecap_8_1937 VDD VSS sg13cmos5l_decap_8
Xdecap_8_1938 VDD VSS sg13cmos5l_decap_8
Xdecap_8_1939 VDD VSS sg13cmos5l_decap_8
Xdecap_8_1940 VDD VSS sg13cmos5l_decap_8
Xdecap_8_1941 VDD VSS sg13cmos5l_decap_8
Xdecap_8_1942 VDD VSS sg13cmos5l_decap_8
Xdecap_8_1943 VDD VSS sg13cmos5l_decap_8
Xdecap_8_1944 VDD VSS sg13cmos5l_decap_8
Xdecap_8_1945 VDD VSS sg13cmos5l_decap_8
Xdecap_8_1946 VDD VSS sg13cmos5l_decap_8
Xdecap_8_1947 VDD VSS sg13cmos5l_decap_8
Xdecap_8_1948 VDD VSS sg13cmos5l_decap_8
Xdecap_8_1949 VDD VSS sg13cmos5l_decap_8
Xdecap_8_1950 VDD VSS sg13cmos5l_decap_8
Xdecap_8_1951 VDD VSS sg13cmos5l_decap_8
Xdecap_8_1952 VDD VSS sg13cmos5l_decap_8
Xdecap_8_1953 VDD VSS sg13cmos5l_decap_8
Xdecap_8_1954 VDD VSS sg13cmos5l_decap_8
Xdecap_8_1955 VDD VSS sg13cmos5l_decap_8
Xdecap_8_1956 VDD VSS sg13cmos5l_decap_8
Xdecap_8_1957 VDD VSS sg13cmos5l_decap_8
Xdecap_8_1958 VDD VSS sg13cmos5l_decap_8
Xdecap_8_1959 VDD VSS sg13cmos5l_decap_8
Xdecap_8_1960 VDD VSS sg13cmos5l_decap_8
Xdecap_8_1961 VDD VSS sg13cmos5l_decap_8
Xdecap_8_1962 VDD VSS sg13cmos5l_decap_8
Xdecap_8_1963 VDD VSS sg13cmos5l_decap_8
Xdecap_8_1964 VDD VSS sg13cmos5l_decap_8
Xdecap_8_1965 VDD VSS sg13cmos5l_decap_8
Xdecap_8_1966 VDD VSS sg13cmos5l_decap_8
Xdecap_8_1967 VDD VSS sg13cmos5l_decap_8
Xdecap_8_1968 VDD VSS sg13cmos5l_decap_8
Xdecap_8_1969 VDD VSS sg13cmos5l_decap_8
Xdecap_8_1970 VDD VSS sg13cmos5l_decap_8
Xdecap_8_1971 VDD VSS sg13cmos5l_decap_8
Xdecap_8_1972 VDD VSS sg13cmos5l_decap_8
Xdecap_8_1973 VDD VSS sg13cmos5l_decap_8
Xdecap_8_1974 VDD VSS sg13cmos5l_decap_8
Xdecap_8_1975 VDD VSS sg13cmos5l_decap_8
Xdecap_8_1976 VDD VSS sg13cmos5l_decap_8
Xdecap_8_1977 VDD VSS sg13cmos5l_decap_8
Xdecap_8_1978 VDD VSS sg13cmos5l_decap_8
Xdecap_8_1979 VDD VSS sg13cmos5l_decap_8
Xdecap_8_1980 VDD VSS sg13cmos5l_decap_8
Xdecap_8_1981 VDD VSS sg13cmos5l_decap_8
Xdecap_8_1982 VDD VSS sg13cmos5l_decap_8
Xdecap_8_1983 VDD VSS sg13cmos5l_decap_8
Xdecap_8_1984 VDD VSS sg13cmos5l_decap_8
Xdecap_8_1985 VDD VSS sg13cmos5l_decap_8
Xdecap_8_1986 VDD VSS sg13cmos5l_decap_8
Xdecap_8_1987 VDD VSS sg13cmos5l_decap_8
Xdecap_8_1988 VDD VSS sg13cmos5l_decap_8
Xdecap_8_1989 VDD VSS sg13cmos5l_decap_8
Xdecap_8_1990 VDD VSS sg13cmos5l_decap_8
Xdecap_8_1991 VDD VSS sg13cmos5l_decap_8
Xdecap_8_1992 VDD VSS sg13cmos5l_decap_8
Xdecap_8_1993 VDD VSS sg13cmos5l_decap_8
Xdecap_8_1994 VDD VSS sg13cmos5l_decap_8
Xdecap_8_1995 VDD VSS sg13cmos5l_decap_8
Xdecap_8_1996 VDD VSS sg13cmos5l_decap_8
Xdecap_8_1997 VDD VSS sg13cmos5l_decap_8
Xdecap_8_1998 VDD VSS sg13cmos5l_decap_8
Xdecap_8_1999 VDD VSS sg13cmos5l_decap_8
Xdecap_8_2000 VDD VSS sg13cmos5l_decap_8
Xdecap_8_2001 VDD VSS sg13cmos5l_decap_8
Xdecap_8_2002 VDD VSS sg13cmos5l_decap_8
Xdecap_8_2003 VDD VSS sg13cmos5l_decap_8
Xdecap_8_2004 VDD VSS sg13cmos5l_decap_8
Xdecap_8_2005 VDD VSS sg13cmos5l_decap_8
Xdecap_8_2006 VDD VSS sg13cmos5l_decap_8
Xdecap_8_2007 VDD VSS sg13cmos5l_decap_8
Xdecap_8_2008 VDD VSS sg13cmos5l_decap_8
Xdecap_8_2009 VDD VSS sg13cmos5l_decap_8
Xdecap_8_2010 VDD VSS sg13cmos5l_decap_8
Xdecap_8_2011 VDD VSS sg13cmos5l_decap_8
Xdecap_8_2012 VDD VSS sg13cmos5l_decap_8
Xdecap_8_2013 VDD VSS sg13cmos5l_decap_8
Xdecap_8_2014 VDD VSS sg13cmos5l_decap_8
Xdecap_8_2015 VDD VSS sg13cmos5l_decap_8
Xdecap_8_2016 VDD VSS sg13cmos5l_decap_8
Xdecap_8_2017 VDD VSS sg13cmos5l_decap_8
Xdecap_8_2018 VDD VSS sg13cmos5l_decap_8
Xdecap_8_2019 VDD VSS sg13cmos5l_decap_8
Xdecap_8_2020 VDD VSS sg13cmos5l_decap_8
Xdecap_8_2021 VDD VSS sg13cmos5l_decap_8
Xdecap_8_2022 VDD VSS sg13cmos5l_decap_8
Xdecap_8_2023 VDD VSS sg13cmos5l_decap_8
Xdecap_8_2024 VDD VSS sg13cmos5l_decap_8
Xdecap_8_2025 VDD VSS sg13cmos5l_decap_8
Xdecap_8_2026 VDD VSS sg13cmos5l_decap_8
Xdecap_8_2027 VDD VSS sg13cmos5l_decap_8
Xdecap_8_2028 VDD VSS sg13cmos5l_decap_8
Xdecap_8_2029 VDD VSS sg13cmos5l_decap_8
Xdecap_8_2030 VDD VSS sg13cmos5l_decap_8
Xdecap_8_2031 VDD VSS sg13cmos5l_decap_8
Xdecap_8_2032 VDD VSS sg13cmos5l_decap_8
Xdecap_8_2033 VDD VSS sg13cmos5l_decap_8
Xdecap_8_2034 VDD VSS sg13cmos5l_decap_8
Xdecap_8_2035 VDD VSS sg13cmos5l_decap_8
Xdecap_8_2036 VDD VSS sg13cmos5l_decap_8
Xdecap_8_2037 VDD VSS sg13cmos5l_decap_8
Xdecap_8_2038 VDD VSS sg13cmos5l_decap_8
Xdecap_8_2039 VDD VSS sg13cmos5l_decap_8
Xdecap_8_2040 VDD VSS sg13cmos5l_decap_8
Xdecap_8_2041 VDD VSS sg13cmos5l_decap_8
Xdecap_8_2042 VDD VSS sg13cmos5l_decap_8
Xdecap_8_2043 VDD VSS sg13cmos5l_decap_8
Xdecap_8_2044 VDD VSS sg13cmos5l_decap_8
Xdecap_8_2045 VDD VSS sg13cmos5l_decap_8
Xdecap_8_2046 VDD VSS sg13cmos5l_decap_8
Xdecap_8_2047 VDD VSS sg13cmos5l_decap_8
Xdecap_8_2048 VDD VSS sg13cmos5l_decap_8
Xdecap_8_2049 VDD VSS sg13cmos5l_decap_8
Xdecap_8_2050 VDD VSS sg13cmos5l_decap_8
Xdecap_8_2051 VDD VSS sg13cmos5l_decap_8
Xdecap_8_2052 VDD VSS sg13cmos5l_decap_8
Xdecap_8_2053 VDD VSS sg13cmos5l_decap_8
Xdecap_8_2054 VDD VSS sg13cmos5l_decap_8
Xdecap_8_2055 VDD VSS sg13cmos5l_decap_8
Xdecap_8_2056 VDD VSS sg13cmos5l_decap_8
Xdecap_8_2057 VDD VSS sg13cmos5l_decap_8
Xdecap_8_2058 VDD VSS sg13cmos5l_decap_8
Xdecap_8_2059 VDD VSS sg13cmos5l_decap_8
Xdecap_8_2060 VDD VSS sg13cmos5l_decap_8
Xdecap_8_2061 VDD VSS sg13cmos5l_decap_8
Xdecap_8_2062 VDD VSS sg13cmos5l_decap_8
Xdecap_8_2063 VDD VSS sg13cmos5l_decap_8
Xdecap_8_2064 VDD VSS sg13cmos5l_decap_8
Xdecap_8_2065 VDD VSS sg13cmos5l_decap_8
Xdecap_8_2066 VDD VSS sg13cmos5l_decap_8
Xdecap_8_2067 VDD VSS sg13cmos5l_decap_8
Xdecap_8_2068 VDD VSS sg13cmos5l_decap_8
Xdecap_8_2069 VDD VSS sg13cmos5l_decap_8
Xdecap_8_2070 VDD VSS sg13cmos5l_decap_8
Xdecap_8_2071 VDD VSS sg13cmos5l_decap_8
Xdecap_8_2072 VDD VSS sg13cmos5l_decap_8
Xdecap_8_2073 VDD VSS sg13cmos5l_decap_8
Xdecap_8_2074 VDD VSS sg13cmos5l_decap_8
Xdecap_8_2075 VDD VSS sg13cmos5l_decap_8
Xdecap_8_2076 VDD VSS sg13cmos5l_decap_8
Xdecap_8_2077 VDD VSS sg13cmos5l_decap_8
Xdecap_8_2078 VDD VSS sg13cmos5l_decap_8
Xdecap_8_2079 VDD VSS sg13cmos5l_decap_8
Xdecap_8_2080 VDD VSS sg13cmos5l_decap_8
Xdecap_8_2081 VDD VSS sg13cmos5l_decap_8
Xdecap_8_2082 VDD VSS sg13cmos5l_decap_8
Xdecap_8_2083 VDD VSS sg13cmos5l_decap_8
Xdecap_8_2084 VDD VSS sg13cmos5l_decap_8
Xdecap_8_2085 VDD VSS sg13cmos5l_decap_8
Xdecap_8_2086 VDD VSS sg13cmos5l_decap_8
Xdecap_8_2087 VDD VSS sg13cmos5l_decap_8
Xdecap_8_2088 VDD VSS sg13cmos5l_decap_8
Xdecap_8_2089 VDD VSS sg13cmos5l_decap_8
Xdecap_8_2090 VDD VSS sg13cmos5l_decap_8
Xdecap_8_2091 VDD VSS sg13cmos5l_decap_8
Xdecap_8_2092 VDD VSS sg13cmos5l_decap_8
Xdecap_8_2093 VDD VSS sg13cmos5l_decap_8
Xdecap_8_2094 VDD VSS sg13cmos5l_decap_8
Xdecap_8_2095 VDD VSS sg13cmos5l_decap_8
Xdecap_8_2096 VDD VSS sg13cmos5l_decap_8
Xdecap_8_2097 VDD VSS sg13cmos5l_decap_8
Xdecap_8_2098 VDD VSS sg13cmos5l_decap_8
Xdecap_8_2099 VDD VSS sg13cmos5l_decap_8
Xdecap_8_2100 VDD VSS sg13cmos5l_decap_8
Xdecap_8_2101 VDD VSS sg13cmos5l_decap_8
Xdecap_8_2102 VDD VSS sg13cmos5l_decap_8
Xdecap_8_2103 VDD VSS sg13cmos5l_decap_8
Xdecap_8_2104 VDD VSS sg13cmos5l_decap_8
Xdecap_8_2105 VDD VSS sg13cmos5l_decap_8
Xdecap_8_2106 VDD VSS sg13cmos5l_decap_8
Xdecap_8_2107 VDD VSS sg13cmos5l_decap_8
Xdecap_8_2108 VDD VSS sg13cmos5l_decap_8
Xdecap_8_2109 VDD VSS sg13cmos5l_decap_8
Xdecap_8_2110 VDD VSS sg13cmos5l_decap_8
Xdecap_8_2111 VDD VSS sg13cmos5l_decap_8
Xdecap_8_2112 VDD VSS sg13cmos5l_decap_8
Xdecap_8_2113 VDD VSS sg13cmos5l_decap_8
Xdecap_8_2114 VDD VSS sg13cmos5l_decap_8
Xdecap_8_2115 VDD VSS sg13cmos5l_decap_8
Xdecap_8_2116 VDD VSS sg13cmos5l_decap_8
Xdecap_8_2117 VDD VSS sg13cmos5l_decap_8
Xdecap_8_2118 VDD VSS sg13cmos5l_decap_8
Xdecap_8_2119 VDD VSS sg13cmos5l_decap_8
Xdecap_8_2120 VDD VSS sg13cmos5l_decap_8
Xdecap_8_2121 VDD VSS sg13cmos5l_decap_8
Xdecap_8_2122 VDD VSS sg13cmos5l_decap_8
Xdecap_8_2123 VDD VSS sg13cmos5l_decap_8
Xdecap_8_2124 VDD VSS sg13cmos5l_decap_8
Xdecap_8_2125 VDD VSS sg13cmos5l_decap_8
Xdecap_8_2126 VDD VSS sg13cmos5l_decap_8
Xdecap_8_2127 VDD VSS sg13cmos5l_decap_8
Xdecap_8_2128 VDD VSS sg13cmos5l_decap_8
Xdecap_8_2129 VDD VSS sg13cmos5l_decap_8
Xdecap_8_2130 VDD VSS sg13cmos5l_decap_8
Xdecap_8_2131 VDD VSS sg13cmos5l_decap_8
Xdecap_8_2132 VDD VSS sg13cmos5l_decap_8
Xdecap_8_2133 VDD VSS sg13cmos5l_decap_8
Xdecap_8_2134 VDD VSS sg13cmos5l_decap_8
Xdecap_8_2135 VDD VSS sg13cmos5l_decap_8
Xdecap_8_2136 VDD VSS sg13cmos5l_decap_8
Xdecap_8_2137 VDD VSS sg13cmos5l_decap_8
Xdecap_8_2138 VDD VSS sg13cmos5l_decap_8
Xdecap_8_2139 VDD VSS sg13cmos5l_decap_8
Xdecap_8_2140 VDD VSS sg13cmos5l_decap_8
Xdecap_8_2141 VDD VSS sg13cmos5l_decap_8
Xdecap_8_2142 VDD VSS sg13cmos5l_decap_8
Xdecap_8_2143 VDD VSS sg13cmos5l_decap_8
Xdecap_8_2144 VDD VSS sg13cmos5l_decap_8
Xdecap_8_2145 VDD VSS sg13cmos5l_decap_8
Xdecap_8_2146 VDD VSS sg13cmos5l_decap_8
Xdecap_8_2147 VDD VSS sg13cmos5l_decap_8
Xdecap_8_2148 VDD VSS sg13cmos5l_decap_8
Xdecap_8_2149 VDD VSS sg13cmos5l_decap_8
Xdecap_8_2150 VDD VSS sg13cmos5l_decap_8
Xdecap_8_2151 VDD VSS sg13cmos5l_decap_8
Xdecap_8_2152 VDD VSS sg13cmos5l_decap_8
Xdecap_8_2153 VDD VSS sg13cmos5l_decap_8
Xdecap_8_2154 VDD VSS sg13cmos5l_decap_8
Xdecap_8_2155 VDD VSS sg13cmos5l_decap_8
Xdecap_8_2156 VDD VSS sg13cmos5l_decap_8
Xdecap_8_2157 VDD VSS sg13cmos5l_decap_8
Xdecap_8_2158 VDD VSS sg13cmos5l_decap_8
Xdecap_8_2159 VDD VSS sg13cmos5l_decap_8
Xdecap_8_2160 VDD VSS sg13cmos5l_decap_8
Xdecap_8_2161 VDD VSS sg13cmos5l_decap_8
Xdecap_8_2162 VDD VSS sg13cmos5l_decap_8
Xdecap_8_2163 VDD VSS sg13cmos5l_decap_8
Xdecap_8_2164 VDD VSS sg13cmos5l_decap_8
Xdecap_8_2165 VDD VSS sg13cmos5l_decap_8
Xdecap_8_2166 VDD VSS sg13cmos5l_decap_8
Xdecap_8_2167 VDD VSS sg13cmos5l_decap_8
Xdecap_8_2168 VDD VSS sg13cmos5l_decap_8
Xdecap_8_2169 VDD VSS sg13cmos5l_decap_8
Xdecap_8_2170 VDD VSS sg13cmos5l_decap_8
Xdecap_8_2171 VDD VSS sg13cmos5l_decap_8
Xdecap_8_2172 VDD VSS sg13cmos5l_decap_8
Xdecap_8_2173 VDD VSS sg13cmos5l_decap_8
Xdecap_8_2174 VDD VSS sg13cmos5l_decap_8
Xdecap_8_2175 VDD VSS sg13cmos5l_decap_8
Xdecap_8_2176 VDD VSS sg13cmos5l_decap_8
Xdecap_8_2177 VDD VSS sg13cmos5l_decap_8
Xdecap_8_2178 VDD VSS sg13cmos5l_decap_8
Xdecap_8_2179 VDD VSS sg13cmos5l_decap_8
Xdecap_8_2180 VDD VSS sg13cmos5l_decap_8
Xdecap_8_2181 VDD VSS sg13cmos5l_decap_8
Xdecap_8_2182 VDD VSS sg13cmos5l_decap_8
Xdecap_8_2183 VDD VSS sg13cmos5l_decap_8
Xdecap_8_2184 VDD VSS sg13cmos5l_decap_8
Xdecap_8_2185 VDD VSS sg13cmos5l_decap_8
Xdecap_8_2186 VDD VSS sg13cmos5l_decap_8
Xdecap_8_2187 VDD VSS sg13cmos5l_decap_8
Xdecap_8_2188 VDD VSS sg13cmos5l_decap_8
Xdecap_8_2189 VDD VSS sg13cmos5l_decap_8
Xdecap_8_2190 VDD VSS sg13cmos5l_decap_8
Xdecap_8_2191 VDD VSS sg13cmos5l_decap_8
Xdecap_8_2192 VDD VSS sg13cmos5l_decap_8
Xdecap_8_2193 VDD VSS sg13cmos5l_decap_8
Xdecap_8_2194 VDD VSS sg13cmos5l_decap_8
Xdecap_8_2195 VDD VSS sg13cmos5l_decap_8
Xdecap_8_2196 VDD VSS sg13cmos5l_decap_8
Xdecap_8_2197 VDD VSS sg13cmos5l_decap_8
Xdecap_8_2198 VDD VSS sg13cmos5l_decap_8
Xdecap_8_2199 VDD VSS sg13cmos5l_decap_8
Xdecap_8_2200 VDD VSS sg13cmos5l_decap_8
Xdecap_8_2201 VDD VSS sg13cmos5l_decap_8
Xdecap_8_2202 VDD VSS sg13cmos5l_decap_8
Xdecap_8_2203 VDD VSS sg13cmos5l_decap_8
Xdecap_8_2204 VDD VSS sg13cmos5l_decap_8
Xdecap_8_2205 VDD VSS sg13cmos5l_decap_8
Xdecap_8_2206 VDD VSS sg13cmos5l_decap_8
Xdecap_8_2207 VDD VSS sg13cmos5l_decap_8
Xdecap_8_2208 VDD VSS sg13cmos5l_decap_8
Xdecap_8_2209 VDD VSS sg13cmos5l_decap_8
Xdecap_8_2210 VDD VSS sg13cmos5l_decap_8
Xdecap_8_2211 VDD VSS sg13cmos5l_decap_8
Xdecap_8_2212 VDD VSS sg13cmos5l_decap_8
Xdecap_8_2213 VDD VSS sg13cmos5l_decap_8
Xdecap_8_2214 VDD VSS sg13cmos5l_decap_8
Xdecap_8_2215 VDD VSS sg13cmos5l_decap_8
Xdecap_8_2216 VDD VSS sg13cmos5l_decap_8
Xdecap_8_2217 VDD VSS sg13cmos5l_decap_8
Xdecap_8_2218 VDD VSS sg13cmos5l_decap_8
Xdecap_8_2219 VDD VSS sg13cmos5l_decap_8
Xdecap_8_2220 VDD VSS sg13cmos5l_decap_8
Xdecap_8_2221 VDD VSS sg13cmos5l_decap_8
Xdecap_8_2222 VDD VSS sg13cmos5l_decap_8
Xdecap_8_2223 VDD VSS sg13cmos5l_decap_8
Xdecap_8_2224 VDD VSS sg13cmos5l_decap_8
Xdecap_8_2225 VDD VSS sg13cmos5l_decap_8
Xdecap_8_2226 VDD VSS sg13cmos5l_decap_8
Xdecap_8_2227 VDD VSS sg13cmos5l_decap_8
Xdecap_8_2228 VDD VSS sg13cmos5l_decap_8
Xdecap_8_2229 VDD VSS sg13cmos5l_decap_8
Xdecap_8_2230 VDD VSS sg13cmos5l_decap_8
Xdecap_8_2231 VDD VSS sg13cmos5l_decap_8
Xdecap_8_2232 VDD VSS sg13cmos5l_decap_8
Xdecap_8_2233 VDD VSS sg13cmos5l_decap_8
Xdecap_8_2234 VDD VSS sg13cmos5l_decap_8
Xdecap_8_2235 VDD VSS sg13cmos5l_decap_8
Xdecap_8_2236 VDD VSS sg13cmos5l_decap_8
Xdecap_8_2237 VDD VSS sg13cmos5l_decap_8
Xdecap_8_2238 VDD VSS sg13cmos5l_decap_8
Xdecap_8_2239 VDD VSS sg13cmos5l_decap_8
Xdecap_8_2240 VDD VSS sg13cmos5l_decap_8
Xdecap_8_2241 VDD VSS sg13cmos5l_decap_8
Xdecap_8_2242 VDD VSS sg13cmos5l_decap_8
Xdecap_8_2243 VDD VSS sg13cmos5l_decap_8
Xdecap_8_2244 VDD VSS sg13cmos5l_decap_8
Xdecap_8_2245 VDD VSS sg13cmos5l_decap_8
Xdecap_8_2246 VDD VSS sg13cmos5l_decap_8
Xdecap_8_2247 VDD VSS sg13cmos5l_decap_8
Xdecap_8_2248 VDD VSS sg13cmos5l_decap_8
Xdecap_8_2249 VDD VSS sg13cmos5l_decap_8
Xdecap_8_2250 VDD VSS sg13cmos5l_decap_8
Xdecap_8_2251 VDD VSS sg13cmos5l_decap_8
Xdecap_8_2252 VDD VSS sg13cmos5l_decap_8
Xdecap_8_2253 VDD VSS sg13cmos5l_decap_8
Xdecap_8_2254 VDD VSS sg13cmos5l_decap_8
Xdecap_8_2255 VDD VSS sg13cmos5l_decap_8
Xdecap_8_2256 VDD VSS sg13cmos5l_decap_8
Xdecap_8_2257 VDD VSS sg13cmos5l_decap_8
Xdecap_8_2258 VDD VSS sg13cmos5l_decap_8
Xdecap_8_2259 VDD VSS sg13cmos5l_decap_8
Xdecap_8_2260 VDD VSS sg13cmos5l_decap_8
Xdecap_8_2261 VDD VSS sg13cmos5l_decap_8
Xdecap_8_2262 VDD VSS sg13cmos5l_decap_8
Xdecap_8_2263 VDD VSS sg13cmos5l_decap_8
Xdecap_8_2264 VDD VSS sg13cmos5l_decap_8
Xdecap_8_2265 VDD VSS sg13cmos5l_decap_8
Xdecap_8_2266 VDD VSS sg13cmos5l_decap_8
Xdecap_8_2267 VDD VSS sg13cmos5l_decap_8
Xdecap_8_2268 VDD VSS sg13cmos5l_decap_8
Xdecap_8_2269 VDD VSS sg13cmos5l_decap_8
Xdecap_8_2270 VDD VSS sg13cmos5l_decap_8
Xdecap_8_2271 VDD VSS sg13cmos5l_decap_8
Xdecap_8_2272 VDD VSS sg13cmos5l_decap_8
Xdecap_8_2273 VDD VSS sg13cmos5l_decap_8
Xdecap_8_2274 VDD VSS sg13cmos5l_decap_8
Xdecap_8_2275 VDD VSS sg13cmos5l_decap_8
Xdecap_8_2276 VDD VSS sg13cmos5l_decap_8
Xdecap_8_2277 VDD VSS sg13cmos5l_decap_8
Xdecap_8_2278 VDD VSS sg13cmos5l_decap_8
Xdecap_8_2279 VDD VSS sg13cmos5l_decap_8
Xdecap_8_2280 VDD VSS sg13cmos5l_decap_8
Xdecap_8_2281 VDD VSS sg13cmos5l_decap_8
Xdecap_8_2282 VDD VSS sg13cmos5l_decap_8
Xdecap_8_2283 VDD VSS sg13cmos5l_decap_8
Xdecap_8_2284 VDD VSS sg13cmos5l_decap_8
Xdecap_8_2285 VDD VSS sg13cmos5l_decap_8
Xdecap_8_2286 VDD VSS sg13cmos5l_decap_8
Xdecap_8_2287 VDD VSS sg13cmos5l_decap_8
Xdecap_8_2288 VDD VSS sg13cmos5l_decap_8
Xdecap_8_2289 VDD VSS sg13cmos5l_decap_8
Xdecap_8_2290 VDD VSS sg13cmos5l_decap_8
Xdecap_8_2291 VDD VSS sg13cmos5l_decap_8
Xdecap_8_2292 VDD VSS sg13cmos5l_decap_8
Xdecap_8_2293 VDD VSS sg13cmos5l_decap_8
Xdecap_8_2294 VDD VSS sg13cmos5l_decap_8
Xdecap_8_2295 VDD VSS sg13cmos5l_decap_8
Xdecap_8_2296 VDD VSS sg13cmos5l_decap_8
Xdecap_8_2297 VDD VSS sg13cmos5l_decap_8
Xdecap_8_2298 VDD VSS sg13cmos5l_decap_8
Xdecap_8_2299 VDD VSS sg13cmos5l_decap_8
Xdecap_8_2300 VDD VSS sg13cmos5l_decap_8
Xdecap_8_2301 VDD VSS sg13cmos5l_decap_8
Xdecap_8_2302 VDD VSS sg13cmos5l_decap_8
Xdecap_8_2303 VDD VSS sg13cmos5l_decap_8
Xdecap_8_2304 VDD VSS sg13cmos5l_decap_8
Xdecap_8_2305 VDD VSS sg13cmos5l_decap_8
Xdecap_8_2306 VDD VSS sg13cmos5l_decap_8
Xdecap_8_2307 VDD VSS sg13cmos5l_decap_8
Xdecap_8_2308 VDD VSS sg13cmos5l_decap_8
Xdecap_8_2309 VDD VSS sg13cmos5l_decap_8
Xdecap_8_2310 VDD VSS sg13cmos5l_decap_8
Xdecap_8_2311 VDD VSS sg13cmos5l_decap_8
Xdecap_8_2312 VDD VSS sg13cmos5l_decap_8
Xdecap_8_2313 VDD VSS sg13cmos5l_decap_8
Xdecap_8_2314 VDD VSS sg13cmos5l_decap_8
Xdecap_8_2315 VDD VSS sg13cmos5l_decap_8
Xdecap_8_2316 VDD VSS sg13cmos5l_decap_8
Xdecap_8_2317 VDD VSS sg13cmos5l_decap_8
Xdecap_8_2318 VDD VSS sg13cmos5l_decap_8
Xdecap_8_2319 VDD VSS sg13cmos5l_decap_8
Xdecap_8_2320 VDD VSS sg13cmos5l_decap_8
Xdecap_8_2321 VDD VSS sg13cmos5l_decap_8
Xdecap_8_2322 VDD VSS sg13cmos5l_decap_8
Xdecap_8_2323 VDD VSS sg13cmos5l_decap_8
Xdecap_8_2324 VDD VSS sg13cmos5l_decap_8
Xdecap_8_2325 VDD VSS sg13cmos5l_decap_8
Xdecap_8_2326 VDD VSS sg13cmos5l_decap_8
Xdecap_8_2327 VDD VSS sg13cmos5l_decap_8
Xdecap_8_2328 VDD VSS sg13cmos5l_decap_8
Xdecap_8_2329 VDD VSS sg13cmos5l_decap_8
Xdecap_8_2330 VDD VSS sg13cmos5l_decap_8
Xdecap_8_2331 VDD VSS sg13cmos5l_decap_8
Xdecap_8_2332 VDD VSS sg13cmos5l_decap_8
Xdecap_8_2333 VDD VSS sg13cmos5l_decap_8
Xdecap_8_2334 VDD VSS sg13cmos5l_decap_8
Xdecap_8_2335 VDD VSS sg13cmos5l_decap_8
Xdecap_8_2336 VDD VSS sg13cmos5l_decap_8
Xdecap_8_2337 VDD VSS sg13cmos5l_decap_8
Xdecap_8_2338 VDD VSS sg13cmos5l_decap_8
Xdecap_8_2339 VDD VSS sg13cmos5l_decap_8
Xdecap_8_2340 VDD VSS sg13cmos5l_decap_8
Xdecap_8_2341 VDD VSS sg13cmos5l_decap_8
Xdecap_8_2342 VDD VSS sg13cmos5l_decap_8
Xdecap_8_2343 VDD VSS sg13cmos5l_decap_8
Xdecap_8_2344 VDD VSS sg13cmos5l_decap_8
Xdecap_8_2345 VDD VSS sg13cmos5l_decap_8
Xdecap_8_2346 VDD VSS sg13cmos5l_decap_8
Xdecap_8_2347 VDD VSS sg13cmos5l_decap_8
Xdecap_8_2348 VDD VSS sg13cmos5l_decap_8
Xdecap_8_2349 VDD VSS sg13cmos5l_decap_8
Xdecap_8_2350 VDD VSS sg13cmos5l_decap_8
Xdecap_8_2351 VDD VSS sg13cmos5l_decap_8
Xdecap_8_2352 VDD VSS sg13cmos5l_decap_8
Xdecap_8_2353 VDD VSS sg13cmos5l_decap_8
Xdecap_8_2354 VDD VSS sg13cmos5l_decap_8
Xdecap_8_2355 VDD VSS sg13cmos5l_decap_8
Xdecap_8_2356 VDD VSS sg13cmos5l_decap_8
Xdecap_8_2357 VDD VSS sg13cmos5l_decap_8
Xdecap_8_2358 VDD VSS sg13cmos5l_decap_8
Xdecap_8_2359 VDD VSS sg13cmos5l_decap_8
Xdecap_8_2360 VDD VSS sg13cmos5l_decap_8
Xdecap_8_2361 VDD VSS sg13cmos5l_decap_8
Xdecap_8_2362 VDD VSS sg13cmos5l_decap_8
Xdecap_8_2363 VDD VSS sg13cmos5l_decap_8
Xdecap_8_2364 VDD VSS sg13cmos5l_decap_8
Xdecap_8_2365 VDD VSS sg13cmos5l_decap_8
Xdecap_8_2366 VDD VSS sg13cmos5l_decap_8
Xdecap_8_2367 VDD VSS sg13cmos5l_decap_8
Xdecap_8_2368 VDD VSS sg13cmos5l_decap_8
Xdecap_8_2369 VDD VSS sg13cmos5l_decap_8
Xdecap_8_2370 VDD VSS sg13cmos5l_decap_8
Xdecap_8_2371 VDD VSS sg13cmos5l_decap_8
Xdecap_8_2372 VDD VSS sg13cmos5l_decap_8
Xdecap_8_2373 VDD VSS sg13cmos5l_decap_8
Xdecap_8_2374 VDD VSS sg13cmos5l_decap_8
Xdecap_8_2375 VDD VSS sg13cmos5l_decap_8
Xdecap_8_2376 VDD VSS sg13cmos5l_decap_8
Xdecap_8_2377 VDD VSS sg13cmos5l_decap_8
Xdecap_8_2378 VDD VSS sg13cmos5l_decap_8
Xdecap_8_2379 VDD VSS sg13cmos5l_decap_8
Xdecap_8_2380 VDD VSS sg13cmos5l_decap_8
Xdecap_8_2381 VDD VSS sg13cmos5l_decap_8
Xdecap_8_2382 VDD VSS sg13cmos5l_decap_8
Xdecap_8_2383 VDD VSS sg13cmos5l_decap_8
Xdecap_8_2384 VDD VSS sg13cmos5l_decap_8
Xdecap_8_2385 VDD VSS sg13cmos5l_decap_8
Xdecap_8_2386 VDD VSS sg13cmos5l_decap_8
Xdecap_8_2387 VDD VSS sg13cmos5l_decap_8
Xdecap_8_2388 VDD VSS sg13cmos5l_decap_8
Xdecap_8_2389 VDD VSS sg13cmos5l_decap_8
Xdecap_8_2390 VDD VSS sg13cmos5l_decap_8
Xdecap_8_2391 VDD VSS sg13cmos5l_decap_8
Xdecap_8_2392 VDD VSS sg13cmos5l_decap_8
Xdecap_8_2393 VDD VSS sg13cmos5l_decap_8
Xdecap_8_2394 VDD VSS sg13cmos5l_decap_8
Xdecap_8_2395 VDD VSS sg13cmos5l_decap_8
Xdecap_8_2396 VDD VSS sg13cmos5l_decap_8
Xdecap_8_2397 VDD VSS sg13cmos5l_decap_8
Xdecap_8_2398 VDD VSS sg13cmos5l_decap_8
Xdecap_8_2399 VDD VSS sg13cmos5l_decap_8
Xdecap_8_2400 VDD VSS sg13cmos5l_decap_8
Xdecap_8_2401 VDD VSS sg13cmos5l_decap_8
Xdecap_8_2402 VDD VSS sg13cmos5l_decap_8
Xdecap_8_2403 VDD VSS sg13cmos5l_decap_8
Xdecap_8_2404 VDD VSS sg13cmos5l_decap_8
Xdecap_8_2405 VDD VSS sg13cmos5l_decap_8
Xdecap_8_2406 VDD VSS sg13cmos5l_decap_8
Xdecap_8_2407 VDD VSS sg13cmos5l_decap_8
Xdecap_8_2408 VDD VSS sg13cmos5l_decap_8
Xdecap_8_2409 VDD VSS sg13cmos5l_decap_8
Xdecap_8_2410 VDD VSS sg13cmos5l_decap_8
Xdecap_8_2411 VDD VSS sg13cmos5l_decap_8
Xdecap_8_2412 VDD VSS sg13cmos5l_decap_8
Xdecap_8_2413 VDD VSS sg13cmos5l_decap_8
Xdecap_8_2414 VDD VSS sg13cmos5l_decap_8
Xdecap_8_2415 VDD VSS sg13cmos5l_decap_8
Xdecap_8_2416 VDD VSS sg13cmos5l_decap_8
Xdecap_8_2417 VDD VSS sg13cmos5l_decap_8
Xdecap_8_2418 VDD VSS sg13cmos5l_decap_8
Xdecap_8_2419 VDD VSS sg13cmos5l_decap_8
Xdecap_8_2420 VDD VSS sg13cmos5l_decap_8
Xdecap_8_2421 VDD VSS sg13cmos5l_decap_8
Xdecap_8_2422 VDD VSS sg13cmos5l_decap_8
Xdecap_8_2423 VDD VSS sg13cmos5l_decap_8
Xdecap_8_2424 VDD VSS sg13cmos5l_decap_8
Xdecap_8_2425 VDD VSS sg13cmos5l_decap_8
Xdecap_8_2426 VDD VSS sg13cmos5l_decap_8
Xdecap_8_2427 VDD VSS sg13cmos5l_decap_8
Xdecap_8_2428 VDD VSS sg13cmos5l_decap_8
Xdecap_8_2429 VDD VSS sg13cmos5l_decap_8
Xdecap_8_2430 VDD VSS sg13cmos5l_decap_8
Xdecap_8_2431 VDD VSS sg13cmos5l_decap_8
Xdecap_8_2432 VDD VSS sg13cmos5l_decap_8
Xdecap_8_2433 VDD VSS sg13cmos5l_decap_8
Xdecap_8_2434 VDD VSS sg13cmos5l_decap_8
Xdecap_8_2435 VDD VSS sg13cmos5l_decap_8
Xdecap_8_2436 VDD VSS sg13cmos5l_decap_8
Xdecap_8_2437 VDD VSS sg13cmos5l_decap_8
Xdecap_8_2438 VDD VSS sg13cmos5l_decap_8
Xdecap_8_2439 VDD VSS sg13cmos5l_decap_8
Xdecap_8_2440 VDD VSS sg13cmos5l_decap_8
Xdecap_8_2441 VDD VSS sg13cmos5l_decap_8
Xdecap_8_2442 VDD VSS sg13cmos5l_decap_8
Xdecap_8_2443 VDD VSS sg13cmos5l_decap_8
Xdecap_8_2444 VDD VSS sg13cmos5l_decap_8
Xdecap_8_2445 VDD VSS sg13cmos5l_decap_8
Xdecap_8_2446 VDD VSS sg13cmos5l_decap_8
Xdecap_8_2447 VDD VSS sg13cmos5l_decap_8
Xdecap_8_2448 VDD VSS sg13cmos5l_decap_8
Xdecap_8_2449 VDD VSS sg13cmos5l_decap_8
Xdecap_8_2450 VDD VSS sg13cmos5l_decap_8
Xdecap_8_2451 VDD VSS sg13cmos5l_decap_8
Xdecap_8_2452 VDD VSS sg13cmos5l_decap_8
Xdecap_8_2453 VDD VSS sg13cmos5l_decap_8
Xdecap_8_2454 VDD VSS sg13cmos5l_decap_8
Xdecap_8_2455 VDD VSS sg13cmos5l_decap_8
Xdecap_8_2456 VDD VSS sg13cmos5l_decap_8
Xdecap_8_2457 VDD VSS sg13cmos5l_decap_8
Xdecap_8_2458 VDD VSS sg13cmos5l_decap_8
Xdecap_8_2459 VDD VSS sg13cmos5l_decap_8
Xdecap_8_2460 VDD VSS sg13cmos5l_decap_8
Xdecap_8_2461 VDD VSS sg13cmos5l_decap_8
Xdecap_8_2462 VDD VSS sg13cmos5l_decap_8
Xdecap_8_2463 VDD VSS sg13cmos5l_decap_8
Xdecap_8_2464 VDD VSS sg13cmos5l_decap_8
Xdecap_8_2465 VDD VSS sg13cmos5l_decap_8
Xdecap_8_2466 VDD VSS sg13cmos5l_decap_8
Xdecap_8_2467 VDD VSS sg13cmos5l_decap_8
Xdecap_8_2468 VDD VSS sg13cmos5l_decap_8
Xdecap_8_2469 VDD VSS sg13cmos5l_decap_8
Xdecap_8_2470 VDD VSS sg13cmos5l_decap_8
Xdecap_8_2471 VDD VSS sg13cmos5l_decap_8
Xdecap_8_2472 VDD VSS sg13cmos5l_decap_8
Xdecap_8_2473 VDD VSS sg13cmos5l_decap_8
Xdecap_8_2474 VDD VSS sg13cmos5l_decap_8
Xdecap_8_2475 VDD VSS sg13cmos5l_decap_8
Xdecap_8_2476 VDD VSS sg13cmos5l_decap_8
Xdecap_8_2477 VDD VSS sg13cmos5l_decap_8
Xdecap_8_2478 VDD VSS sg13cmos5l_decap_8
Xdecap_8_2479 VDD VSS sg13cmos5l_decap_8
Xdecap_8_2480 VDD VSS sg13cmos5l_decap_8
Xdecap_8_2481 VDD VSS sg13cmos5l_decap_8
Xdecap_8_2482 VDD VSS sg13cmos5l_decap_8
Xdecap_8_2483 VDD VSS sg13cmos5l_decap_8
Xdecap_8_2484 VDD VSS sg13cmos5l_decap_8
Xdecap_8_2485 VDD VSS sg13cmos5l_decap_8
Xdecap_8_2486 VDD VSS sg13cmos5l_decap_8
Xdecap_8_2487 VDD VSS sg13cmos5l_decap_8
Xdecap_8_2488 VDD VSS sg13cmos5l_decap_8
Xdecap_8_2489 VDD VSS sg13cmos5l_decap_8
Xdecap_8_2490 VDD VSS sg13cmos5l_decap_8
Xdecap_8_2491 VDD VSS sg13cmos5l_decap_8
Xdecap_8_2492 VDD VSS sg13cmos5l_decap_8
Xdecap_8_2493 VDD VSS sg13cmos5l_decap_8
Xdecap_8_2494 VDD VSS sg13cmos5l_decap_8
Xdecap_8_2495 VDD VSS sg13cmos5l_decap_8
Xdecap_8_2496 VDD VSS sg13cmos5l_decap_8
Xdecap_8_2497 VDD VSS sg13cmos5l_decap_8
Xdecap_8_2498 VDD VSS sg13cmos5l_decap_8
Xdecap_8_2499 VDD VSS sg13cmos5l_decap_8
Xdecap_8_2500 VDD VSS sg13cmos5l_decap_8
Xdecap_8_2501 VDD VSS sg13cmos5l_decap_8
Xdecap_8_2502 VDD VSS sg13cmos5l_decap_8
Xdecap_8_2503 VDD VSS sg13cmos5l_decap_8
Xdecap_8_2504 VDD VSS sg13cmos5l_decap_8
Xdecap_8_2505 VDD VSS sg13cmos5l_decap_8
Xdecap_8_2506 VDD VSS sg13cmos5l_decap_8
Xdecap_8_2507 VDD VSS sg13cmos5l_decap_8
Xdecap_8_2508 VDD VSS sg13cmos5l_decap_8
Xdecap_8_2509 VDD VSS sg13cmos5l_decap_8
Xdecap_8_2510 VDD VSS sg13cmos5l_decap_8
Xdecap_8_2511 VDD VSS sg13cmos5l_decap_8
Xdecap_8_2512 VDD VSS sg13cmos5l_decap_8
Xdecap_8_2513 VDD VSS sg13cmos5l_decap_8
Xdecap_8_2514 VDD VSS sg13cmos5l_decap_8
Xdecap_8_2515 VDD VSS sg13cmos5l_decap_8
Xdecap_8_2516 VDD VSS sg13cmos5l_decap_8
Xdecap_8_2517 VDD VSS sg13cmos5l_decap_8
Xdecap_8_2518 VDD VSS sg13cmos5l_decap_8
Xdecap_8_2519 VDD VSS sg13cmos5l_decap_8
Xdecap_8_2520 VDD VSS sg13cmos5l_decap_8
Xdecap_8_2521 VDD VSS sg13cmos5l_decap_8
Xdecap_8_2522 VDD VSS sg13cmos5l_decap_8
Xdecap_8_2523 VDD VSS sg13cmos5l_decap_8
Xdecap_8_2524 VDD VSS sg13cmos5l_decap_8
Xdecap_8_2525 VDD VSS sg13cmos5l_decap_8
Xdecap_8_2526 VDD VSS sg13cmos5l_decap_8
Xdecap_8_2527 VDD VSS sg13cmos5l_decap_8
Xdecap_8_2528 VDD VSS sg13cmos5l_decap_8
Xdecap_8_2529 VDD VSS sg13cmos5l_decap_8
Xdecap_8_2530 VDD VSS sg13cmos5l_decap_8
Xdecap_8_2531 VDD VSS sg13cmos5l_decap_8
Xdecap_8_2532 VDD VSS sg13cmos5l_decap_8
Xdecap_8_2533 VDD VSS sg13cmos5l_decap_8
Xdecap_8_2534 VDD VSS sg13cmos5l_decap_8
Xdecap_8_2535 VDD VSS sg13cmos5l_decap_8
Xdecap_8_2536 VDD VSS sg13cmos5l_decap_8
Xdecap_8_2537 VDD VSS sg13cmos5l_decap_8
Xdecap_8_2538 VDD VSS sg13cmos5l_decap_8
Xdecap_8_2539 VDD VSS sg13cmos5l_decap_8
Xdecap_8_2540 VDD VSS sg13cmos5l_decap_8
Xdecap_8_2541 VDD VSS sg13cmos5l_decap_8
Xdecap_8_2542 VDD VSS sg13cmos5l_decap_8
Xdecap_8_2543 VDD VSS sg13cmos5l_decap_8
Xdecap_8_2544 VDD VSS sg13cmos5l_decap_8
Xdecap_8_2545 VDD VSS sg13cmos5l_decap_8
Xdecap_8_2546 VDD VSS sg13cmos5l_decap_8
Xdecap_8_2547 VDD VSS sg13cmos5l_decap_8
Xdecap_8_2548 VDD VSS sg13cmos5l_decap_8
Xdecap_8_2549 VDD VSS sg13cmos5l_decap_8
Xdecap_8_2550 VDD VSS sg13cmos5l_decap_8
Xdecap_8_2551 VDD VSS sg13cmos5l_decap_8
Xdecap_8_2552 VDD VSS sg13cmos5l_decap_8
Xdecap_8_2553 VDD VSS sg13cmos5l_decap_8
Xdecap_8_2554 VDD VSS sg13cmos5l_decap_8
Xdecap_8_2555 VDD VSS sg13cmos5l_decap_8
Xdecap_8_2556 VDD VSS sg13cmos5l_decap_8
Xdecap_8_2557 VDD VSS sg13cmos5l_decap_8
Xdecap_8_2558 VDD VSS sg13cmos5l_decap_8
Xdecap_8_2559 VDD VSS sg13cmos5l_decap_8
Xdecap_8_2560 VDD VSS sg13cmos5l_decap_8
Xdecap_8_2561 VDD VSS sg13cmos5l_decap_8
Xdecap_8_2562 VDD VSS sg13cmos5l_decap_8
Xdecap_8_2563 VDD VSS sg13cmos5l_decap_8
Xdecap_8_2564 VDD VSS sg13cmos5l_decap_8
Xdecap_8_2565 VDD VSS sg13cmos5l_decap_8
Xdecap_8_2566 VDD VSS sg13cmos5l_decap_8
Xdecap_8_2567 VDD VSS sg13cmos5l_decap_8
Xdecap_8_2568 VDD VSS sg13cmos5l_decap_8
Xdecap_8_2569 VDD VSS sg13cmos5l_decap_8
Xdecap_8_2570 VDD VSS sg13cmos5l_decap_8
Xdecap_8_2571 VDD VSS sg13cmos5l_decap_8
Xdecap_8_2572 VDD VSS sg13cmos5l_decap_8
Xdecap_8_2573 VDD VSS sg13cmos5l_decap_8
Xdecap_8_2574 VDD VSS sg13cmos5l_decap_8
Xdecap_8_2575 VDD VSS sg13cmos5l_decap_8
Xdecap_8_2576 VDD VSS sg13cmos5l_decap_8
Xdecap_8_2577 VDD VSS sg13cmos5l_decap_8
Xdecap_8_2578 VDD VSS sg13cmos5l_decap_8
Xdecap_8_2579 VDD VSS sg13cmos5l_decap_8
Xdecap_8_2580 VDD VSS sg13cmos5l_decap_8
Xdecap_8_2581 VDD VSS sg13cmos5l_decap_8
Xdecap_8_2582 VDD VSS sg13cmos5l_decap_8
Xdecap_8_2583 VDD VSS sg13cmos5l_decap_8
Xdecap_8_2584 VDD VSS sg13cmos5l_decap_8
Xdecap_8_2585 VDD VSS sg13cmos5l_decap_8
Xdecap_8_2586 VDD VSS sg13cmos5l_decap_8
Xdecap_8_2587 VDD VSS sg13cmos5l_decap_8
Xdecap_8_2588 VDD VSS sg13cmos5l_decap_8
Xdecap_8_2589 VDD VSS sg13cmos5l_decap_8
Xdecap_8_2590 VDD VSS sg13cmos5l_decap_8
Xdecap_8_2591 VDD VSS sg13cmos5l_decap_8
Xdecap_8_2592 VDD VSS sg13cmos5l_decap_8
Xdecap_8_2593 VDD VSS sg13cmos5l_decap_8
Xdecap_8_2594 VDD VSS sg13cmos5l_decap_8
Xdecap_8_2595 VDD VSS sg13cmos5l_decap_8
Xdecap_8_2596 VDD VSS sg13cmos5l_decap_8
Xdecap_8_2597 VDD VSS sg13cmos5l_decap_8
Xdecap_8_2598 VDD VSS sg13cmos5l_decap_8
Xdecap_8_2599 VDD VSS sg13cmos5l_decap_8
Xdecap_8_2600 VDD VSS sg13cmos5l_decap_8
Xdecap_8_2601 VDD VSS sg13cmos5l_decap_8
Xdecap_8_2602 VDD VSS sg13cmos5l_decap_8
Xdecap_8_2603 VDD VSS sg13cmos5l_decap_8
Xdecap_8_2604 VDD VSS sg13cmos5l_decap_8
Xdecap_8_2605 VDD VSS sg13cmos5l_decap_8
Xdecap_8_2606 VDD VSS sg13cmos5l_decap_8
Xdecap_8_2607 VDD VSS sg13cmos5l_decap_8
Xdecap_8_2608 VDD VSS sg13cmos5l_decap_8
Xdecap_8_2609 VDD VSS sg13cmos5l_decap_8
Xdecap_8_2610 VDD VSS sg13cmos5l_decap_8
Xdecap_8_2611 VDD VSS sg13cmos5l_decap_8
Xdecap_8_2612 VDD VSS sg13cmos5l_decap_8
Xdecap_8_2613 VDD VSS sg13cmos5l_decap_8
Xdecap_8_2614 VDD VSS sg13cmos5l_decap_8
Xdecap_8_2615 VDD VSS sg13cmos5l_decap_8
Xdecap_8_2616 VDD VSS sg13cmos5l_decap_8
Xdecap_8_2617 VDD VSS sg13cmos5l_decap_8
Xdecap_8_2618 VDD VSS sg13cmos5l_decap_8
Xdecap_8_2619 VDD VSS sg13cmos5l_decap_8
Xdecap_8_2620 VDD VSS sg13cmos5l_decap_8
Xdecap_8_2621 VDD VSS sg13cmos5l_decap_8
Xdecap_8_2622 VDD VSS sg13cmos5l_decap_8
Xdecap_8_2623 VDD VSS sg13cmos5l_decap_8
Xdecap_8_2624 VDD VSS sg13cmos5l_decap_8
Xdecap_8_2625 VDD VSS sg13cmos5l_decap_8
Xdecap_8_2626 VDD VSS sg13cmos5l_decap_8
Xdecap_8_2627 VDD VSS sg13cmos5l_decap_8
Xdecap_8_2628 VDD VSS sg13cmos5l_decap_8
Xdecap_8_2629 VDD VSS sg13cmos5l_decap_8
Xdecap_8_2630 VDD VSS sg13cmos5l_decap_8
Xdecap_8_2631 VDD VSS sg13cmos5l_decap_8
Xdecap_8_2632 VDD VSS sg13cmos5l_decap_8
Xdecap_8_2633 VDD VSS sg13cmos5l_decap_8
Xdecap_8_2634 VDD VSS sg13cmos5l_decap_8
Xdecap_8_2635 VDD VSS sg13cmos5l_decap_8
Xdecap_8_2636 VDD VSS sg13cmos5l_decap_8
Xdecap_8_2637 VDD VSS sg13cmos5l_decap_8
Xdecap_8_2638 VDD VSS sg13cmos5l_decap_8
Xdecap_8_2639 VDD VSS sg13cmos5l_decap_8
Xdecap_8_2640 VDD VSS sg13cmos5l_decap_8
Xdecap_8_2641 VDD VSS sg13cmos5l_decap_8
Xdecap_8_2642 VDD VSS sg13cmos5l_decap_8
Xdecap_8_2643 VDD VSS sg13cmos5l_decap_8
Xdecap_8_2644 VDD VSS sg13cmos5l_decap_8
Xdecap_8_2645 VDD VSS sg13cmos5l_decap_8
Xdecap_8_2646 VDD VSS sg13cmos5l_decap_8
Xdecap_8_2647 VDD VSS sg13cmos5l_decap_8
Xdecap_8_2648 VDD VSS sg13cmos5l_decap_8
Xdecap_8_2649 VDD VSS sg13cmos5l_decap_8
Xdecap_8_2650 VDD VSS sg13cmos5l_decap_8
Xdecap_8_2651 VDD VSS sg13cmos5l_decap_8
Xdecap_8_2652 VDD VSS sg13cmos5l_decap_8
Xdecap_8_2653 VDD VSS sg13cmos5l_decap_8
Xdecap_8_2654 VDD VSS sg13cmos5l_decap_8
Xdecap_8_2655 VDD VSS sg13cmos5l_decap_8
Xdecap_8_2656 VDD VSS sg13cmos5l_decap_8
Xdecap_8_2657 VDD VSS sg13cmos5l_decap_8
Xdecap_8_2658 VDD VSS sg13cmos5l_decap_8
Xdecap_8_2659 VDD VSS sg13cmos5l_decap_8
Xdecap_8_2660 VDD VSS sg13cmos5l_decap_8
Xdecap_8_2661 VDD VSS sg13cmos5l_decap_8
Xdecap_8_2662 VDD VSS sg13cmos5l_decap_8
Xdecap_8_2663 VDD VSS sg13cmos5l_decap_8
Xdecap_8_2664 VDD VSS sg13cmos5l_decap_8
Xdecap_8_2665 VDD VSS sg13cmos5l_decap_8
Xdecap_8_2666 VDD VSS sg13cmos5l_decap_8
Xdecap_8_2667 VDD VSS sg13cmos5l_decap_8
Xdecap_8_2668 VDD VSS sg13cmos5l_decap_8
Xdecap_8_2669 VDD VSS sg13cmos5l_decap_8
Xdecap_8_2670 VDD VSS sg13cmos5l_decap_8
Xdecap_8_2671 VDD VSS sg13cmos5l_decap_8
Xdecap_8_2672 VDD VSS sg13cmos5l_decap_8
Xdecap_8_2673 VDD VSS sg13cmos5l_decap_8
Xdecap_8_2674 VDD VSS sg13cmos5l_decap_8
Xdecap_8_2675 VDD VSS sg13cmos5l_decap_8
Xdecap_8_2676 VDD VSS sg13cmos5l_decap_8
Xdecap_8_2677 VDD VSS sg13cmos5l_decap_8
Xdecap_8_2678 VDD VSS sg13cmos5l_decap_8
Xdecap_8_2679 VDD VSS sg13cmos5l_decap_8
Xdecap_8_2680 VDD VSS sg13cmos5l_decap_8
Xdecap_8_2681 VDD VSS sg13cmos5l_decap_8
Xdecap_8_2682 VDD VSS sg13cmos5l_decap_8
Xdecap_8_2683 VDD VSS sg13cmos5l_decap_8
Xdecap_8_2684 VDD VSS sg13cmos5l_decap_8
Xdecap_8_2685 VDD VSS sg13cmos5l_decap_8
Xdecap_8_2686 VDD VSS sg13cmos5l_decap_8
Xdecap_8_2687 VDD VSS sg13cmos5l_decap_8
Xdecap_8_2688 VDD VSS sg13cmos5l_decap_8
Xdecap_8_2689 VDD VSS sg13cmos5l_decap_8
Xdecap_8_2690 VDD VSS sg13cmos5l_decap_8
Xdecap_8_2691 VDD VSS sg13cmos5l_decap_8
Xdecap_8_2692 VDD VSS sg13cmos5l_decap_8
Xdecap_8_2693 VDD VSS sg13cmos5l_decap_8
Xdecap_8_2694 VDD VSS sg13cmos5l_decap_8
Xdecap_8_2695 VDD VSS sg13cmos5l_decap_8
Xdecap_8_2696 VDD VSS sg13cmos5l_decap_8
Xdecap_8_2697 VDD VSS sg13cmos5l_decap_8
Xdecap_8_2698 VDD VSS sg13cmos5l_decap_8
Xdecap_8_2699 VDD VSS sg13cmos5l_decap_8
Xdecap_8_2700 VDD VSS sg13cmos5l_decap_8
Xdecap_8_2701 VDD VSS sg13cmos5l_decap_8
Xdecap_8_2702 VDD VSS sg13cmos5l_decap_8
Xdecap_8_2703 VDD VSS sg13cmos5l_decap_8
Xdecap_8_2704 VDD VSS sg13cmos5l_decap_8
Xdecap_8_2705 VDD VSS sg13cmos5l_decap_8
Xdecap_8_2706 VDD VSS sg13cmos5l_decap_8
Xdecap_8_2707 VDD VSS sg13cmos5l_decap_8
Xdecap_8_2708 VDD VSS sg13cmos5l_decap_8
Xdecap_8_2709 VDD VSS sg13cmos5l_decap_8
Xdecap_8_2710 VDD VSS sg13cmos5l_decap_8
Xdecap_8_2711 VDD VSS sg13cmos5l_decap_8
Xdecap_8_2712 VDD VSS sg13cmos5l_decap_8
Xdecap_8_2713 VDD VSS sg13cmos5l_decap_8
Xdecap_8_2714 VDD VSS sg13cmos5l_decap_8
Xdecap_8_2715 VDD VSS sg13cmos5l_decap_8
Xdecap_8_2716 VDD VSS sg13cmos5l_decap_8
Xdecap_8_2717 VDD VSS sg13cmos5l_decap_8
Xdecap_8_2718 VDD VSS sg13cmos5l_decap_8
Xdecap_8_2719 VDD VSS sg13cmos5l_decap_8
Xdecap_8_2720 VDD VSS sg13cmos5l_decap_8
Xdecap_8_2721 VDD VSS sg13cmos5l_decap_8
Xdecap_8_2722 VDD VSS sg13cmos5l_decap_8
Xdecap_8_2723 VDD VSS sg13cmos5l_decap_8
Xdecap_8_2724 VDD VSS sg13cmos5l_decap_8
Xdecap_8_2725 VDD VSS sg13cmos5l_decap_8
Xdecap_8_2726 VDD VSS sg13cmos5l_decap_8
Xdecap_8_2727 VDD VSS sg13cmos5l_decap_8
Xdecap_8_2728 VDD VSS sg13cmos5l_decap_8
Xdecap_8_2729 VDD VSS sg13cmos5l_decap_8
Xdecap_8_2730 VDD VSS sg13cmos5l_decap_8
Xdecap_8_2731 VDD VSS sg13cmos5l_decap_8
Xdecap_8_2732 VDD VSS sg13cmos5l_decap_8
Xdecap_8_2733 VDD VSS sg13cmos5l_decap_8
Xdecap_8_2734 VDD VSS sg13cmos5l_decap_8
Xdecap_8_2735 VDD VSS sg13cmos5l_decap_8
Xdecap_8_2736 VDD VSS sg13cmos5l_decap_8
Xdecap_8_2737 VDD VSS sg13cmos5l_decap_8
Xdecap_8_2738 VDD VSS sg13cmos5l_decap_8
Xdecap_8_2739 VDD VSS sg13cmos5l_decap_8
Xdecap_8_2740 VDD VSS sg13cmos5l_decap_8
Xdecap_8_2741 VDD VSS sg13cmos5l_decap_8
Xdecap_8_2742 VDD VSS sg13cmos5l_decap_8
Xdecap_8_2743 VDD VSS sg13cmos5l_decap_8
Xdecap_8_2744 VDD VSS sg13cmos5l_decap_8
Xdecap_8_2745 VDD VSS sg13cmos5l_decap_8
Xdecap_8_2746 VDD VSS sg13cmos5l_decap_8
Xdecap_8_2747 VDD VSS sg13cmos5l_decap_8
Xdecap_8_2748 VDD VSS sg13cmos5l_decap_8
Xdecap_8_2749 VDD VSS sg13cmos5l_decap_8
Xdecap_8_2750 VDD VSS sg13cmos5l_decap_8
Xdecap_8_2751 VDD VSS sg13cmos5l_decap_8
Xdecap_8_2752 VDD VSS sg13cmos5l_decap_8
Xdecap_8_2753 VDD VSS sg13cmos5l_decap_8
Xdecap_8_2754 VDD VSS sg13cmos5l_decap_8
Xdecap_8_2755 VDD VSS sg13cmos5l_decap_8
Xdecap_8_2756 VDD VSS sg13cmos5l_decap_8
Xdecap_8_2757 VDD VSS sg13cmos5l_decap_8
Xdecap_8_2758 VDD VSS sg13cmos5l_decap_8
Xdecap_8_2759 VDD VSS sg13cmos5l_decap_8
Xdecap_8_2760 VDD VSS sg13cmos5l_decap_8
Xdecap_8_2761 VDD VSS sg13cmos5l_decap_8
Xdecap_8_2762 VDD VSS sg13cmos5l_decap_8
Xdecap_8_2763 VDD VSS sg13cmos5l_decap_8
Xdecap_8_2764 VDD VSS sg13cmos5l_decap_8
Xdecap_8_2765 VDD VSS sg13cmos5l_decap_8
Xdecap_8_2766 VDD VSS sg13cmos5l_decap_8
Xdecap_8_2767 VDD VSS sg13cmos5l_decap_8
Xdecap_8_2768 VDD VSS sg13cmos5l_decap_8
Xdecap_8_2769 VDD VSS sg13cmos5l_decap_8
Xdecap_8_2770 VDD VSS sg13cmos5l_decap_8
Xdecap_8_2771 VDD VSS sg13cmos5l_decap_8
Xdecap_8_2772 VDD VSS sg13cmos5l_decap_8
Xdecap_8_2773 VDD VSS sg13cmos5l_decap_8
Xdecap_8_2774 VDD VSS sg13cmos5l_decap_8
Xdecap_8_2775 VDD VSS sg13cmos5l_decap_8
Xdecap_8_2776 VDD VSS sg13cmos5l_decap_8
Xdecap_8_2777 VDD VSS sg13cmos5l_decap_8
Xdecap_8_2778 VDD VSS sg13cmos5l_decap_8
Xdecap_8_2779 VDD VSS sg13cmos5l_decap_8
Xdecap_8_2780 VDD VSS sg13cmos5l_decap_8
Xdecap_8_2781 VDD VSS sg13cmos5l_decap_8
Xdecap_8_2782 VDD VSS sg13cmos5l_decap_8
Xdecap_8_2783 VDD VSS sg13cmos5l_decap_8
Xdecap_8_2784 VDD VSS sg13cmos5l_decap_8
Xdecap_8_2785 VDD VSS sg13cmos5l_decap_8
Xdecap_8_2786 VDD VSS sg13cmos5l_decap_8
Xdecap_8_2787 VDD VSS sg13cmos5l_decap_8
Xdecap_8_2788 VDD VSS sg13cmos5l_decap_8
Xdecap_8_2789 VDD VSS sg13cmos5l_decap_8
Xdecap_8_2790 VDD VSS sg13cmos5l_decap_8
Xdecap_8_2791 VDD VSS sg13cmos5l_decap_8
Xdecap_8_2792 VDD VSS sg13cmos5l_decap_8
Xdecap_8_2793 VDD VSS sg13cmos5l_decap_8
Xdecap_8_2794 VDD VSS sg13cmos5l_decap_8
Xdecap_8_2795 VDD VSS sg13cmos5l_decap_8
Xdecap_8_2796 VDD VSS sg13cmos5l_decap_8
Xdecap_8_2797 VDD VSS sg13cmos5l_decap_8
Xdecap_8_2798 VDD VSS sg13cmos5l_decap_8
Xdecap_8_2799 VDD VSS sg13cmos5l_decap_8
Xdecap_8_2800 VDD VSS sg13cmos5l_decap_8
Xdecap_8_2801 VDD VSS sg13cmos5l_decap_8
Xdecap_8_2802 VDD VSS sg13cmos5l_decap_8
Xdecap_8_2803 VDD VSS sg13cmos5l_decap_8
Xdecap_8_2804 VDD VSS sg13cmos5l_decap_8
Xdecap_8_2805 VDD VSS sg13cmos5l_decap_8
Xdecap_8_2806 VDD VSS sg13cmos5l_decap_8
Xdecap_8_2807 VDD VSS sg13cmos5l_decap_8
Xdecap_8_2808 VDD VSS sg13cmos5l_decap_8
Xdecap_8_2809 VDD VSS sg13cmos5l_decap_8
Xdecap_8_2810 VDD VSS sg13cmos5l_decap_8
Xdecap_8_2811 VDD VSS sg13cmos5l_decap_8
Xdecap_8_2812 VDD VSS sg13cmos5l_decap_8
Xdecap_8_2813 VDD VSS sg13cmos5l_decap_8
Xdecap_8_2814 VDD VSS sg13cmos5l_decap_8
Xdecap_8_2815 VDD VSS sg13cmos5l_decap_8
Xdecap_8_2816 VDD VSS sg13cmos5l_decap_8
Xdecap_8_2817 VDD VSS sg13cmos5l_decap_8
Xdecap_8_2818 VDD VSS sg13cmos5l_decap_8
Xdecap_8_2819 VDD VSS sg13cmos5l_decap_8
Xdecap_8_2820 VDD VSS sg13cmos5l_decap_8
Xdecap_8_2821 VDD VSS sg13cmos5l_decap_8
Xdecap_8_2822 VDD VSS sg13cmos5l_decap_8
Xdecap_8_2823 VDD VSS sg13cmos5l_decap_8
Xdecap_8_2824 VDD VSS sg13cmos5l_decap_8
Xdecap_8_2825 VDD VSS sg13cmos5l_decap_8
Xdecap_8_2826 VDD VSS sg13cmos5l_decap_8
Xdecap_8_2827 VDD VSS sg13cmos5l_decap_8
Xdecap_8_2828 VDD VSS sg13cmos5l_decap_8
Xdecap_8_2829 VDD VSS sg13cmos5l_decap_8
Xdecap_8_2830 VDD VSS sg13cmos5l_decap_8
Xdecap_8_2831 VDD VSS sg13cmos5l_decap_8
Xdecap_8_2832 VDD VSS sg13cmos5l_decap_8
Xdecap_8_2833 VDD VSS sg13cmos5l_decap_8
Xdecap_8_2834 VDD VSS sg13cmos5l_decap_8
Xdecap_8_2835 VDD VSS sg13cmos5l_decap_8
Xdecap_8_2836 VDD VSS sg13cmos5l_decap_8
Xdecap_8_2837 VDD VSS sg13cmos5l_decap_8
Xdecap_8_2838 VDD VSS sg13cmos5l_decap_8
Xdecap_8_2839 VDD VSS sg13cmos5l_decap_8
Xdecap_8_2840 VDD VSS sg13cmos5l_decap_8
Xdecap_8_2841 VDD VSS sg13cmos5l_decap_8
Xdecap_8_2842 VDD VSS sg13cmos5l_decap_8
Xdecap_8_2843 VDD VSS sg13cmos5l_decap_8
Xdecap_8_2844 VDD VSS sg13cmos5l_decap_8
Xdecap_8_2845 VDD VSS sg13cmos5l_decap_8
Xdecap_8_2846 VDD VSS sg13cmos5l_decap_8
Xdecap_8_2847 VDD VSS sg13cmos5l_decap_8
Xdecap_8_2848 VDD VSS sg13cmos5l_decap_8
Xdecap_8_2849 VDD VSS sg13cmos5l_decap_8
Xdecap_8_2850 VDD VSS sg13cmos5l_decap_8
Xdecap_8_2851 VDD VSS sg13cmos5l_decap_8
Xdecap_8_2852 VDD VSS sg13cmos5l_decap_8
Xdecap_8_2853 VDD VSS sg13cmos5l_decap_8
Xdecap_8_2854 VDD VSS sg13cmos5l_decap_8
Xdecap_8_2855 VDD VSS sg13cmos5l_decap_8
Xdecap_8_2856 VDD VSS sg13cmos5l_decap_8
Xdecap_8_2857 VDD VSS sg13cmos5l_decap_8
Xdecap_8_2858 VDD VSS sg13cmos5l_decap_8
Xdecap_8_2859 VDD VSS sg13cmos5l_decap_8
Xdecap_8_2860 VDD VSS sg13cmos5l_decap_8
Xdecap_8_2861 VDD VSS sg13cmos5l_decap_8
Xdecap_8_2862 VDD VSS sg13cmos5l_decap_8
Xdecap_8_2863 VDD VSS sg13cmos5l_decap_8
Xdecap_8_2864 VDD VSS sg13cmos5l_decap_8
Xdecap_8_2865 VDD VSS sg13cmos5l_decap_8
Xdecap_8_2866 VDD VSS sg13cmos5l_decap_8
Xdecap_8_2867 VDD VSS sg13cmos5l_decap_8
Xdecap_8_2868 VDD VSS sg13cmos5l_decap_8
Xdecap_8_2869 VDD VSS sg13cmos5l_decap_8
Xdecap_8_2870 VDD VSS sg13cmos5l_decap_8
Xdecap_8_2871 VDD VSS sg13cmos5l_decap_8
Xdecap_8_2872 VDD VSS sg13cmos5l_decap_8
Xdecap_8_2873 VDD VSS sg13cmos5l_decap_8
Xdecap_8_2874 VDD VSS sg13cmos5l_decap_8
Xdecap_8_2875 VDD VSS sg13cmos5l_decap_8
Xdecap_8_2876 VDD VSS sg13cmos5l_decap_8
Xdecap_8_2877 VDD VSS sg13cmos5l_decap_8
Xdecap_8_2878 VDD VSS sg13cmos5l_decap_8
Xdecap_8_2879 VDD VSS sg13cmos5l_decap_8
Xdecap_8_2880 VDD VSS sg13cmos5l_decap_8
Xdecap_8_2881 VDD VSS sg13cmos5l_decap_8
Xdecap_8_2882 VDD VSS sg13cmos5l_decap_8
Xdecap_8_2883 VDD VSS sg13cmos5l_decap_8
Xdecap_8_2884 VDD VSS sg13cmos5l_decap_8
Xdecap_8_2885 VDD VSS sg13cmos5l_decap_8
Xdecap_8_2886 VDD VSS sg13cmos5l_decap_8
Xdecap_8_2887 VDD VSS sg13cmos5l_decap_8
Xdecap_8_2888 VDD VSS sg13cmos5l_decap_8
Xdecap_8_2889 VDD VSS sg13cmos5l_decap_8
Xdecap_8_2890 VDD VSS sg13cmos5l_decap_8
Xdecap_8_2891 VDD VSS sg13cmos5l_decap_8
Xdecap_8_2892 VDD VSS sg13cmos5l_decap_8
Xdecap_8_2893 VDD VSS sg13cmos5l_decap_8
Xdecap_8_2894 VDD VSS sg13cmos5l_decap_8
Xdecap_8_2895 VDD VSS sg13cmos5l_decap_8
Xdecap_8_2896 VDD VSS sg13cmos5l_decap_8
Xdecap_8_2897 VDD VSS sg13cmos5l_decap_8
Xdecap_8_2898 VDD VSS sg13cmos5l_decap_8
Xdecap_8_2899 VDD VSS sg13cmos5l_decap_8
Xdecap_8_2900 VDD VSS sg13cmos5l_decap_8
Xdecap_8_2901 VDD VSS sg13cmos5l_decap_8
Xdecap_8_2902 VDD VSS sg13cmos5l_decap_8
Xdecap_8_2903 VDD VSS sg13cmos5l_decap_8
Xdecap_8_2904 VDD VSS sg13cmos5l_decap_8
Xdecap_8_2905 VDD VSS sg13cmos5l_decap_8
Xdecap_8_2906 VDD VSS sg13cmos5l_decap_8
Xdecap_8_2907 VDD VSS sg13cmos5l_decap_8
Xdecap_8_2908 VDD VSS sg13cmos5l_decap_8
Xdecap_8_2909 VDD VSS sg13cmos5l_decap_8
Xdecap_8_2910 VDD VSS sg13cmos5l_decap_8
Xdecap_8_2911 VDD VSS sg13cmos5l_decap_8
Xdecap_8_2912 VDD VSS sg13cmos5l_decap_8
Xdecap_8_2913 VDD VSS sg13cmos5l_decap_8
Xdecap_8_2914 VDD VSS sg13cmos5l_decap_8
Xdecap_8_2915 VDD VSS sg13cmos5l_decap_8
Xdecap_8_2916 VDD VSS sg13cmos5l_decap_8
Xdecap_8_2917 VDD VSS sg13cmos5l_decap_8
Xdecap_8_2918 VDD VSS sg13cmos5l_decap_8
Xdecap_8_2919 VDD VSS sg13cmos5l_decap_8
Xdecap_8_2920 VDD VSS sg13cmos5l_decap_8
Xdecap_8_2921 VDD VSS sg13cmos5l_decap_8
Xdecap_8_2922 VDD VSS sg13cmos5l_decap_8
Xdecap_8_2923 VDD VSS sg13cmos5l_decap_8
Xdecap_8_2924 VDD VSS sg13cmos5l_decap_8
Xdecap_8_2925 VDD VSS sg13cmos5l_decap_8
Xdecap_8_2926 VDD VSS sg13cmos5l_decap_8
Xdecap_8_2927 VDD VSS sg13cmos5l_decap_8
Xdecap_8_2928 VDD VSS sg13cmos5l_decap_8
Xdecap_8_2929 VDD VSS sg13cmos5l_decap_8
Xdecap_8_2930 VDD VSS sg13cmos5l_decap_8
Xdecap_8_2931 VDD VSS sg13cmos5l_decap_8
Xdecap_8_2932 VDD VSS sg13cmos5l_decap_8
Xdecap_8_2933 VDD VSS sg13cmos5l_decap_8
Xdecap_8_2934 VDD VSS sg13cmos5l_decap_8
Xdecap_8_2935 VDD VSS sg13cmos5l_decap_8
Xdecap_8_2936 VDD VSS sg13cmos5l_decap_8
Xdecap_8_2937 VDD VSS sg13cmos5l_decap_8
Xdecap_8_2938 VDD VSS sg13cmos5l_decap_8
Xdecap_8_2939 VDD VSS sg13cmos5l_decap_8
Xdecap_8_2940 VDD VSS sg13cmos5l_decap_8
Xdecap_8_2941 VDD VSS sg13cmos5l_decap_8
Xdecap_8_2942 VDD VSS sg13cmos5l_decap_8
Xdecap_8_2943 VDD VSS sg13cmos5l_decap_8
Xdecap_8_2944 VDD VSS sg13cmos5l_decap_8
Xdecap_8_2945 VDD VSS sg13cmos5l_decap_8
Xdecap_8_2946 VDD VSS sg13cmos5l_decap_8
Xdecap_8_2947 VDD VSS sg13cmos5l_decap_8
Xdecap_8_2948 VDD VSS sg13cmos5l_decap_8
Xdecap_8_2949 VDD VSS sg13cmos5l_decap_8
Xdecap_8_2950 VDD VSS sg13cmos5l_decap_8
Xdecap_8_2951 VDD VSS sg13cmos5l_decap_8
Xdecap_8_2952 VDD VSS sg13cmos5l_decap_8
Xdecap_8_2953 VDD VSS sg13cmos5l_decap_8
Xdecap_8_2954 VDD VSS sg13cmos5l_decap_8
Xdecap_8_2955 VDD VSS sg13cmos5l_decap_8
Xdecap_8_2956 VDD VSS sg13cmos5l_decap_8
Xdecap_8_2957 VDD VSS sg13cmos5l_decap_8
Xdecap_8_2958 VDD VSS sg13cmos5l_decap_8
Xdecap_8_2959 VDD VSS sg13cmos5l_decap_8
Xdecap_8_2960 VDD VSS sg13cmos5l_decap_8
Xdecap_8_2961 VDD VSS sg13cmos5l_decap_8
Xdecap_8_2962 VDD VSS sg13cmos5l_decap_8
Xdecap_8_2963 VDD VSS sg13cmos5l_decap_8
Xdecap_8_2964 VDD VSS sg13cmos5l_decap_8
Xdecap_8_2965 VDD VSS sg13cmos5l_decap_8
Xdecap_8_2966 VDD VSS sg13cmos5l_decap_8
Xdecap_8_2967 VDD VSS sg13cmos5l_decap_8
Xdecap_8_2968 VDD VSS sg13cmos5l_decap_8
Xdecap_8_2969 VDD VSS sg13cmos5l_decap_8
Xdecap_8_2970 VDD VSS sg13cmos5l_decap_8
Xdecap_8_2971 VDD VSS sg13cmos5l_decap_8
Xdecap_8_2972 VDD VSS sg13cmos5l_decap_8
Xdecap_8_2973 VDD VSS sg13cmos5l_decap_8
Xdecap_8_2974 VDD VSS sg13cmos5l_decap_8
Xdecap_8_2975 VDD VSS sg13cmos5l_decap_8
Xdecap_8_2976 VDD VSS sg13cmos5l_decap_8
Xdecap_8_2977 VDD VSS sg13cmos5l_decap_8
Xdecap_8_2978 VDD VSS sg13cmos5l_decap_8
Xdecap_8_2979 VDD VSS sg13cmos5l_decap_8
Xdecap_8_2980 VDD VSS sg13cmos5l_decap_8
Xdecap_8_2981 VDD VSS sg13cmos5l_decap_8
Xdecap_8_2982 VDD VSS sg13cmos5l_decap_8
Xdecap_8_2983 VDD VSS sg13cmos5l_decap_8
Xdecap_8_2984 VDD VSS sg13cmos5l_decap_8
Xdecap_8_2985 VDD VSS sg13cmos5l_decap_8
Xdecap_8_2986 VDD VSS sg13cmos5l_decap_8
Xdecap_8_2987 VDD VSS sg13cmos5l_decap_8
Xdecap_8_2988 VDD VSS sg13cmos5l_decap_8
Xdecap_8_2989 VDD VSS sg13cmos5l_decap_8
Xdecap_8_2990 VDD VSS sg13cmos5l_decap_8
Xdecap_8_2991 VDD VSS sg13cmos5l_decap_8
Xdecap_8_2992 VDD VSS sg13cmos5l_decap_8
Xdecap_8_2993 VDD VSS sg13cmos5l_decap_8
Xdecap_8_2994 VDD VSS sg13cmos5l_decap_8
Xdecap_8_2995 VDD VSS sg13cmos5l_decap_8
Xdecap_8_2996 VDD VSS sg13cmos5l_decap_8
Xdecap_8_2997 VDD VSS sg13cmos5l_decap_8
Xdecap_8_2998 VDD VSS sg13cmos5l_decap_8
Xdecap_8_2999 VDD VSS sg13cmos5l_decap_8
Xdecap_8_3000 VDD VSS sg13cmos5l_decap_8
Xdecap_8_3001 VDD VSS sg13cmos5l_decap_8
Xdecap_8_3002 VDD VSS sg13cmos5l_decap_8
Xdecap_8_3003 VDD VSS sg13cmos5l_decap_8
Xdecap_8_3004 VDD VSS sg13cmos5l_decap_8
Xdecap_8_3005 VDD VSS sg13cmos5l_decap_8
Xdecap_8_3006 VDD VSS sg13cmos5l_decap_8
Xdecap_8_3007 VDD VSS sg13cmos5l_decap_8
Xdecap_8_3008 VDD VSS sg13cmos5l_decap_8
Xdecap_8_3009 VDD VSS sg13cmos5l_decap_8
Xdecap_8_3010 VDD VSS sg13cmos5l_decap_8
Xdecap_8_3011 VDD VSS sg13cmos5l_decap_8
Xdecap_8_3012 VDD VSS sg13cmos5l_decap_8
Xdecap_8_3013 VDD VSS sg13cmos5l_decap_8
Xdecap_8_3014 VDD VSS sg13cmos5l_decap_8
Xdecap_8_3015 VDD VSS sg13cmos5l_decap_8
Xdecap_8_3016 VDD VSS sg13cmos5l_decap_8
Xdecap_8_3017 VDD VSS sg13cmos5l_decap_8
Xdecap_8_3018 VDD VSS sg13cmos5l_decap_8
Xdecap_8_3019 VDD VSS sg13cmos5l_decap_8
Xdecap_8_3020 VDD VSS sg13cmos5l_decap_8
Xdecap_8_3021 VDD VSS sg13cmos5l_decap_8
Xdecap_8_3022 VDD VSS sg13cmos5l_decap_8
Xdecap_8_3023 VDD VSS sg13cmos5l_decap_8
Xdecap_8_3024 VDD VSS sg13cmos5l_decap_8
Xdecap_8_3025 VDD VSS sg13cmos5l_decap_8
Xdecap_8_3026 VDD VSS sg13cmos5l_decap_8
Xdecap_8_3027 VDD VSS sg13cmos5l_decap_8
Xdecap_8_3028 VDD VSS sg13cmos5l_decap_8
Xdecap_8_3029 VDD VSS sg13cmos5l_decap_8
Xdecap_8_3030 VDD VSS sg13cmos5l_decap_8
Xdecap_8_3031 VDD VSS sg13cmos5l_decap_8
Xdecap_8_3032 VDD VSS sg13cmos5l_decap_8
Xdecap_8_3033 VDD VSS sg13cmos5l_decap_8
Xdecap_8_3034 VDD VSS sg13cmos5l_decap_8
Xdecap_8_3035 VDD VSS sg13cmos5l_decap_8
Xdecap_8_3036 VDD VSS sg13cmos5l_decap_8
Xdecap_8_3037 VDD VSS sg13cmos5l_decap_8
Xdecap_8_3038 VDD VSS sg13cmos5l_decap_8
Xdecap_8_3039 VDD VSS sg13cmos5l_decap_8
Xdecap_8_3040 VDD VSS sg13cmos5l_decap_8
Xdecap_8_3041 VDD VSS sg13cmos5l_decap_8
Xdecap_8_3042 VDD VSS sg13cmos5l_decap_8
Xdecap_8_3043 VDD VSS sg13cmos5l_decap_8
Xdecap_8_3044 VDD VSS sg13cmos5l_decap_8
Xdecap_8_3045 VDD VSS sg13cmos5l_decap_8
Xdecap_8_3046 VDD VSS sg13cmos5l_decap_8
Xdecap_8_3047 VDD VSS sg13cmos5l_decap_8
Xdecap_8_3048 VDD VSS sg13cmos5l_decap_8
Xdecap_8_3049 VDD VSS sg13cmos5l_decap_8
Xdecap_8_3050 VDD VSS sg13cmos5l_decap_8
Xdecap_8_3051 VDD VSS sg13cmos5l_decap_8
Xdecap_8_3052 VDD VSS sg13cmos5l_decap_8
Xdecap_8_3053 VDD VSS sg13cmos5l_decap_8
Xdecap_8_3054 VDD VSS sg13cmos5l_decap_8
Xdecap_8_3055 VDD VSS sg13cmos5l_decap_8
Xdecap_8_3056 VDD VSS sg13cmos5l_decap_8
Xdecap_8_3057 VDD VSS sg13cmos5l_decap_8
Xdecap_8_3058 VDD VSS sg13cmos5l_decap_8
Xdecap_8_3059 VDD VSS sg13cmos5l_decap_8
Xdecap_8_3060 VDD VSS sg13cmos5l_decap_8
Xdecap_8_3061 VDD VSS sg13cmos5l_decap_8
Xdecap_8_3062 VDD VSS sg13cmos5l_decap_8
Xdecap_8_3063 VDD VSS sg13cmos5l_decap_8
Xdecap_8_3064 VDD VSS sg13cmos5l_decap_8
Xdecap_8_3065 VDD VSS sg13cmos5l_decap_8
Xdecap_8_3066 VDD VSS sg13cmos5l_decap_8
Xdecap_8_3067 VDD VSS sg13cmos5l_decap_8
Xdecap_8_3068 VDD VSS sg13cmos5l_decap_8
Xdecap_8_3069 VDD VSS sg13cmos5l_decap_8
Xdecap_8_3070 VDD VSS sg13cmos5l_decap_8
Xdecap_8_3071 VDD VSS sg13cmos5l_decap_8
Xdecap_8_3072 VDD VSS sg13cmos5l_decap_8
Xdecap_8_3073 VDD VSS sg13cmos5l_decap_8
Xdecap_8_3074 VDD VSS sg13cmos5l_decap_8
Xdecap_8_3075 VDD VSS sg13cmos5l_decap_8
Xdecap_8_3076 VDD VSS sg13cmos5l_decap_8
Xdecap_8_3077 VDD VSS sg13cmos5l_decap_8
Xdecap_8_3078 VDD VSS sg13cmos5l_decap_8
Xdecap_8_3079 VDD VSS sg13cmos5l_decap_8
Xdecap_8_3080 VDD VSS sg13cmos5l_decap_8
Xdecap_8_3081 VDD VSS sg13cmos5l_decap_8
Xdecap_8_3082 VDD VSS sg13cmos5l_decap_8
Xdecap_8_3083 VDD VSS sg13cmos5l_decap_8
Xdecap_8_3084 VDD VSS sg13cmos5l_decap_8
Xdecap_8_3085 VDD VSS sg13cmos5l_decap_8
Xdecap_8_3086 VDD VSS sg13cmos5l_decap_8
Xdecap_8_3087 VDD VSS sg13cmos5l_decap_8
Xdecap_8_3088 VDD VSS sg13cmos5l_decap_8
Xdecap_8_3089 VDD VSS sg13cmos5l_decap_8
Xdecap_8_3090 VDD VSS sg13cmos5l_decap_8
Xdecap_8_3091 VDD VSS sg13cmos5l_decap_8
Xdecap_8_3092 VDD VSS sg13cmos5l_decap_8
Xdecap_8_3093 VDD VSS sg13cmos5l_decap_8
Xdecap_8_3094 VDD VSS sg13cmos5l_decap_8
Xdecap_8_3095 VDD VSS sg13cmos5l_decap_8
Xdecap_8_3096 VDD VSS sg13cmos5l_decap_8
Xdecap_8_3097 VDD VSS sg13cmos5l_decap_8
Xdecap_8_3098 VDD VSS sg13cmos5l_decap_8
Xdecap_8_3099 VDD VSS sg13cmos5l_decap_8
Xdecap_8_3100 VDD VSS sg13cmos5l_decap_8
Xdecap_8_3101 VDD VSS sg13cmos5l_decap_8
Xdecap_8_3102 VDD VSS sg13cmos5l_decap_8
Xdecap_8_3103 VDD VSS sg13cmos5l_decap_8
Xdecap_8_3104 VDD VSS sg13cmos5l_decap_8
Xdecap_8_3105 VDD VSS sg13cmos5l_decap_8
Xdecap_8_3106 VDD VSS sg13cmos5l_decap_8
Xdecap_8_3107 VDD VSS sg13cmos5l_decap_8
Xdecap_8_3108 VDD VSS sg13cmos5l_decap_8
Xdecap_8_3109 VDD VSS sg13cmos5l_decap_8
Xdecap_8_3110 VDD VSS sg13cmos5l_decap_8
Xdecap_8_3111 VDD VSS sg13cmos5l_decap_8
Xdecap_8_3112 VDD VSS sg13cmos5l_decap_8
Xdecap_8_3113 VDD VSS sg13cmos5l_decap_8
Xdecap_8_3114 VDD VSS sg13cmos5l_decap_8
Xdecap_8_3115 VDD VSS sg13cmos5l_decap_8
Xdecap_8_3116 VDD VSS sg13cmos5l_decap_8
Xdecap_8_3117 VDD VSS sg13cmos5l_decap_8
Xdecap_8_3118 VDD VSS sg13cmos5l_decap_8
Xdecap_8_3119 VDD VSS sg13cmos5l_decap_8
Xdecap_8_3120 VDD VSS sg13cmos5l_decap_8
Xdecap_8_3121 VDD VSS sg13cmos5l_decap_8
Xdecap_8_3122 VDD VSS sg13cmos5l_decap_8
Xdecap_8_3123 VDD VSS sg13cmos5l_decap_8
Xdecap_8_3124 VDD VSS sg13cmos5l_decap_8
Xdecap_8_3125 VDD VSS sg13cmos5l_decap_8
Xdecap_8_3126 VDD VSS sg13cmos5l_decap_8
Xdecap_8_3127 VDD VSS sg13cmos5l_decap_8
Xdecap_8_3128 VDD VSS sg13cmos5l_decap_8
Xdecap_8_3129 VDD VSS sg13cmos5l_decap_8
Xdecap_8_3130 VDD VSS sg13cmos5l_decap_8
Xdecap_8_3131 VDD VSS sg13cmos5l_decap_8
Xdecap_8_3132 VDD VSS sg13cmos5l_decap_8
Xdecap_8_3133 VDD VSS sg13cmos5l_decap_8
Xdecap_8_3134 VDD VSS sg13cmos5l_decap_8
Xdecap_8_3135 VDD VSS sg13cmos5l_decap_8
Xdecap_8_3136 VDD VSS sg13cmos5l_decap_8
Xdecap_8_3137 VDD VSS sg13cmos5l_decap_8
Xdecap_8_3138 VDD VSS sg13cmos5l_decap_8
Xdecap_8_3139 VDD VSS sg13cmos5l_decap_8
Xdecap_8_3140 VDD VSS sg13cmos5l_decap_8
Xdecap_8_3141 VDD VSS sg13cmos5l_decap_8
Xdecap_8_3142 VDD VSS sg13cmos5l_decap_8
Xdecap_8_3143 VDD VSS sg13cmos5l_decap_8
Xdecap_8_3144 VDD VSS sg13cmos5l_decap_8
Xdecap_8_3145 VDD VSS sg13cmos5l_decap_8
Xdecap_8_3146 VDD VSS sg13cmos5l_decap_8
Xdecap_8_3147 VDD VSS sg13cmos5l_decap_8
Xdecap_8_3148 VDD VSS sg13cmos5l_decap_8
Xdecap_8_3149 VDD VSS sg13cmos5l_decap_8
Xdecap_8_3150 VDD VSS sg13cmos5l_decap_8
Xdecap_8_3151 VDD VSS sg13cmos5l_decap_8
Xdecap_8_3152 VDD VSS sg13cmos5l_decap_8
Xdecap_8_3153 VDD VSS sg13cmos5l_decap_8
Xdecap_8_3154 VDD VSS sg13cmos5l_decap_8
Xdecap_8_3155 VDD VSS sg13cmos5l_decap_8
Xdecap_8_3156 VDD VSS sg13cmos5l_decap_8
Xdecap_8_3157 VDD VSS sg13cmos5l_decap_8
Xdecap_8_3158 VDD VSS sg13cmos5l_decap_8
Xdecap_8_3159 VDD VSS sg13cmos5l_decap_8
Xdecap_8_3160 VDD VSS sg13cmos5l_decap_8
Xdecap_8_3161 VDD VSS sg13cmos5l_decap_8
Xdecap_8_3162 VDD VSS sg13cmos5l_decap_8
Xdecap_8_3163 VDD VSS sg13cmos5l_decap_8
Xdecap_8_3164 VDD VSS sg13cmos5l_decap_8
Xdecap_8_3165 VDD VSS sg13cmos5l_decap_8
Xdecap_8_3166 VDD VSS sg13cmos5l_decap_8
Xdecap_8_3167 VDD VSS sg13cmos5l_decap_8
Xdecap_8_3168 VDD VSS sg13cmos5l_decap_8
Xdecap_8_3169 VDD VSS sg13cmos5l_decap_8
Xdecap_8_3170 VDD VSS sg13cmos5l_decap_8
Xdecap_8_3171 VDD VSS sg13cmos5l_decap_8
Xdecap_8_3172 VDD VSS sg13cmos5l_decap_8
Xdecap_8_3173 VDD VSS sg13cmos5l_decap_8
Xdecap_8_3174 VDD VSS sg13cmos5l_decap_8
Xdecap_8_3175 VDD VSS sg13cmos5l_decap_8
Xdecap_8_3176 VDD VSS sg13cmos5l_decap_8
Xdecap_8_3177 VDD VSS sg13cmos5l_decap_8
Xdecap_8_3178 VDD VSS sg13cmos5l_decap_8
Xdecap_8_3179 VDD VSS sg13cmos5l_decap_8
Xdecap_8_3180 VDD VSS sg13cmos5l_decap_8
Xdecap_8_3181 VDD VSS sg13cmos5l_decap_8
Xdecap_8_3182 VDD VSS sg13cmos5l_decap_8
Xdecap_8_3183 VDD VSS sg13cmos5l_decap_8
Xdecap_8_3184 VDD VSS sg13cmos5l_decap_8
Xdecap_8_3185 VDD VSS sg13cmos5l_decap_8
Xdecap_8_3186 VDD VSS sg13cmos5l_decap_8
Xdecap_8_3187 VDD VSS sg13cmos5l_decap_8
Xdecap_8_3188 VDD VSS sg13cmos5l_decap_8
Xdecap_8_3189 VDD VSS sg13cmos5l_decap_8
Xdecap_8_3190 VDD VSS sg13cmos5l_decap_8
Xdecap_8_3191 VDD VSS sg13cmos5l_decap_8
Xdecap_8_3192 VDD VSS sg13cmos5l_decap_8
Xdecap_8_3193 VDD VSS sg13cmos5l_decap_8
Xdecap_8_3194 VDD VSS sg13cmos5l_decap_8
Xdecap_8_3195 VDD VSS sg13cmos5l_decap_8
Xdecap_8_3196 VDD VSS sg13cmos5l_decap_8
Xdecap_8_3197 VDD VSS sg13cmos5l_decap_8
Xdecap_8_3198 VDD VSS sg13cmos5l_decap_8
Xdecap_8_3199 VDD VSS sg13cmos5l_decap_8
Xdecap_8_3200 VDD VSS sg13cmos5l_decap_8
Xdecap_8_3201 VDD VSS sg13cmos5l_decap_8
Xdecap_8_3202 VDD VSS sg13cmos5l_decap_8
Xdecap_8_3203 VDD VSS sg13cmos5l_decap_8
Xdecap_8_3204 VDD VSS sg13cmos5l_decap_8
Xdecap_8_3205 VDD VSS sg13cmos5l_decap_8
Xdecap_8_3206 VDD VSS sg13cmos5l_decap_8
Xdecap_8_3207 VDD VSS sg13cmos5l_decap_8
Xdecap_8_3208 VDD VSS sg13cmos5l_decap_8
Xdecap_8_3209 VDD VSS sg13cmos5l_decap_8
Xdecap_8_3210 VDD VSS sg13cmos5l_decap_8
Xdecap_8_3211 VDD VSS sg13cmos5l_decap_8
Xdecap_8_3212 VDD VSS sg13cmos5l_decap_8
Xdecap_8_3213 VDD VSS sg13cmos5l_decap_8
Xdecap_8_3214 VDD VSS sg13cmos5l_decap_8
Xdecap_8_3215 VDD VSS sg13cmos5l_decap_8
Xdecap_8_3216 VDD VSS sg13cmos5l_decap_8
Xdecap_8_3217 VDD VSS sg13cmos5l_decap_8
Xdecap_8_3218 VDD VSS sg13cmos5l_decap_8
Xdecap_8_3219 VDD VSS sg13cmos5l_decap_8
Xdecap_8_3220 VDD VSS sg13cmos5l_decap_8
Xdecap_8_3221 VDD VSS sg13cmos5l_decap_8
Xdecap_8_3222 VDD VSS sg13cmos5l_decap_8
Xdecap_8_3223 VDD VSS sg13cmos5l_decap_8
Xdecap_8_3224 VDD VSS sg13cmos5l_decap_8
Xdecap_8_3225 VDD VSS sg13cmos5l_decap_8
Xdecap_8_3226 VDD VSS sg13cmos5l_decap_8
Xdecap_8_3227 VDD VSS sg13cmos5l_decap_8
Xdecap_8_3228 VDD VSS sg13cmos5l_decap_8
Xdecap_8_3229 VDD VSS sg13cmos5l_decap_8
Xdecap_8_3230 VDD VSS sg13cmos5l_decap_8
Xdecap_8_3231 VDD VSS sg13cmos5l_decap_8
Xdecap_8_3232 VDD VSS sg13cmos5l_decap_8
Xdecap_8_3233 VDD VSS sg13cmos5l_decap_8
Xdecap_8_3234 VDD VSS sg13cmos5l_decap_8
Xdecap_8_3235 VDD VSS sg13cmos5l_decap_8
Xdecap_8_3236 VDD VSS sg13cmos5l_decap_8
Xdecap_8_3237 VDD VSS sg13cmos5l_decap_8
Xdecap_8_3238 VDD VSS sg13cmos5l_decap_8
Xdecap_8_3239 VDD VSS sg13cmos5l_decap_8
Xdecap_8_3240 VDD VSS sg13cmos5l_decap_8
Xdecap_8_3241 VDD VSS sg13cmos5l_decap_8
Xdecap_8_3242 VDD VSS sg13cmos5l_decap_8
Xdecap_8_3243 VDD VSS sg13cmos5l_decap_8
Xdecap_8_3244 VDD VSS sg13cmos5l_decap_8
Xdecap_8_3245 VDD VSS sg13cmos5l_decap_8
Xdecap_8_3246 VDD VSS sg13cmos5l_decap_8
Xdecap_8_3247 VDD VSS sg13cmos5l_decap_8
Xdecap_8_3248 VDD VSS sg13cmos5l_decap_8
Xdecap_8_3249 VDD VSS sg13cmos5l_decap_8
Xdecap_8_3250 VDD VSS sg13cmos5l_decap_8
Xdecap_8_3251 VDD VSS sg13cmos5l_decap_8
Xdecap_8_3252 VDD VSS sg13cmos5l_decap_8
Xdecap_8_3253 VDD VSS sg13cmos5l_decap_8
Xdecap_8_3254 VDD VSS sg13cmos5l_decap_8
Xdecap_8_3255 VDD VSS sg13cmos5l_decap_8
Xdecap_8_3256 VDD VSS sg13cmos5l_decap_8
Xdecap_8_3257 VDD VSS sg13cmos5l_decap_8
Xdecap_8_3258 VDD VSS sg13cmos5l_decap_8
Xdecap_8_3259 VDD VSS sg13cmos5l_decap_8
Xdecap_8_3260 VDD VSS sg13cmos5l_decap_8
Xdecap_8_3261 VDD VSS sg13cmos5l_decap_8
Xdecap_8_3262 VDD VSS sg13cmos5l_decap_8
Xdecap_8_3263 VDD VSS sg13cmos5l_decap_8
Xdecap_8_3264 VDD VSS sg13cmos5l_decap_8
Xdecap_8_3265 VDD VSS sg13cmos5l_decap_8
Xdecap_8_3266 VDD VSS sg13cmos5l_decap_8
Xdecap_8_3267 VDD VSS sg13cmos5l_decap_8
Xdecap_8_3268 VDD VSS sg13cmos5l_decap_8
Xdecap_8_3269 VDD VSS sg13cmos5l_decap_8
Xdecap_8_3270 VDD VSS sg13cmos5l_decap_8
Xdecap_8_3271 VDD VSS sg13cmos5l_decap_8
Xdecap_8_3272 VDD VSS sg13cmos5l_decap_8
Xdecap_8_3273 VDD VSS sg13cmos5l_decap_8
Xdecap_8_3274 VDD VSS sg13cmos5l_decap_8
Xdecap_8_3275 VDD VSS sg13cmos5l_decap_8
Xdecap_8_3276 VDD VSS sg13cmos5l_decap_8
Xdecap_8_3277 VDD VSS sg13cmos5l_decap_8
Xdecap_8_3278 VDD VSS sg13cmos5l_decap_8
Xdecap_8_3279 VDD VSS sg13cmos5l_decap_8
Xdecap_8_3280 VDD VSS sg13cmos5l_decap_8
Xdecap_8_3281 VDD VSS sg13cmos5l_decap_8
Xdecap_8_3282 VDD VSS sg13cmos5l_decap_8
Xdecap_8_3283 VDD VSS sg13cmos5l_decap_8
Xdecap_8_3284 VDD VSS sg13cmos5l_decap_8
Xdecap_8_3285 VDD VSS sg13cmos5l_decap_8
Xdecap_8_3286 VDD VSS sg13cmos5l_decap_8
Xdecap_8_3287 VDD VSS sg13cmos5l_decap_8
Xdecap_8_3288 VDD VSS sg13cmos5l_decap_8
Xdecap_8_3289 VDD VSS sg13cmos5l_decap_8
Xdecap_8_3290 VDD VSS sg13cmos5l_decap_8
Xdecap_8_3291 VDD VSS sg13cmos5l_decap_8
Xdecap_8_3292 VDD VSS sg13cmos5l_decap_8
Xdecap_8_3293 VDD VSS sg13cmos5l_decap_8
Xdecap_8_3294 VDD VSS sg13cmos5l_decap_8
Xdecap_8_3295 VDD VSS sg13cmos5l_decap_8
Xdecap_8_3296 VDD VSS sg13cmos5l_decap_8
Xdecap_8_3297 VDD VSS sg13cmos5l_decap_8
Xdecap_8_3298 VDD VSS sg13cmos5l_decap_8
Xdecap_8_3299 VDD VSS sg13cmos5l_decap_8
Xdecap_8_3300 VDD VSS sg13cmos5l_decap_8
Xdecap_8_3301 VDD VSS sg13cmos5l_decap_8
Xdecap_8_3302 VDD VSS sg13cmos5l_decap_8
Xdecap_8_3303 VDD VSS sg13cmos5l_decap_8
Xdecap_8_3304 VDD VSS sg13cmos5l_decap_8
Xdecap_8_3305 VDD VSS sg13cmos5l_decap_8
Xdecap_8_3306 VDD VSS sg13cmos5l_decap_8
Xdecap_8_3307 VDD VSS sg13cmos5l_decap_8
Xdecap_8_3308 VDD VSS sg13cmos5l_decap_8
Xdecap_8_3309 VDD VSS sg13cmos5l_decap_8
Xdecap_8_3310 VDD VSS sg13cmos5l_decap_8
Xdecap_8_3311 VDD VSS sg13cmos5l_decap_8
Xdecap_8_3312 VDD VSS sg13cmos5l_decap_8
Xdecap_8_3313 VDD VSS sg13cmos5l_decap_8
Xdecap_8_3314 VDD VSS sg13cmos5l_decap_8
Xdecap_8_3315 VDD VSS sg13cmos5l_decap_8
Xdecap_8_3316 VDD VSS sg13cmos5l_decap_8
Xdecap_8_3317 VDD VSS sg13cmos5l_decap_8
Xdecap_8_3318 VDD VSS sg13cmos5l_decap_8
Xdecap_8_3319 VDD VSS sg13cmos5l_decap_8
Xdecap_8_3320 VDD VSS sg13cmos5l_decap_8
Xdecap_8_3321 VDD VSS sg13cmos5l_decap_8
Xdecap_8_3322 VDD VSS sg13cmos5l_decap_8
Xdecap_8_3323 VDD VSS sg13cmos5l_decap_8
Xdecap_8_3324 VDD VSS sg13cmos5l_decap_8
Xdecap_8_3325 VDD VSS sg13cmos5l_decap_8
Xdecap_8_3326 VDD VSS sg13cmos5l_decap_8
Xdecap_8_3327 VDD VSS sg13cmos5l_decap_8
Xdecap_8_3328 VDD VSS sg13cmos5l_decap_8
Xdecap_8_3329 VDD VSS sg13cmos5l_decap_8
Xdecap_8_3330 VDD VSS sg13cmos5l_decap_8
Xdecap_8_3331 VDD VSS sg13cmos5l_decap_8
Xdecap_8_3332 VDD VSS sg13cmos5l_decap_8
Xdecap_8_3333 VDD VSS sg13cmos5l_decap_8
Xdecap_8_3334 VDD VSS sg13cmos5l_decap_8
Xdecap_8_3335 VDD VSS sg13cmos5l_decap_8
Xdecap_8_3336 VDD VSS sg13cmos5l_decap_8
Xdecap_8_3337 VDD VSS sg13cmos5l_decap_8
Xdecap_8_3338 VDD VSS sg13cmos5l_decap_8
Xdecap_8_3339 VDD VSS sg13cmos5l_decap_8
Xdecap_8_3340 VDD VSS sg13cmos5l_decap_8
Xdecap_8_3341 VDD VSS sg13cmos5l_decap_8
Xdecap_8_3342 VDD VSS sg13cmos5l_decap_8
Xdecap_8_3343 VDD VSS sg13cmos5l_decap_8
Xdecap_8_3344 VDD VSS sg13cmos5l_decap_8
Xdecap_8_3345 VDD VSS sg13cmos5l_decap_8
Xdecap_8_3346 VDD VSS sg13cmos5l_decap_8
Xdecap_8_3347 VDD VSS sg13cmos5l_decap_8
Xdecap_8_3348 VDD VSS sg13cmos5l_decap_8
Xdecap_8_3349 VDD VSS sg13cmos5l_decap_8
Xdecap_8_3350 VDD VSS sg13cmos5l_decap_8
Xdecap_8_3351 VDD VSS sg13cmos5l_decap_8
Xdecap_8_3352 VDD VSS sg13cmos5l_decap_8
Xdecap_8_3353 VDD VSS sg13cmos5l_decap_8
Xdecap_8_3354 VDD VSS sg13cmos5l_decap_8
Xdecap_8_3355 VDD VSS sg13cmos5l_decap_8
Xdecap_8_3356 VDD VSS sg13cmos5l_decap_8
Xdecap_8_3357 VDD VSS sg13cmos5l_decap_8
Xdecap_8_3358 VDD VSS sg13cmos5l_decap_8
Xdecap_8_3359 VDD VSS sg13cmos5l_decap_8
Xdecap_8_3360 VDD VSS sg13cmos5l_decap_8
Xdecap_8_3361 VDD VSS sg13cmos5l_decap_8
Xdecap_8_3362 VDD VSS sg13cmos5l_decap_8
Xdecap_8_3363 VDD VSS sg13cmos5l_decap_8
Xdecap_8_3364 VDD VSS sg13cmos5l_decap_8
Xdecap_8_3365 VDD VSS sg13cmos5l_decap_8
Xdecap_8_3366 VDD VSS sg13cmos5l_decap_8
Xdecap_8_3367 VDD VSS sg13cmos5l_decap_8
Xdecap_8_3368 VDD VSS sg13cmos5l_decap_8
Xdecap_8_3369 VDD VSS sg13cmos5l_decap_8
Xdecap_8_3370 VDD VSS sg13cmos5l_decap_8
Xdecap_8_3371 VDD VSS sg13cmos5l_decap_8
Xdecap_8_3372 VDD VSS sg13cmos5l_decap_8
Xdecap_8_3373 VDD VSS sg13cmos5l_decap_8
Xdecap_8_3374 VDD VSS sg13cmos5l_decap_8
Xdecap_8_3375 VDD VSS sg13cmos5l_decap_8
Xdecap_8_3376 VDD VSS sg13cmos5l_decap_8
Xdecap_8_3377 VDD VSS sg13cmos5l_decap_8
Xdecap_8_3378 VDD VSS sg13cmos5l_decap_8
Xdecap_8_3379 VDD VSS sg13cmos5l_decap_8
Xdecap_8_3380 VDD VSS sg13cmos5l_decap_8
Xdecap_8_3381 VDD VSS sg13cmos5l_decap_8
Xdecap_8_3382 VDD VSS sg13cmos5l_decap_8
Xdecap_8_3383 VDD VSS sg13cmos5l_decap_8
Xdecap_8_3384 VDD VSS sg13cmos5l_decap_8
Xdecap_8_3385 VDD VSS sg13cmos5l_decap_8
Xdecap_8_3386 VDD VSS sg13cmos5l_decap_8
Xdecap_8_3387 VDD VSS sg13cmos5l_decap_8
Xdecap_8_3388 VDD VSS sg13cmos5l_decap_8
Xdecap_8_3389 VDD VSS sg13cmos5l_decap_8
Xdecap_8_3390 VDD VSS sg13cmos5l_decap_8
Xdecap_8_3391 VDD VSS sg13cmos5l_decap_8
Xdecap_8_3392 VDD VSS sg13cmos5l_decap_8
Xdecap_8_3393 VDD VSS sg13cmos5l_decap_8
Xdecap_8_3394 VDD VSS sg13cmos5l_decap_8
Xdecap_8_3395 VDD VSS sg13cmos5l_decap_8
Xdecap_8_3396 VDD VSS sg13cmos5l_decap_8
Xdecap_8_3397 VDD VSS sg13cmos5l_decap_8
Xdecap_8_3398 VDD VSS sg13cmos5l_decap_8
Xdecap_8_3399 VDD VSS sg13cmos5l_decap_8
Xdecap_8_3400 VDD VSS sg13cmos5l_decap_8
Xdecap_8_3401 VDD VSS sg13cmos5l_decap_8
Xdecap_8_3402 VDD VSS sg13cmos5l_decap_8
Xdecap_8_3403 VDD VSS sg13cmos5l_decap_8
Xdecap_8_3404 VDD VSS sg13cmos5l_decap_8
Xdecap_8_3405 VDD VSS sg13cmos5l_decap_8
Xdecap_8_3406 VDD VSS sg13cmos5l_decap_8
Xdecap_8_3407 VDD VSS sg13cmos5l_decap_8
Xdecap_8_3408 VDD VSS sg13cmos5l_decap_8
Xdecap_8_3409 VDD VSS sg13cmos5l_decap_8
Xdecap_8_3410 VDD VSS sg13cmos5l_decap_8
Xdecap_8_3411 VDD VSS sg13cmos5l_decap_8
Xdecap_8_3412 VDD VSS sg13cmos5l_decap_8
Xdecap_8_3413 VDD VSS sg13cmos5l_decap_8
Xdecap_8_3414 VDD VSS sg13cmos5l_decap_8
Xdecap_8_3415 VDD VSS sg13cmos5l_decap_8
Xdecap_8_3416 VDD VSS sg13cmos5l_decap_8
Xdecap_8_3417 VDD VSS sg13cmos5l_decap_8
Xdecap_8_3418 VDD VSS sg13cmos5l_decap_8
Xdecap_8_3419 VDD VSS sg13cmos5l_decap_8
Xdecap_8_3420 VDD VSS sg13cmos5l_decap_8
Xdecap_8_3421 VDD VSS sg13cmos5l_decap_8
Xdecap_8_3422 VDD VSS sg13cmos5l_decap_8
Xdecap_8_3423 VDD VSS sg13cmos5l_decap_8
Xdecap_8_3424 VDD VSS sg13cmos5l_decap_8
Xdecap_8_3425 VDD VSS sg13cmos5l_decap_8
Xdecap_8_3426 VDD VSS sg13cmos5l_decap_8
Xdecap_8_3427 VDD VSS sg13cmos5l_decap_8
Xdecap_8_3428 VDD VSS sg13cmos5l_decap_8
Xdecap_8_3429 VDD VSS sg13cmos5l_decap_8
Xdecap_8_3430 VDD VSS sg13cmos5l_decap_8
Xdecap_8_3431 VDD VSS sg13cmos5l_decap_8
Xdecap_8_3432 VDD VSS sg13cmos5l_decap_8
Xdecap_8_3433 VDD VSS sg13cmos5l_decap_8
Xdecap_8_3434 VDD VSS sg13cmos5l_decap_8
Xdecap_8_3435 VDD VSS sg13cmos5l_decap_8
Xdecap_8_3436 VDD VSS sg13cmos5l_decap_8
Xdecap_8_3437 VDD VSS sg13cmos5l_decap_8
Xdecap_8_3438 VDD VSS sg13cmos5l_decap_8
Xdecap_8_3439 VDD VSS sg13cmos5l_decap_8
Xdecap_8_3440 VDD VSS sg13cmos5l_decap_8
Xdecap_8_3441 VDD VSS sg13cmos5l_decap_8
Xdecap_8_3442 VDD VSS sg13cmos5l_decap_8
Xdecap_8_3443 VDD VSS sg13cmos5l_decap_8
Xdecap_8_3444 VDD VSS sg13cmos5l_decap_8
Xdecap_8_3445 VDD VSS sg13cmos5l_decap_8
Xdecap_8_3446 VDD VSS sg13cmos5l_decap_8
Xdecap_8_3447 VDD VSS sg13cmos5l_decap_8
Xdecap_8_3448 VDD VSS sg13cmos5l_decap_8
Xdecap_8_3449 VDD VSS sg13cmos5l_decap_8
Xdecap_8_3450 VDD VSS sg13cmos5l_decap_8
Xdecap_8_3451 VDD VSS sg13cmos5l_decap_8
Xdecap_8_3452 VDD VSS sg13cmos5l_decap_8
Xdecap_8_3453 VDD VSS sg13cmos5l_decap_8
Xdecap_8_3454 VDD VSS sg13cmos5l_decap_8
Xdecap_8_3455 VDD VSS sg13cmos5l_decap_8
Xdecap_8_3456 VDD VSS sg13cmos5l_decap_8
Xdecap_8_3457 VDD VSS sg13cmos5l_decap_8
Xdecap_8_3458 VDD VSS sg13cmos5l_decap_8
Xdecap_8_3459 VDD VSS sg13cmos5l_decap_8
Xdecap_8_3460 VDD VSS sg13cmos5l_decap_8
Xdecap_8_3461 VDD VSS sg13cmos5l_decap_8
Xdecap_8_3462 VDD VSS sg13cmos5l_decap_8
Xdecap_8_3463 VDD VSS sg13cmos5l_decap_8
Xdecap_8_3464 VDD VSS sg13cmos5l_decap_8
Xdecap_8_3465 VDD VSS sg13cmos5l_decap_8
Xdecap_8_3466 VDD VSS sg13cmos5l_decap_8
Xdecap_8_3467 VDD VSS sg13cmos5l_decap_8
Xdecap_8_3468 VDD VSS sg13cmos5l_decap_8
Xdecap_8_3469 VDD VSS sg13cmos5l_decap_8
Xdecap_8_3470 VDD VSS sg13cmos5l_decap_8
Xdecap_8_3471 VDD VSS sg13cmos5l_decap_8
Xdecap_8_3472 VDD VSS sg13cmos5l_decap_8
Xdecap_8_3473 VDD VSS sg13cmos5l_decap_8
Xdecap_8_3474 VDD VSS sg13cmos5l_decap_8
Xdecap_8_3475 VDD VSS sg13cmos5l_decap_8
Xdecap_8_3476 VDD VSS sg13cmos5l_decap_8
Xdecap_8_3477 VDD VSS sg13cmos5l_decap_8
Xdecap_8_3478 VDD VSS sg13cmos5l_decap_8
Xdecap_8_3479 VDD VSS sg13cmos5l_decap_8
Xdecap_8_3480 VDD VSS sg13cmos5l_decap_8
Xdecap_8_3481 VDD VSS sg13cmos5l_decap_8
Xdecap_8_3482 VDD VSS sg13cmos5l_decap_8
Xdecap_8_3483 VDD VSS sg13cmos5l_decap_8
Xdecap_8_3484 VDD VSS sg13cmos5l_decap_8
Xdecap_8_3485 VDD VSS sg13cmos5l_decap_8
Xdecap_8_3486 VDD VSS sg13cmos5l_decap_8
Xdecap_8_3487 VDD VSS sg13cmos5l_decap_8
Xdecap_8_3488 VDD VSS sg13cmos5l_decap_8
Xdecap_8_3489 VDD VSS sg13cmos5l_decap_8
Xdecap_8_3490 VDD VSS sg13cmos5l_decap_8
Xdecap_8_3491 VDD VSS sg13cmos5l_decap_8
Xdecap_8_3492 VDD VSS sg13cmos5l_decap_8
Xdecap_8_3493 VDD VSS sg13cmos5l_decap_8
Xdecap_8_3494 VDD VSS sg13cmos5l_decap_8
Xdecap_8_3495 VDD VSS sg13cmos5l_decap_8
Xdecap_8_3496 VDD VSS sg13cmos5l_decap_8
Xdecap_8_3497 VDD VSS sg13cmos5l_decap_8
Xdecap_8_3498 VDD VSS sg13cmos5l_decap_8
Xdecap_8_3499 VDD VSS sg13cmos5l_decap_8
Xdecap_8_3500 VDD VSS sg13cmos5l_decap_8
Xdecap_8_3501 VDD VSS sg13cmos5l_decap_8
Xdecap_8_3502 VDD VSS sg13cmos5l_decap_8
Xdecap_8_3503 VDD VSS sg13cmos5l_decap_8
Xdecap_8_3504 VDD VSS sg13cmos5l_decap_8
Xdecap_8_3505 VDD VSS sg13cmos5l_decap_8
Xdecap_8_3506 VDD VSS sg13cmos5l_decap_8
Xdecap_8_3507 VDD VSS sg13cmos5l_decap_8
Xdecap_8_3508 VDD VSS sg13cmos5l_decap_8
Xdecap_8_3509 VDD VSS sg13cmos5l_decap_8
Xdecap_8_3510 VDD VSS sg13cmos5l_decap_8
Xdecap_8_3511 VDD VSS sg13cmos5l_decap_8
Xdecap_8_3512 VDD VSS sg13cmos5l_decap_8
Xdecap_8_3513 VDD VSS sg13cmos5l_decap_8
Xdecap_8_3514 VDD VSS sg13cmos5l_decap_8
Xdecap_8_3515 VDD VSS sg13cmos5l_decap_8
Xdecap_8_3516 VDD VSS sg13cmos5l_decap_8
Xdecap_8_3517 VDD VSS sg13cmos5l_decap_8
Xdecap_8_3518 VDD VSS sg13cmos5l_decap_8
Xdecap_8_3519 VDD VSS sg13cmos5l_decap_8
Xdecap_8_3520 VDD VSS sg13cmos5l_decap_8
Xdecap_8_3521 VDD VSS sg13cmos5l_decap_8
Xdecap_8_3522 VDD VSS sg13cmos5l_decap_8
Xdecap_8_3523 VDD VSS sg13cmos5l_decap_8
Xdecap_8_3524 VDD VSS sg13cmos5l_decap_8
Xdecap_8_3525 VDD VSS sg13cmos5l_decap_8
Xdecap_8_3526 VDD VSS sg13cmos5l_decap_8
Xdecap_8_3527 VDD VSS sg13cmos5l_decap_8
Xdecap_8_3528 VDD VSS sg13cmos5l_decap_8
Xdecap_8_3529 VDD VSS sg13cmos5l_decap_8
Xdecap_8_3530 VDD VSS sg13cmos5l_decap_8
Xdecap_8_3531 VDD VSS sg13cmos5l_decap_8
Xdecap_8_3532 VDD VSS sg13cmos5l_decap_8
Xdecap_8_3533 VDD VSS sg13cmos5l_decap_8
Xdecap_8_3534 VDD VSS sg13cmos5l_decap_8
Xdecap_8_3535 VDD VSS sg13cmos5l_decap_8
Xdecap_8_3536 VDD VSS sg13cmos5l_decap_8
Xdecap_8_3537 VDD VSS sg13cmos5l_decap_8
Xdecap_8_3538 VDD VSS sg13cmos5l_decap_8
Xdecap_8_3539 VDD VSS sg13cmos5l_decap_8
Xdecap_8_3540 VDD VSS sg13cmos5l_decap_8
Xdecap_8_3541 VDD VSS sg13cmos5l_decap_8
Xdecap_8_3542 VDD VSS sg13cmos5l_decap_8
Xdecap_8_3543 VDD VSS sg13cmos5l_decap_8
Xdecap_8_3544 VDD VSS sg13cmos5l_decap_8
Xdecap_8_3545 VDD VSS sg13cmos5l_decap_8
Xdecap_8_3546 VDD VSS sg13cmos5l_decap_8
Xdecap_8_3547 VDD VSS sg13cmos5l_decap_8
Xdecap_8_3548 VDD VSS sg13cmos5l_decap_8
Xdecap_8_3549 VDD VSS sg13cmos5l_decap_8
Xdecap_8_3550 VDD VSS sg13cmos5l_decap_8
Xdecap_8_3551 VDD VSS sg13cmos5l_decap_8
Xdecap_8_3552 VDD VSS sg13cmos5l_decap_8
Xdecap_8_3553 VDD VSS sg13cmos5l_decap_8
Xdecap_8_3554 VDD VSS sg13cmos5l_decap_8
Xdecap_8_3555 VDD VSS sg13cmos5l_decap_8
Xdecap_8_3556 VDD VSS sg13cmos5l_decap_8
Xdecap_8_3557 VDD VSS sg13cmos5l_decap_8
Xdecap_8_3558 VDD VSS sg13cmos5l_decap_8
Xdecap_8_3559 VDD VSS sg13cmos5l_decap_8
Xdecap_8_3560 VDD VSS sg13cmos5l_decap_8
Xdecap_8_3561 VDD VSS sg13cmos5l_decap_8
Xdecap_8_3562 VDD VSS sg13cmos5l_decap_8
Xdecap_8_3563 VDD VSS sg13cmos5l_decap_8
Xdecap_8_3564 VDD VSS sg13cmos5l_decap_8
Xdecap_8_3565 VDD VSS sg13cmos5l_decap_8
Xdecap_8_3566 VDD VSS sg13cmos5l_decap_8
Xdecap_8_3567 VDD VSS sg13cmos5l_decap_8
Xdecap_8_3568 VDD VSS sg13cmos5l_decap_8
Xdecap_8_3569 VDD VSS sg13cmos5l_decap_8
Xdecap_8_3570 VDD VSS sg13cmos5l_decap_8
Xdecap_8_3571 VDD VSS sg13cmos5l_decap_8
Xdecap_8_3572 VDD VSS sg13cmos5l_decap_8
Xdecap_8_3573 VDD VSS sg13cmos5l_decap_8
Xdecap_8_3574 VDD VSS sg13cmos5l_decap_8
Xdecap_8_3575 VDD VSS sg13cmos5l_decap_8
Xdecap_8_3576 VDD VSS sg13cmos5l_decap_8
Xdecap_4_0 VDD VSS sg13cmos5l_decap_4
Xdecap_4_1 VDD VSS sg13cmos5l_decap_4
Xdecap_4_2 VDD VSS sg13cmos5l_decap_4
Xdecap_4_3 VDD VSS sg13cmos5l_decap_4
Xdecap_4_4 VDD VSS sg13cmos5l_decap_4
Xdecap_4_5 VDD VSS sg13cmos5l_decap_4
Xdecap_4_6 VDD VSS sg13cmos5l_decap_4
Xdecap_4_7 VDD VSS sg13cmos5l_decap_4
Xdecap_4_8 VDD VSS sg13cmos5l_decap_4
Xdecap_4_9 VDD VSS sg13cmos5l_decap_4
Xdecap_4_10 VDD VSS sg13cmos5l_decap_4
Xdecap_4_11 VDD VSS sg13cmos5l_decap_4
Xdecap_4_12 VDD VSS sg13cmos5l_decap_4
Xdecap_4_13 VDD VSS sg13cmos5l_decap_4
Xdecap_4_14 VDD VSS sg13cmos5l_decap_4
Xdecap_4_15 VDD VSS sg13cmos5l_decap_4
Xdecap_4_16 VDD VSS sg13cmos5l_decap_4
Xdecap_4_17 VDD VSS sg13cmos5l_decap_4
Xdecap_4_18 VDD VSS sg13cmos5l_decap_4
Xdecap_4_19 VDD VSS sg13cmos5l_decap_4
Xdecap_4_20 VDD VSS sg13cmos5l_decap_4
Xdecap_4_21 VDD VSS sg13cmos5l_decap_4
Xdecap_4_22 VDD VSS sg13cmos5l_decap_4
Xdecap_4_23 VDD VSS sg13cmos5l_decap_4
Xdecap_4_24 VDD VSS sg13cmos5l_decap_4
Xdecap_4_25 VDD VSS sg13cmos5l_decap_4
Xdecap_4_26 VDD VSS sg13cmos5l_decap_4
Xdecap_4_27 VDD VSS sg13cmos5l_decap_4
Xdecap_4_28 VDD VSS sg13cmos5l_decap_4
Xdecap_4_29 VDD VSS sg13cmos5l_decap_4
Xdecap_4_30 VDD VSS sg13cmos5l_decap_4
Xdecap_4_31 VDD VSS sg13cmos5l_decap_4
Xdecap_4_32 VDD VSS sg13cmos5l_decap_4
Xdecap_4_33 VDD VSS sg13cmos5l_decap_4
Xdecap_4_34 VDD VSS sg13cmos5l_decap_4
Xdecap_4_35 VDD VSS sg13cmos5l_decap_4
Xdecap_4_36 VDD VSS sg13cmos5l_decap_4
Xdecap_4_37 VDD VSS sg13cmos5l_decap_4
Xdecap_4_38 VDD VSS sg13cmos5l_decap_4
Xdecap_4_39 VDD VSS sg13cmos5l_decap_4
Xdecap_4_40 VDD VSS sg13cmos5l_decap_4
Xdecap_4_41 VDD VSS sg13cmos5l_decap_4
Xdecap_4_42 VDD VSS sg13cmos5l_decap_4
Xdecap_4_43 VDD VSS sg13cmos5l_decap_4
Xdecap_4_44 VDD VSS sg13cmos5l_decap_4
Xdecap_4_45 VDD VSS sg13cmos5l_decap_4
Xdecap_4_46 VDD VSS sg13cmos5l_decap_4
Xdecap_4_47 VDD VSS sg13cmos5l_decap_4
Xdecap_4_48 VDD VSS sg13cmos5l_decap_4
Xdecap_4_49 VDD VSS sg13cmos5l_decap_4
Xdecap_4_50 VDD VSS sg13cmos5l_decap_4
Xdecap_4_51 VDD VSS sg13cmos5l_decap_4
Xdecap_4_52 VDD VSS sg13cmos5l_decap_4
Xdecap_4_53 VDD VSS sg13cmos5l_decap_4
Xdecap_4_54 VDD VSS sg13cmos5l_decap_4
Xdecap_4_55 VDD VSS sg13cmos5l_decap_4
Xdecap_4_56 VDD VSS sg13cmos5l_decap_4
Xdecap_4_57 VDD VSS sg13cmos5l_decap_4
Xdecap_4_58 VDD VSS sg13cmos5l_decap_4
Xdecap_4_59 VDD VSS sg13cmos5l_decap_4
Xdecap_4_60 VDD VSS sg13cmos5l_decap_4
Xdecap_4_61 VDD VSS sg13cmos5l_decap_4
Xdecap_4_62 VDD VSS sg13cmos5l_decap_4
Xdecap_4_63 VDD VSS sg13cmos5l_decap_4
Xdecap_4_64 VDD VSS sg13cmos5l_decap_4
Xdecap_4_65 VDD VSS sg13cmos5l_decap_4
Xdecap_4_66 VDD VSS sg13cmos5l_decap_4
Xdecap_4_67 VDD VSS sg13cmos5l_decap_4
Xdecap_4_68 VDD VSS sg13cmos5l_decap_4
Xdecap_4_69 VDD VSS sg13cmos5l_decap_4
Xdecap_4_70 VDD VSS sg13cmos5l_decap_4
Xdecap_4_71 VDD VSS sg13cmos5l_decap_4
Xdecap_4_72 VDD VSS sg13cmos5l_decap_4
Xdecap_4_73 VDD VSS sg13cmos5l_decap_4
Xdecap_4_74 VDD VSS sg13cmos5l_decap_4
Xdecap_4_75 VDD VSS sg13cmos5l_decap_4
Xdecap_4_76 VDD VSS sg13cmos5l_decap_4
Xdecap_4_77 VDD VSS sg13cmos5l_decap_4
Xdecap_4_78 VDD VSS sg13cmos5l_decap_4
Xdecap_4_79 VDD VSS sg13cmos5l_decap_4
Xdecap_4_80 VDD VSS sg13cmos5l_decap_4
Xdecap_4_81 VDD VSS sg13cmos5l_decap_4
Xdecap_4_82 VDD VSS sg13cmos5l_decap_4
Xdecap_4_83 VDD VSS sg13cmos5l_decap_4
Xdecap_4_84 VDD VSS sg13cmos5l_decap_4
Xdecap_4_85 VDD VSS sg13cmos5l_decap_4
Xdecap_4_86 VDD VSS sg13cmos5l_decap_4
Xdecap_4_87 VDD VSS sg13cmos5l_decap_4
Xdecap_4_88 VDD VSS sg13cmos5l_decap_4
Xdecap_4_89 VDD VSS sg13cmos5l_decap_4
Xdecap_4_90 VDD VSS sg13cmos5l_decap_4
Xdecap_4_91 VDD VSS sg13cmos5l_decap_4
Xdecap_4_92 VDD VSS sg13cmos5l_decap_4
Xdecap_4_93 VDD VSS sg13cmos5l_decap_4
Xdecap_4_94 VDD VSS sg13cmos5l_decap_4
Xdecap_4_95 VDD VSS sg13cmos5l_decap_4
Xdecap_4_96 VDD VSS sg13cmos5l_decap_4
Xdecap_4_97 VDD VSS sg13cmos5l_decap_4
Xdecap_4_98 VDD VSS sg13cmos5l_decap_4
Xdecap_4_99 VDD VSS sg13cmos5l_decap_4
Xdecap_4_100 VDD VSS sg13cmos5l_decap_4
Xdecap_4_101 VDD VSS sg13cmos5l_decap_4
Xdecap_4_102 VDD VSS sg13cmos5l_decap_4
Xdecap_4_103 VDD VSS sg13cmos5l_decap_4
Xdecap_4_104 VDD VSS sg13cmos5l_decap_4
Xdecap_4_105 VDD VSS sg13cmos5l_decap_4
Xdecap_4_106 VDD VSS sg13cmos5l_decap_4
Xdecap_4_107 VDD VSS sg13cmos5l_decap_4
Xdecap_4_108 VDD VSS sg13cmos5l_decap_4
Xdecap_4_109 VDD VSS sg13cmos5l_decap_4
Xdecap_4_110 VDD VSS sg13cmos5l_decap_4
Xdecap_4_111 VDD VSS sg13cmos5l_decap_4
Xdecap_4_112 VDD VSS sg13cmos5l_decap_4
Xdecap_4_113 VDD VSS sg13cmos5l_decap_4
Xdecap_4_114 VDD VSS sg13cmos5l_decap_4
Xdecap_4_115 VDD VSS sg13cmos5l_decap_4
Xdecap_4_116 VDD VSS sg13cmos5l_decap_4
Xdecap_4_117 VDD VSS sg13cmos5l_decap_4
Xdecap_4_118 VDD VSS sg13cmos5l_decap_4
Xdecap_4_119 VDD VSS sg13cmos5l_decap_4
Xdecap_4_120 VDD VSS sg13cmos5l_decap_4
Xdecap_4_121 VDD VSS sg13cmos5l_decap_4
Xdecap_4_122 VDD VSS sg13cmos5l_decap_4
* ---- Grouped substrate taps (ptap1) ----
* In flat mode KLayout extracts the guard rings of the pad ring as ONE ptap1 per net pair.
* The per-cell ptap1 of the CDL were removed and are placed here with the exact values
* of the extracted netlist (chip_top_extracted.cir).
R_ptap_0 IOVSS VSS ptap1 A=173395.07965e-12 P=40827.778e-6
R_ptap_1 VSS VSS ptap1 A=726.8736e-12 P=4895.216e-6
.ends SoC6169

* ------------------------------ IO library ------------------------------
.subckt sg13cmos5l_IOPadIOVss vdd vss iovdd iovss vsub
XI3 iovss iovss iovdd vsub sg13cmos5l_DCNDiode
XI2 iovss iovdd iovss sg13cmos5l_DCPDiode
.ends sg13cmos5l_IOPadIOVss

.subckt sg13cmos5l_DCPDiode anode cathode guard
DD1 anode cathode dpantenna m=1 w=1.26u l=27.78u a=35.003p p=58.08u
DD0 anode cathode dpantenna m=1 w=1.26u l=27.78u a=35.003p p=58.08u
.ends sg13cmos5l_DCPDiode

.subckt sg13cmos5l_DCNDiode anode cathode guard vsub
DD1 vsub cathode dantenna m=1 w=1.26u l=27.78u a=35.003p p=58.08u
DD0 vsub cathode dantenna m=1 w=1.26u l=27.78u a=35.003p p=58.08u
.ends sg13cmos5l_DCNDiode

.subckt sg13cmos5l_IOPadIOVdd vdd vss iovdd iovss vsub
XI1 net4 iovss iovdd vsub sg13cmos5l_Clamp_N43N43D4R
XI3 iovdd net1 vsub sg13cmos5l_RCClampResistor
XI2 net4 net1 iovss iovdd vsub sg13cmos5l_RCClampInverter
.ends sg13cmos5l_IOPadIOVdd

.subckt sg13cmos5l_RCClampInverter out in iovss supply vsub
MN1 iovss in iovss vsub sg13_hv_nmos m=1 w=63.000u l=9.5u ng=7
MN3 out in iovss vsub sg13_hv_nmos m=1 w=54.000u l=500.0n ng=6
MN0 iovss in iovss vsub sg13_hv_nmos m=1 w=63.000u l=9.5u ng=7
MN2 out in iovss vsub sg13_hv_nmos m=1 w=54.000u l=500.0n ng=6
MP0 out in supply supply sg13_hv_pmos m=1 w=350.000u l=500.0n ng=50
.ends sg13cmos5l_RCClampInverter

.subckt sg13cmos5l_RCClampResistor pin1 pin2 vsub
RR15 net15 net16 5.239K $SUB=vsub $[rppd] l=20u w=1u b=0 m=1
RR20 net20 net21 5.239K $SUB=vsub $[rppd] l=20u w=1u b=0 m=1
RR23 net23 net24 5.239K $SUB=vsub $[rppd] l=20u w=1u b=0 m=1
RR17 net17 net18 5.239K $SUB=vsub $[rppd] l=20u w=1u b=0 m=1
RR16 net16 net17 5.239K $SUB=vsub $[rppd] l=20u w=1u b=0 m=1
RR25 net25 pin2 5.239K $SUB=vsub $[rppd] l=20u w=1u b=0 m=1
RR22 net22 net23 5.239K $SUB=vsub $[rppd] l=20u w=1u b=0 m=1
RR19 net19 net20 5.239K $SUB=vsub $[rppd] l=20u w=1u b=0 m=1
RR24 net24 net25 5.239K $SUB=vsub $[rppd] l=20u w=1u b=0 m=1
RR21 net21 net22 5.239K $SUB=vsub $[rppd] l=20u w=1u b=0 m=1
RR18 net18 net19 5.239K $SUB=vsub $[rppd] l=20u w=1u b=0 m=1
RR5 net5 net6 5.239K $SUB=vsub $[rppd] l=20u w=1u b=0 m=1
RR8 net8 net9 5.239K $SUB=vsub $[rppd] l=20u w=1u b=0 m=1
RR11 net11 net12 5.239K $SUB=vsub $[rppd] l=20u w=1u b=0 m=1
RR14 net14 net15 5.239K $SUB=vsub $[rppd] l=20u w=1u b=0 m=1
RR2 net2 net3 5.239K $SUB=vsub $[rppd] l=20u w=1u b=0 m=1
RR1 net1 net2 5.239K $SUB=vsub $[rppd] l=20u w=1u b=0 m=1
RR13 net13 net14 5.239K $SUB=vsub $[rppd] l=20u w=1u b=0 m=1
RR10 net10 net11 5.239K $SUB=vsub $[rppd] l=20u w=1u b=0 m=1
RR7 net7 net8 5.239K $SUB=vsub $[rppd] l=20u w=1u b=0 m=1
RR4 net4 net5 5.239K $SUB=vsub $[rppd] l=20u w=1u b=0 m=1
RR12 net12 net13 5.239K $SUB=vsub $[rppd] l=20u w=1u b=0 m=1
RR9 net9 net10 5.239K $SUB=vsub $[rppd] l=20u w=1u b=0 m=1
RR6 net6 net7 5.239K $SUB=vsub $[rppd] l=20u w=1u b=0 m=1
RR3 net3 net4 5.239K $SUB=vsub $[rppd] l=20u w=1u b=0 m=1
RR0 pin1 net1 5.239K $SUB=vsub $[rppd] l=20u w=1u b=0 m=1
.ends sg13cmos5l_RCClampResistor

.subckt sg13cmos5l_Clamp_N43N43D4R gate iovss pad vsub
MN0<1> pad gate iovss vsub sg13_hv_nmos m=1 w=4.4u l=600.0n ng=1
MN0<2> pad gate iovss vsub sg13_hv_nmos m=1 w=4.4u l=600.0n ng=1
MN0<3> pad gate iovss vsub sg13_hv_nmos m=1 w=4.4u l=600.0n ng=1
MN0<4> pad gate iovss vsub sg13_hv_nmos m=1 w=4.4u l=600.0n ng=1
MN0<5> pad gate iovss vsub sg13_hv_nmos m=1 w=4.4u l=600.0n ng=1
MN0<6> pad gate iovss vsub sg13_hv_nmos m=1 w=4.4u l=600.0n ng=1
MN0<7> pad gate iovss vsub sg13_hv_nmos m=1 w=4.4u l=600.0n ng=1
MN0<8> pad gate iovss vsub sg13_hv_nmos m=1 w=4.4u l=600.0n ng=1
MN0<9> pad gate iovss vsub sg13_hv_nmos m=1 w=4.4u l=600.0n ng=1
MN0<10> pad gate iovss vsub sg13_hv_nmos m=1 w=4.4u l=600.0n ng=1
MN0<11> pad gate iovss vsub sg13_hv_nmos m=1 w=4.4u l=600.0n ng=1
MN0<12> pad gate iovss vsub sg13_hv_nmos m=1 w=4.4u l=600.0n ng=1
MN0<13> pad gate iovss vsub sg13_hv_nmos m=1 w=4.4u l=600.0n ng=1
MN0<14> pad gate iovss vsub sg13_hv_nmos m=1 w=4.4u l=600.0n ng=1
MN0<15> pad gate iovss vsub sg13_hv_nmos m=1 w=4.4u l=600.0n ng=1
MN0<16> pad gate iovss vsub sg13_hv_nmos m=1 w=4.4u l=600.0n ng=1
MN0<17> pad gate iovss vsub sg13_hv_nmos m=1 w=4.4u l=600.0n ng=1
MN0<18> pad gate iovss vsub sg13_hv_nmos m=1 w=4.4u l=600.0n ng=1
MN0<19> pad gate iovss vsub sg13_hv_nmos m=1 w=4.4u l=600.0n ng=1
MN0<20> pad gate iovss vsub sg13_hv_nmos m=1 w=4.4u l=600.0n ng=1
MN0<21> pad gate iovss vsub sg13_hv_nmos m=1 w=4.4u l=600.0n ng=1
MN0<22> pad gate iovss vsub sg13_hv_nmos m=1 w=4.4u l=600.0n ng=1
MN0<23> pad gate iovss vsub sg13_hv_nmos m=1 w=4.4u l=600.0n ng=1
MN0<24> pad gate iovss vsub sg13_hv_nmos m=1 w=4.4u l=600.0n ng=1
MN0<25> pad gate iovss vsub sg13_hv_nmos m=1 w=4.4u l=600.0n ng=1
MN0<26> pad gate iovss vsub sg13_hv_nmos m=1 w=4.4u l=600.0n ng=1
MN0<27> pad gate iovss vsub sg13_hv_nmos m=1 w=4.4u l=600.0n ng=1
MN0<28> pad gate iovss vsub sg13_hv_nmos m=1 w=4.4u l=600.0n ng=1
MN0<29> pad gate iovss vsub sg13_hv_nmos m=1 w=4.4u l=600.0n ng=1
MN0<30> pad gate iovss vsub sg13_hv_nmos m=1 w=4.4u l=600.0n ng=1
MN0<31> pad gate iovss vsub sg13_hv_nmos m=1 w=4.4u l=600.0n ng=1
MN0<32> pad gate iovss vsub sg13_hv_nmos m=1 w=4.4u l=600.0n ng=1
MN0<33> pad gate iovss vsub sg13_hv_nmos m=1 w=4.4u l=600.0n ng=1
MN0<34> pad gate iovss vsub sg13_hv_nmos m=1 w=4.4u l=600.0n ng=1
MN0<35> pad gate iovss vsub sg13_hv_nmos m=1 w=4.4u l=600.0n ng=1
MN0<36> pad gate iovss vsub sg13_hv_nmos m=1 w=4.4u l=600.0n ng=1
MN0<37> pad gate iovss vsub sg13_hv_nmos m=1 w=4.4u l=600.0n ng=1
MN0<38> pad gate iovss vsub sg13_hv_nmos m=1 w=4.4u l=600.0n ng=1
MN0<39> pad gate iovss vsub sg13_hv_nmos m=1 w=4.4u l=600.0n ng=1
MN0<40> pad gate iovss vsub sg13_hv_nmos m=1 w=4.4u l=600.0n ng=1
MN0<41> pad gate iovss vsub sg13_hv_nmos m=1 w=4.4u l=600.0n ng=1
MN0<42> pad gate iovss vsub sg13_hv_nmos m=1 w=4.4u l=600.0n ng=1
MN0<43> pad gate iovss vsub sg13_hv_nmos m=1 w=4.4u l=600.0n ng=1
MN0<44> pad gate iovss vsub sg13_hv_nmos m=1 w=4.4u l=600.0n ng=1
MN0<45> pad gate iovss vsub sg13_hv_nmos m=1 w=4.4u l=600.0n ng=1
MN0<46> pad gate iovss vsub sg13_hv_nmos m=1 w=4.4u l=600.0n ng=1
MN0<47> pad gate iovss vsub sg13_hv_nmos m=1 w=4.4u l=600.0n ng=1
MN0<48> pad gate iovss vsub sg13_hv_nmos m=1 w=4.4u l=600.0n ng=1
MN0<49> pad gate iovss vsub sg13_hv_nmos m=1 w=4.4u l=600.0n ng=1
MN0<50> pad gate iovss vsub sg13_hv_nmos m=1 w=4.4u l=600.0n ng=1
MN0<51> pad gate iovss vsub sg13_hv_nmos m=1 w=4.4u l=600.0n ng=1
MN0<52> pad gate iovss vsub sg13_hv_nmos m=1 w=4.4u l=600.0n ng=1
MN0<53> pad gate iovss vsub sg13_hv_nmos m=1 w=4.4u l=600.0n ng=1
MN0<54> pad gate iovss vsub sg13_hv_nmos m=1 w=4.4u l=600.0n ng=1
MN0<55> pad gate iovss vsub sg13_hv_nmos m=1 w=4.4u l=600.0n ng=1
MN0<56> pad gate iovss vsub sg13_hv_nmos m=1 w=4.4u l=600.0n ng=1
MN0<57> pad gate iovss vsub sg13_hv_nmos m=1 w=4.4u l=600.0n ng=1
MN0<58> pad gate iovss vsub sg13_hv_nmos m=1 w=4.4u l=600.0n ng=1
MN0<59> pad gate iovss vsub sg13_hv_nmos m=1 w=4.4u l=600.0n ng=1
MN0<60> pad gate iovss vsub sg13_hv_nmos m=1 w=4.4u l=600.0n ng=1
MN0<61> pad gate iovss vsub sg13_hv_nmos m=1 w=4.4u l=600.0n ng=1
MN0<62> pad gate iovss vsub sg13_hv_nmos m=1 w=4.4u l=600.0n ng=1
MN0<63> pad gate iovss vsub sg13_hv_nmos m=1 w=4.4u l=600.0n ng=1
MN0<64> pad gate iovss vsub sg13_hv_nmos m=1 w=4.4u l=600.0n ng=1
MN0<65> pad gate iovss vsub sg13_hv_nmos m=1 w=4.4u l=600.0n ng=1
MN0<66> pad gate iovss vsub sg13_hv_nmos m=1 w=4.4u l=600.0n ng=1
MN0<67> pad gate iovss vsub sg13_hv_nmos m=1 w=4.4u l=600.0n ng=1
MN0<68> pad gate iovss vsub sg13_hv_nmos m=1 w=4.4u l=600.0n ng=1
MN0<69> pad gate iovss vsub sg13_hv_nmos m=1 w=4.4u l=600.0n ng=1
MN0<70> pad gate iovss vsub sg13_hv_nmos m=1 w=4.4u l=600.0n ng=1
MN0<71> pad gate iovss vsub sg13_hv_nmos m=1 w=4.4u l=600.0n ng=1
MN0<72> pad gate iovss vsub sg13_hv_nmos m=1 w=4.4u l=600.0n ng=1
MN0<73> pad gate iovss vsub sg13_hv_nmos m=1 w=4.4u l=600.0n ng=1
MN0<74> pad gate iovss vsub sg13_hv_nmos m=1 w=4.4u l=600.0n ng=1
MN0<75> pad gate iovss vsub sg13_hv_nmos m=1 w=4.4u l=600.0n ng=1
MN0<76> pad gate iovss vsub sg13_hv_nmos m=1 w=4.4u l=600.0n ng=1
MN0<77> pad gate iovss vsub sg13_hv_nmos m=1 w=4.4u l=600.0n ng=1
MN0<78> pad gate iovss vsub sg13_hv_nmos m=1 w=4.4u l=600.0n ng=1
MN0<79> pad gate iovss vsub sg13_hv_nmos m=1 w=4.4u l=600.0n ng=1
MN0<80> pad gate iovss vsub sg13_hv_nmos m=1 w=4.4u l=600.0n ng=1
MN0<81> pad gate iovss vsub sg13_hv_nmos m=1 w=4.4u l=600.0n ng=1
MN0<82> pad gate iovss vsub sg13_hv_nmos m=1 w=4.4u l=600.0n ng=1
MN0<83> pad gate iovss vsub sg13_hv_nmos m=1 w=4.4u l=600.0n ng=1
MN0<84> pad gate iovss vsub sg13_hv_nmos m=1 w=4.4u l=600.0n ng=1
MN0<85> pad gate iovss vsub sg13_hv_nmos m=1 w=4.4u l=600.0n ng=1
MN0<86> pad gate iovss vsub sg13_hv_nmos m=1 w=4.4u l=600.0n ng=1
MN0<87> pad gate iovss vsub sg13_hv_nmos m=1 w=4.4u l=600.0n ng=1
MN0<88> pad gate iovss vsub sg13_hv_nmos m=1 w=4.4u l=600.0n ng=1
MN0<89> pad gate iovss vsub sg13_hv_nmos m=1 w=4.4u l=600.0n ng=1
MN0<90> pad gate iovss vsub sg13_hv_nmos m=1 w=4.4u l=600.0n ng=1
MN0<91> pad gate iovss vsub sg13_hv_nmos m=1 w=4.4u l=600.0n ng=1
MN0<92> pad gate iovss vsub sg13_hv_nmos m=1 w=4.4u l=600.0n ng=1
MN0<93> pad gate iovss vsub sg13_hv_nmos m=1 w=4.4u l=600.0n ng=1
MN0<94> pad gate iovss vsub sg13_hv_nmos m=1 w=4.4u l=600.0n ng=1
MN0<95> pad gate iovss vsub sg13_hv_nmos m=1 w=4.4u l=600.0n ng=1
MN0<96> pad gate iovss vsub sg13_hv_nmos m=1 w=4.4u l=600.0n ng=1
MN0<97> pad gate iovss vsub sg13_hv_nmos m=1 w=4.4u l=600.0n ng=1
MN0<98> pad gate iovss vsub sg13_hv_nmos m=1 w=4.4u l=600.0n ng=1
MN0<99> pad gate iovss vsub sg13_hv_nmos m=1 w=4.4u l=600.0n ng=1
MN0<100> pad gate iovss vsub sg13_hv_nmos m=1 w=4.4u l=600.0n ng=1
MN0<101> pad gate iovss vsub sg13_hv_nmos m=1 w=4.4u l=600.0n ng=1
MN0<102> pad gate iovss vsub sg13_hv_nmos m=1 w=4.4u l=600.0n ng=1
MN0<103> pad gate iovss vsub sg13_hv_nmos m=1 w=4.4u l=600.0n ng=1
MN0<104> pad gate iovss vsub sg13_hv_nmos m=1 w=4.4u l=600.0n ng=1
MN0<105> pad gate iovss vsub sg13_hv_nmos m=1 w=4.4u l=600.0n ng=1
MN0<106> pad gate iovss vsub sg13_hv_nmos m=1 w=4.4u l=600.0n ng=1
MN0<107> pad gate iovss vsub sg13_hv_nmos m=1 w=4.4u l=600.0n ng=1
MN0<108> pad gate iovss vsub sg13_hv_nmos m=1 w=4.4u l=600.0n ng=1
MN0<109> pad gate iovss vsub sg13_hv_nmos m=1 w=4.4u l=600.0n ng=1
MN0<110> pad gate iovss vsub sg13_hv_nmos m=1 w=4.4u l=600.0n ng=1
MN0<111> pad gate iovss vsub sg13_hv_nmos m=1 w=4.4u l=600.0n ng=1
MN0<112> pad gate iovss vsub sg13_hv_nmos m=1 w=4.4u l=600.0n ng=1
MN0<113> pad gate iovss vsub sg13_hv_nmos m=1 w=4.4u l=600.0n ng=1
MN0<114> pad gate iovss vsub sg13_hv_nmos m=1 w=4.4u l=600.0n ng=1
MN0<115> pad gate iovss vsub sg13_hv_nmos m=1 w=4.4u l=600.0n ng=1
MN0<116> pad gate iovss vsub sg13_hv_nmos m=1 w=4.4u l=600.0n ng=1
MN0<117> pad gate iovss vsub sg13_hv_nmos m=1 w=4.4u l=600.0n ng=1
MN0<118> pad gate iovss vsub sg13_hv_nmos m=1 w=4.4u l=600.0n ng=1
MN0<119> pad gate iovss vsub sg13_hv_nmos m=1 w=4.4u l=600.0n ng=1
MN0<120> pad gate iovss vsub sg13_hv_nmos m=1 w=4.4u l=600.0n ng=1
MN0<121> pad gate iovss vsub sg13_hv_nmos m=1 w=4.4u l=600.0n ng=1
MN0<122> pad gate iovss vsub sg13_hv_nmos m=1 w=4.4u l=600.0n ng=1
MN0<123> pad gate iovss vsub sg13_hv_nmos m=1 w=4.4u l=600.0n ng=1
MN0<124> pad gate iovss vsub sg13_hv_nmos m=1 w=4.4u l=600.0n ng=1
MN0<125> pad gate iovss vsub sg13_hv_nmos m=1 w=4.4u l=600.0n ng=1
MN0<126> pad gate iovss vsub sg13_hv_nmos m=1 w=4.4u l=600.0n ng=1
MN0<127> pad gate iovss vsub sg13_hv_nmos m=1 w=4.4u l=600.0n ng=1
MN0<128> pad gate iovss vsub sg13_hv_nmos m=1 w=4.4u l=600.0n ng=1
MN0<129> pad gate iovss vsub sg13_hv_nmos m=1 w=4.4u l=600.0n ng=1
MN0<130> pad gate iovss vsub sg13_hv_nmos m=1 w=4.4u l=600.0n ng=1
MN0<131> pad gate iovss vsub sg13_hv_nmos m=1 w=4.4u l=600.0n ng=1
MN0<132> pad gate iovss vsub sg13_hv_nmos m=1 w=4.4u l=600.0n ng=1
MN0<133> pad gate iovss vsub sg13_hv_nmos m=1 w=4.4u l=600.0n ng=1
MN0<134> pad gate iovss vsub sg13_hv_nmos m=1 w=4.4u l=600.0n ng=1
MN0<135> pad gate iovss vsub sg13_hv_nmos m=1 w=4.4u l=600.0n ng=1
MN0<136> pad gate iovss vsub sg13_hv_nmos m=1 w=4.4u l=600.0n ng=1
MN0<137> pad gate iovss vsub sg13_hv_nmos m=1 w=4.4u l=600.0n ng=1
MN0<138> pad gate iovss vsub sg13_hv_nmos m=1 w=4.4u l=600.0n ng=1
MN0<139> pad gate iovss vsub sg13_hv_nmos m=1 w=4.4u l=600.0n ng=1
MN0<140> pad gate iovss vsub sg13_hv_nmos m=1 w=4.4u l=600.0n ng=1
MN0<141> pad gate iovss vsub sg13_hv_nmos m=1 w=4.4u l=600.0n ng=1
MN0<142> pad gate iovss vsub sg13_hv_nmos m=1 w=4.4u l=600.0n ng=1
MN0<143> pad gate iovss vsub sg13_hv_nmos m=1 w=4.4u l=600.0n ng=1
MN0<144> pad gate iovss vsub sg13_hv_nmos m=1 w=4.4u l=600.0n ng=1
MN0<145> pad gate iovss vsub sg13_hv_nmos m=1 w=4.4u l=600.0n ng=1
MN0<146> pad gate iovss vsub sg13_hv_nmos m=1 w=4.4u l=600.0n ng=1
MN0<147> pad gate iovss vsub sg13_hv_nmos m=1 w=4.4u l=600.0n ng=1
MN0<148> pad gate iovss vsub sg13_hv_nmos m=1 w=4.4u l=600.0n ng=1
MN0<149> pad gate iovss vsub sg13_hv_nmos m=1 w=4.4u l=600.0n ng=1
MN0<150> pad gate iovss vsub sg13_hv_nmos m=1 w=4.4u l=600.0n ng=1
MN0<151> pad gate iovss vsub sg13_hv_nmos m=1 w=4.4u l=600.0n ng=1
MN0<152> pad gate iovss vsub sg13_hv_nmos m=1 w=4.4u l=600.0n ng=1
MN0<153> pad gate iovss vsub sg13_hv_nmos m=1 w=4.4u l=600.0n ng=1
MN0<154> pad gate iovss vsub sg13_hv_nmos m=1 w=4.4u l=600.0n ng=1
MN0<155> pad gate iovss vsub sg13_hv_nmos m=1 w=4.4u l=600.0n ng=1
MN0<156> pad gate iovss vsub sg13_hv_nmos m=1 w=4.4u l=600.0n ng=1
MN0<157> pad gate iovss vsub sg13_hv_nmos m=1 w=4.4u l=600.0n ng=1
MN0<158> pad gate iovss vsub sg13_hv_nmos m=1 w=4.4u l=600.0n ng=1
MN0<159> pad gate iovss vsub sg13_hv_nmos m=1 w=4.4u l=600.0n ng=1
MN0<160> pad gate iovss vsub sg13_hv_nmos m=1 w=4.4u l=600.0n ng=1
MN0<161> pad gate iovss vsub sg13_hv_nmos m=1 w=4.4u l=600.0n ng=1
MN0<162> pad gate iovss vsub sg13_hv_nmos m=1 w=4.4u l=600.0n ng=1
MN0<163> pad gate iovss vsub sg13_hv_nmos m=1 w=4.4u l=600.0n ng=1
MN0<164> pad gate iovss vsub sg13_hv_nmos m=1 w=4.4u l=600.0n ng=1
MN0<165> pad gate iovss vsub sg13_hv_nmos m=1 w=4.4u l=600.0n ng=1
MN0<166> pad gate iovss vsub sg13_hv_nmos m=1 w=4.4u l=600.0n ng=1
MN0<167> pad gate iovss vsub sg13_hv_nmos m=1 w=4.4u l=600.0n ng=1
MN0<168> pad gate iovss vsub sg13_hv_nmos m=1 w=4.4u l=600.0n ng=1
MN0<169> pad gate iovss vsub sg13_hv_nmos m=1 w=4.4u l=600.0n ng=1
MN0<170> pad gate iovss vsub sg13_hv_nmos m=1 w=4.4u l=600.0n ng=1
MN0<171> pad gate iovss vsub sg13_hv_nmos m=1 w=4.4u l=600.0n ng=1
MN0<172> pad gate iovss vsub sg13_hv_nmos m=1 w=4.4u l=600.0n ng=1
DD0 vsub gate dantenna m=1 w=480n l=480n a=230.4f p=1.92u
.ends sg13cmos5l_Clamp_N43N43D4R

.subckt sg13cmos5l_IOPadOut30mA pad c2p vdd vss iovdd iovss vsub
XI2 net2 net1 iovdd c2p vdd vss vsub sg13cmos5l_GateLevelUpInv
XI1 net1 iovdd iovss pad sg13cmos5l_Clamp_P15N15D
XI3 net2 iovss pad vsub sg13cmos5l_Clamp_N15N15D
XI4 iovss pad iovdd vsub sg13cmos5l_DCNDiode
XI0 pad iovdd iovss sg13cmos5l_DCPDiode
.ends sg13cmos5l_IOPadOut30mA

.subckt sg13cmos5l_Clamp_N15N15D gate iovss pad vsub
MN0 pad gate iovss vsub sg13_hv_nmos m=1 w=66.000u l=600.0n ng=15
DD0 vsub gate dantenna m=1 w=780.00n l=780.00n a=608.400f p=3.12u
.ends sg13cmos5l_Clamp_N15N15D

.subckt sg13cmos5l_Clamp_P15N15D gate iovdd iovss pad
DD0 gate iovdd dpantenna m=1 w=780.00n l=780.00n a=608.400f p=3.12u
MP1 pad gate iovdd iovdd sg13_hv_pmos m=1 w=99.9u l=600.0n ng=15
MP0 pad gate iovdd iovdd sg13_hv_pmos m=1 w=99.9u l=600.0n ng=15
.ends sg13cmos5l_Clamp_P15N15D

.subckt sg13cmos5l_GateLevelUpInv ngate pgate iovdd core vdd vss vsub
XI1 pgate core iovdd vdd vss vsub sg13cmos5l_LevelUpInv
XI0 ngate core iovdd vdd vss vsub sg13cmos5l_LevelUpInv
.ends sg13cmos5l_GateLevelUpInv

.subckt sg13cmos5l_LevelUpInv o i iovdd vdd vss vsub
MN1 net2 i vss vsub sg13_lv_nmos m=1 w=2.75u l=130.00n ng=1
MP3 net2 i vdd vdd sg13_lv_pmos m=1 w=4.75u l=130.00n ng=1
MN0 o net4 vss vsub sg13_hv_nmos m=1 w=1.9u l=450.00n ng=1
MN3 net4 net2 vss vsub sg13_hv_nmos m=1 w=1.9u l=450.00n ng=1
MN2 net3 i vss vsub sg13_hv_nmos m=1 w=1.9u l=450.00n ng=1
MP0 o net4 iovdd iovdd sg13_hv_pmos m=1 w=3.9u l=450.00n ng=1
MP1 net3 net4 iovdd iovdd sg13_hv_pmos m=1 w=300.0n l=450.00n ng=1
MP2 net4 net3 iovdd iovdd sg13_hv_pmos m=1 w=300.0n l=450.00n ng=1
.ends sg13cmos5l_LevelUpInv

.subckt sg13cmos5l_IOPadIn pad p2c vdd vss iovdd iovss vsub
XI0 p2c pad iovdd iovss vdd vss vsub sg13cmos5l_LevelDown
XI2 iovss pad iovdd vsub sg13cmos5l_DCNDiode
XI1 pad iovdd iovss sg13cmos5l_DCPDiode
.ends sg13cmos5l_IOPadIn

.subckt sg13cmos5l_LevelDown core pad iovdd iovss vdd vss vsub
MP0 vdd vdd vdd vdd sg13_hv_pmos m=1 w=4.65u l=450.00n ng=1
MP2 net4 net7 iovdd iovdd sg13_hv_pmos m=1 w=4.6u l=450.00n ng=2
MP3 net7 net1 iovdd iovdd sg13_hv_pmos m=1 w=4.6u l=450.00n ng=2
MN3 net4 net7 iovss vsub sg13_hv_nmos m=1 w=1.3u l=450.00n ng=1
MN4 net7 net1 iovss vsub sg13_hv_nmos m=1 w=1.3u l=450.00n ng=1
MN2 net2 net4 vss vsub sg13_hv_nmos m=1 w=2.65u l=450.00n ng=1
MN0 vdd net7 net2 vsub sg13_hv_nmos m=1 w=2.65u l=450.00n ng=1
MN1 core net2 vss vsub sg13_lv_nmos m=1 w=2.75u l=130.00n ng=1
MP1 core net2 vdd vdd sg13_lv_pmos m=1 w=4.75u l=130.00n ng=1
XI0 net1 iovss pad iovdd vsub sg13cmos5l_SecondaryProtection
.ends sg13cmos5l_LevelDown

.subckt sg13cmos5l_SecondaryProtection core minus pad plus vsub
RR0 pad core 586.899 $SUB=vsub $[rppd] m=1 l=2u w=1u b=0 m=1
DD1 vsub core dantenna m=1 w=640n l=3.1u a=1.984p p=7.48u
DD0 core plus dpantenna m=1 w=640n l=4.98u a=3.187p p=11.24u
.ends sg13cmos5l_SecondaryProtection

.subckt sg13cmos5l_IOPadVdd vdd vss iovdd iovss vsub
XI1 net3 iovss vdd vsub sg13cmos5l_Clamp_N43N43D4R
XI4 vdd net1 vsub sg13cmos5l_RCClampResistor
XI3 net3 net1 iovss vdd vsub sg13cmos5l_RCClampInverter
.ends sg13cmos5l_IOPadVdd

.subckt sg13cmos5l_Filler400 vdd vss iovdd iovss
.ends sg13cmos5l_Filler400

.subckt sg13cmos5l_Corner vdd vss iovdd iovss
.ends sg13cmos5l_Corner

.subckt sg13cmos5l_IOPadAnalog pad padres vdd vss iovdd iovss vsub
XI0 iovdd iovss pad sg13cmos5l_Clamp_P20N0D
XI5 iovss pad iovdd vsub sg13cmos5l_DCNDiode
XI2 pad iovdd iovss sg13cmos5l_DCPDiode
XI3 padres iovss pad iovdd vsub sg13cmos5l_SecondaryProtection
XI4 iovss pad vsub sg13cmos5l_Clamp_N20N0D
.ends sg13cmos5l_IOPadAnalog

.subckt sg13cmos5l_Clamp_N20N0D iovss pad vsub
MN0 pad net2 iovss vsub sg13_hv_nmos m=1 w=88.000u l=600.0n ng=20
RR0 iovss net2 1.959K $SUB=vsub $[rppd] l=3.54u w=500n b=0 m=1
.ends sg13cmos5l_Clamp_N20N0D

.subckt sg13cmos5l_Clamp_P20N0D iovdd iovss pad
MP1 pad net2 iovdd iovdd sg13_hv_pmos m=1 w=133.2u l=600.0n ng=20
MP0 pad net2 iovdd iovdd sg13_hv_pmos m=1 w=133.2u l=600.0n ng=20
RR0 net2 iovdd 6.768K $SUB=iovdd $[rppd] l=12.9u w=500n b=0 m=1
.ends sg13cmos5l_Clamp_P20N0D

.subckt sg13cmos5l_IOPadVss vdd vss iovdd iovss vsub
XI1 iovss vss iovdd vsub sg13cmos5l_DCNDiode
XI2 vss iovdd iovss sg13cmos5l_DCPDiode
.ends sg13cmos5l_IOPadVss

.subckt sg13cmos5l_Filler200 vdd vss iovdd iovss
.ends sg13cmos5l_Filler200

.subckt sg13cmos5l_Filler4000 vdd vss iovdd iovss
.ends sg13cmos5l_Filler4000

.subckt sg13cmos5l_Filler1000 vdd vss iovdd iovss
.ends sg13cmos5l_Filler1000

* ------------------------------ std cells ------------------------------
.SUBCKT sg13cmos5l_decap_8 VDD VSS
MN0 VSS VDD VSS VSS sg13_lv_nmos m=1 w=840.00n l=1.000u ng=2
MP0 VDD VSS VDD VDD sg13_lv_pmos m=1 w=2.000u l=1.000u ng=2
.ends sg13cmos5l_decap_8

.SUBCKT sg13cmos5l_decap_4 VDD VSS
MN0 VSS VDD VSS VSS sg13_lv_nmos m=1 w=420.00n l=1.000u ng=1
MP0 VDD VSS VDD VDD sg13_lv_pmos m=1 w=1.000u l=1.000u ng=1
.ends sg13cmos5l_decap_4

* ------------------------------ core ------------------------------
* ======================================================================
* Spectre top + Magic blocks -> SPICE (KLayout LVS) - top2klayout.py v2
* Top    : COMPLETE_PROYECT_FIG
* ======================================================================

**************************************************
* TOP CELL: COMPLETE_PROYECT_FIG
**************************************************

.subckt COMPLETE_PROYECT_FIG EN_WRITE EN_REFERENCE EN_SEARCH reset CLK serial_in_addr OUTPUT serial_in_data VEVAL_IN VDD VSS

XahdlI18 EN_REFERENCE EN_SEARCH EN_WRITE PC VEVAL1 CLK OUTPUT_en reset REF_sel wl_ref addr_shift deco_en
+ shift_en VSS VDD CAM_CONTROL
XahdlI15 REF_sel net48 net137 net135 net133 net131 net129 net127 net125 net123 net121 net119 net46 net117
+ net115 net113 net111 net109 net107 net105 net103 net101 net99 net44 net97 net96 net42 net40 net33 net30
+ net27 net23 net4 RS0 net3 net136 net134 net132 net130 RS15 RS16 net124 net122 net120 RS1 net118 net116
+ net114 net112 net110 net108 net106 net104 net102 net100 RS2 net98 RS31 net43 net41 net34 net31 net29 net25
+ net22 q0n q10n q11n q12n q13n q14n q15n q16n q17n q18n q19n q1n q20n q21n q22n q23n q24n q25n q26n q27n q28n
+ q29n q2n q30n q31n q3n q4n q5n q6n q7n q8n q9n q0 q10 q11 q12 q13 q14 q15 q16 q17 q18 q19 q1 q20 q21 q22 q23
+ q24 q25 q26 q27 q28 q29 q2 q30 q31 q3 q4 q5 q6 q7 q8 q9 VSS VDD REFERENCE_MUX
XahdlI13 VSS VDD deco_en add0 add1 add2 add3 add4 out0 out10 out11 out12 out13 out14 out15 out16 out17 out18
+ out19 out1 out20 out21 out22 out23 out24 out25 out26 out27 out28 out29 out2 out30 out31 out3 out4 out5 out6
+ out7 out8 out9 decoder_5to32
XahdlI14 VSS VDD CLK q0 q10 q11 q12 q13 q14 q15 q16 q17 q18 q19 q1 q20 q21 q22 q23 q24 q25 q26 q27 q28 q29 q2
+ q30 q31 q3 q4 q5 q6 q7 q8 q9 q0n q10n q11n q12n q13n q14n q15n q16n q17n q18n q19n q1n q20n q21n q22n q23n
+ q24n q25n q26n q27n q28n q29n q2n q30n q31n q3n q4n q5n q6n q7n q8n q9n reset serial_in_data_int shift_en
+ shift_register_32
XI21 serial_in_data REF_sel serial_in_data_int VDD VSS Xnor
XahdlI16 VSS VDD CLK COMP0 net154 net153 net152 COMP13 net150 net149 net148 net147 net146 net145 net163 COMP20
+ net143 COMP22 net141 net140 net139 net138 net128 net126 net92 net162 net90 COMP31 net161 net160 COMP5 net158
+ net157 net156 net155 OUTPUT OUTPUT_en reset OUTPUT
XI20 COMP0 net163 net154 net153 net152 COMP13 net150 net149 net148 net147 net146 net145 net162 COMP20 net143
+ COMP22 net141 net140 net139 net138 net128 net126 net92 net161 net90 COMP31 net160 COMP5 net158 net157 net156
+ net155 PC RS0 net48 RS1 net3 net137 net136 net135 net134 net133 net132 net131 net130 net129 RS15 net127 RS16
+ net125 net124 net123 net122 net121 net120 net119 net46 RS2 net118 net117 net116 net115 net114 net113 net112
+ net111 net110 net109 net108 net107 net106 net105 net104 net103 net102 net101 net100 net99 net44 net43 net98
+ net97 RS31 net96 net42 net41 net40 net34 net33 net31 net30 net29 net27 net25 net23 net22 net4 q0 q0n q1 q10
+ q10n q11 q11n q12 q12n q13 q13n q14 q14n q15 q15n q16 q16n q17 q17n q18 q18n q19 q19n q1n q2 q20 q20n q21
+ q21n q22 q22n q23 q23n q24 q24n q25 q25n q26 q26n q27 q27n q28 q28n q29 q29n q2n q3 q30 q30n q31 q31n q3n q4
+ q4n q5 q5n q6 q6n q7 q7n q8 q8n q9 q9n VDD VEVAL VSS wl_ref out0 out1 out10 out11 out12 out13 out14 out15
+ out16 out17 out18 out19 out2 out20 out21 out22 out23 out24 out25 out26 out27 out28 out29 out3 out30 out31
+ out4 out5 out6 out7 out8 out9 ANALOG_FIGURE
XahdlI12 VSS VDD add0 add1 add2 add3 add4 addr_shift CLK reset serial_in_addr SHIFT_5
* VEVAL driver: inverter supplied by the external analog input VEVAL_IN
MN0 VEVAL VEVAL1 VSS VSS sg13_lv_nmos w=500n l=130n ng=1 m=1
MP0 VEVAL VEVAL1 VEVAL_IN VEVAL_IN sg13_lv_pmos w=15u l=130n ng=1 m=1

.ends COMPLETE_PROYECT_FIG

**************************************************
* SUBCKT: INV
**************************************************

.subckt INV GND IN VDD Y

MN0 Y IN GND GND sg13_lv_nmos w=200n l=130n ng=1 m=1
MP0 Y IN VDD VDD sg13_lv_pmos w=400n l=130n ng=1 m=1

.ends INV

**************************************************
* SUBCKT: Xnor
**************************************************

.subckt Xnor A B OUT VDD VSS

XI3 VSS net3 VDD OUT INV
XI2 VSS net2 VDD net3 INV
XI0 VSS B VDD net1 INV
MN0 net2 A B VSS sg13_lv_nmos w=200n l=130n ng=1 m=1
MP0 net2 A net1 VDD sg13_lv_pmos w=400n l=130n ng=1 m=1

.ends Xnor

**************************************************
* SUBCKT: BUFFER
**************************************************

.subckt BUFFER OUTP OUTPRE VDD VSS

MN0 OUTP medio VSS VSS sg13_lv_nmos w=3u l=130n ng=1 m=1
MP0 OUTP medio VDD VDD sg13_lv_pmos w=6u l=130n ng=1 m=1
XI306 VSS OUTPRE VDD medio INV

.ends BUFFER

**************************************************
* SUBCKT: CELL
**************************************************

.subckt CELL ML SL SL_N VDD VEVAL VSS WL

XI7 VSS net1 VDD net2 INV
XI4 VSS net2 VDD net1 INV
MN5 net11 VEVAL VSS VSS sg13_lv_nmos w=350n l=130n ng=1 m=1
MN4 net11 net3 ML VSS sg13_lv_nmos w=740n l=130n ng=1 m=1
MN3 net3 net2 SL VSS sg13_lv_nmos w=740n l=130n ng=1 m=1
MN2 net3 net1 SL_N VSS sg13_lv_nmos w=740n l=130n ng=1 m=1
MN1 SL_N WL net1 VSS sg13_lv_nmos w=740n l=130n ng=1 m=1
MN0 SL WL net2 VSS sg13_lv_nmos w=740n l=130n ng=1 m=1

.ends CELL

**************************************************
* SUBCKT: WORD_32bits
**************************************************

.subckt WORD_32bits ML SL_0 SL_0N SL_1 SL_10 SL_10N SL_11 SL_11N SL_12 SL_12N SL_13 SL_13N SL_14 SL_14N SL_15
+ SL_15N SL_16 SL_16N SL_17 SL_17N SL_18 SL_18N SL_19 SL_19N SL_1N SL_2 SL_20 SL_20N SL_21 SL_21N SL_22 SL_22N
+ SL_23 SL_23N SL_24 SL_24N SL_25 SL_25N SL_26 SL_26N SL_27 SL_27N SL_28 SL_28N SL_29 SL_29N SL_2N SL_3 SL_30
+ SL_30N SL_31 SL_31N SL_3N SL_4 SL_4N SL_5 SL_5N SL_6 SL_6N SL_7 SL_7N SL_8 SL_8N SL_9 SL_9N VDD VEVAL VSS WL
+ pc

XI31 ML SL_27 SL_27N VDD VEVAL VSS WL CELL
XI30 ML SL_24 SL_24N VDD VEVAL VSS WL CELL
XI29 ML SL_25 SL_25N VDD VEVAL VSS WL CELL
XI28 ML SL_26 SL_26N VDD VEVAL VSS WL CELL
XI27 ML SL_28 SL_28N VDD VEVAL VSS WL CELL
XI26 ML SL_29 SL_29N VDD VEVAL VSS WL CELL
XI25 ML SL_30 SL_30N VDD VEVAL VSS WL CELL
XI24 ML SL_31 SL_31N VDD VEVAL VSS WL CELL
XI23 ML SL_19 SL_19N VDD VEVAL VSS WL CELL
XI22 ML SL_16 SL_16N VDD VEVAL VSS WL CELL
XI21 ML SL_17 SL_17N VDD VEVAL VSS WL CELL
XI20 ML SL_18 SL_18N VDD VEVAL VSS WL CELL
XI19 ML SL_20 SL_20N VDD VEVAL VSS WL CELL
XI18 ML SL_21 SL_21N VDD VEVAL VSS WL CELL
XI17 ML SL_22 SL_22N VDD VEVAL VSS WL CELL
XI15 ML SL_11 SL_11N VDD VEVAL VSS WL CELL
XI14 ML SL_8 SL_8N VDD VEVAL VSS WL CELL
XI13 ML SL_9 SL_9N VDD VEVAL VSS WL CELL
XI12 ML SL_10 SL_10N VDD VEVAL VSS WL CELL
XI10 ML SL_12 SL_12N VDD VEVAL VSS WL CELL
XI6 ML SL_13 SL_13N VDD VEVAL VSS WL CELL
XI2 ML SL_14 SL_14N VDD VEVAL VSS WL CELL
XI1 ML SL_15 SL_15N VDD VEVAL VSS WL CELL
XI11 ML SL_3 SL_3N VDD VEVAL VSS WL CELL
XI9 ML SL_0 SL_0N VDD VEVAL VSS WL CELL
XI8 ML SL_1 SL_1N VDD VEVAL VSS WL CELL
XI7 ML SL_2 SL_2N VDD VEVAL VSS WL CELL
XI5 ML SL_4 SL_4N VDD VEVAL VSS WL CELL
XI4 ML SL_5 SL_5N VDD VEVAL VSS WL CELL
XI3 ML SL_6 SL_6N VDD VEVAL VSS WL CELL
XI0 ML SL_7 SL_7N VDD VEVAL VSS WL CELL
XI16 ML SL_23 SL_23N VDD VEVAL VSS WL CELL
MP0 ML pc VDD VDD sg13_lv_pmos w=2u l=130n ng=1 m=1

.ends WORD_32bits

**************************************************
* SUBCKT: reference_complete
**************************************************

.subckt reference_complete REFSENS SL_0 SL_0N SL_1 SL_10 SL_10N SL_11 SL_11N SL_12 SL_12N SL_13 SL_13N SL_14
+ SL_14N SL_15 SL_15N SL_16 SL_16N SL_17 SL_17N SL_18 SL_18N SL_19 SL_19N SL_1N SL_2 SL_20 SL_20N SL_21 SL_21N
+ SL_22 SL_22N SL_23 SL_23N SL_24 SL_24N SL_25 SL_25N SL_26 SL_26N SL_27 SL_27N SL_28 SL_28N SL_29 SL_29N
+ SL_2N SL_3 SL_30 SL_30N SL_31 SL_31N SL_3N SL_4 SL_4N SL_5 SL_5N SL_6 SL_6N SL_7 SL_7N SL_8 SL_8N SL_9 SL_9N
+ VDD VEVAL VSS WL pc

XI311 REFSENS net1 VDD VSS BUFFER
XI323 VSS ML_ref VDD net1 INV
XI0 ML_ref SL_0 SL_0N SL_1 SL_10 SL_10N SL_11 SL_11N SL_12 SL_12N SL_13 SL_13N SL_14 SL_14N SL_15 SL_15N SL_16
+ SL_16N SL_17 SL_17N SL_18 SL_18N SL_19 SL_19N SL_1N SL_2 SL_20 SL_20N SL_21 SL_21N SL_22 SL_22N SL_23 SL_23N
+ SL_24 SL_24N SL_25 SL_25N SL_26 SL_26N SL_27 SL_27N SL_28 SL_28N SL_29 SL_29N SL_2N SL_3 SL_30 SL_30N SL_31
+ SL_31N SL_3N SL_4 SL_4N SL_5 SL_5N SL_6 SL_6N SL_7 SL_7N SL_8 SL_8N SL_9 SL_9N VDD VEVAL VSS WL pc
+ WORD_32bits

.ends reference_complete

**************************************************
* SUBCKT: ARRAY_32x32
**************************************************

.subckt ARRAY_32x32 ML_0 ML_1 ML_10 ML_11 ML_12 ML_13 ML_14 ML_15 ML_16 ML_17 ML_18 ML_19 ML_2 ML_20 ML_21
+ ML_22 ML_23 ML_24 ML_25 ML_26 ML_27 ML_28 ML_29 ML_3 ML_30 ML_31 ML_4 ML_5 ML_6 ML_7 ML_8 ML_9 SL_0 SL_0N
+ SL_1 SL_10 SL_10N SL_11 SL_11N SL_12 SL_12N SL_13 SL_13N SL_14 SL_14N SL_15 SL_15N SL_16 SL_16N SL_17 SL_17N
+ SL_18 SL_18N SL_19 SL_19N SL_1N SL_2 SL_20 SL_20N SL_21 SL_21N SL_22 SL_22N SL_23 SL_23N SL_24 SL_24N SL_25
+ SL_25N SL_26 SL_26N SL_27 SL_27N SL_28 SL_28N SL_29 SL_29N SL_2N SL_3 SL_30 SL_30N SL_31 SL_31N SL_3N SL_4
+ SL_4N SL_5 SL_5N SL_6 SL_6N SL_7 SL_7N SL_8 SL_8N SL_9 SL_9N VDD VEVAL VSS WL_0 WL_1 WL_10 WL_11 WL_12 WL_13
+ WL_14 WL_15 WL_16 WL_17 WL_18 WL_19 WL_2 WL_20 WL_21 WL_22 WL_23 WL_24 WL_25 WL_26 WL_27 WL_28 WL_29 WL_3
+ WL_30 WL_31 WL_4 WL_5 WL_6 WL_7 WL_8 WL_9 pc

XI25 ML_14 SL_0 SL_0N SL_1 SL_10 SL_10N SL_11 SL_11N SL_12 SL_12N SL_13 SL_13N SL_14 SL_14N SL_15 SL_15N SL_16
+ SL_16N SL_17 SL_17N SL_18 SL_18N SL_19 SL_19N SL_1N SL_2 SL_20 SL_20N SL_21 SL_21N SL_22 SL_22N SL_23 SL_23N
+ SL_24 SL_24N SL_25 SL_25N SL_26 SL_26N SL_27 SL_27N SL_28 SL_28N SL_29 SL_29N SL_2N SL_3 SL_30 SL_30N SL_31
+ SL_31N SL_3N SL_4 SL_4N SL_5 SL_5N SL_6 SL_6N SL_7 SL_7N SL_8 SL_8N SL_9 SL_9N VDD VEVAL VSS WL_14 pc
+ WORD_32bits
XI24 ML_13 SL_0 SL_0N SL_1 SL_10 SL_10N SL_11 SL_11N SL_12 SL_12N SL_13 SL_13N SL_14 SL_14N SL_15 SL_15N SL_16
+ SL_16N SL_17 SL_17N SL_18 SL_18N SL_19 SL_19N SL_1N SL_2 SL_20 SL_20N SL_21 SL_21N SL_22 SL_22N SL_23 SL_23N
+ SL_24 SL_24N SL_25 SL_25N SL_26 SL_26N SL_27 SL_27N SL_28 SL_28N SL_29 SL_29N SL_2N SL_3 SL_30 SL_30N SL_31
+ SL_31N SL_3N SL_4 SL_4N SL_5 SL_5N SL_6 SL_6N SL_7 SL_7N SL_8 SL_8N SL_9 SL_9N VDD VEVAL VSS WL_13 pc
+ WORD_32bits
XI23 ML_12 SL_0 SL_0N SL_1 SL_10 SL_10N SL_11 SL_11N SL_12 SL_12N SL_13 SL_13N SL_14 SL_14N SL_15 SL_15N SL_16
+ SL_16N SL_17 SL_17N SL_18 SL_18N SL_19 SL_19N SL_1N SL_2 SL_20 SL_20N SL_21 SL_21N SL_22 SL_22N SL_23 SL_23N
+ SL_24 SL_24N SL_25 SL_25N SL_26 SL_26N SL_27 SL_27N SL_28 SL_28N SL_29 SL_29N SL_2N SL_3 SL_30 SL_30N SL_31
+ SL_31N SL_3N SL_4 SL_4N SL_5 SL_5N SL_6 SL_6N SL_7 SL_7N SL_8 SL_8N SL_9 SL_9N VDD VEVAL VSS WL_12 pc
+ WORD_32bits
XI47 ML_17 SL_0 SL_0N SL_1 SL_10 SL_10N SL_11 SL_11N SL_12 SL_12N SL_13 SL_13N SL_14 SL_14N SL_15 SL_15N SL_16
+ SL_16N SL_17 SL_17N SL_18 SL_18N SL_19 SL_19N SL_1N SL_2 SL_20 SL_20N SL_21 SL_21N SL_22 SL_22N SL_23 SL_23N
+ SL_24 SL_24N SL_25 SL_25N SL_26 SL_26N SL_27 SL_27N SL_28 SL_28N SL_29 SL_29N SL_2N SL_3 SL_30 SL_30N SL_31
+ SL_31N SL_3N SL_4 SL_4N SL_5 SL_5N SL_6 SL_6N SL_7 SL_7N SL_8 SL_8N SL_9 SL_9N VDD VEVAL VSS WL_17 pc
+ WORD_32bits
XI43 ML_18 SL_0 SL_0N SL_1 SL_10 SL_10N SL_11 SL_11N SL_12 SL_12N SL_13 SL_13N SL_14 SL_14N SL_15 SL_15N SL_16
+ SL_16N SL_17 SL_17N SL_18 SL_18N SL_19 SL_19N SL_1N SL_2 SL_20 SL_20N SL_21 SL_21N SL_22 SL_22N SL_23 SL_23N
+ SL_24 SL_24N SL_25 SL_25N SL_26 SL_26N SL_27 SL_27N SL_28 SL_28N SL_29 SL_29N SL_2N SL_3 SL_30 SL_30N SL_31
+ SL_31N SL_3N SL_4 SL_4N SL_5 SL_5N SL_6 SL_6N SL_7 SL_7N SL_8 SL_8N SL_9 SL_9N VDD VEVAL VSS WL_18 pc
+ WORD_32bits
XI49 ML_16 SL_0 SL_0N SL_1 SL_10 SL_10N SL_11 SL_11N SL_12 SL_12N SL_13 SL_13N SL_14 SL_14N SL_15 SL_15N SL_16
+ SL_16N SL_17 SL_17N SL_18 SL_18N SL_19 SL_19N SL_1N SL_2 SL_20 SL_20N SL_21 SL_21N SL_22 SL_22N SL_23 SL_23N
+ SL_24 SL_24N SL_25 SL_25N SL_26 SL_26N SL_27 SL_27N SL_28 SL_28N SL_29 SL_29N SL_2N SL_3 SL_30 SL_30N SL_31
+ SL_31N SL_3N SL_4 SL_4N SL_5 SL_5N SL_6 SL_6N SL_7 SL_7N SL_8 SL_8N SL_9 SL_9N VDD VEVAL VSS WL_16 pc
+ WORD_32bits
XI46 ML_22 SL_0 SL_0N SL_1 SL_10 SL_10N SL_11 SL_11N SL_12 SL_12N SL_13 SL_13N SL_14 SL_14N SL_15 SL_15N SL_16
+ SL_16N SL_17 SL_17N SL_18 SL_18N SL_19 SL_19N SL_1N SL_2 SL_20 SL_20N SL_21 SL_21N SL_22 SL_22N SL_23 SL_23N
+ SL_24 SL_24N SL_25 SL_25N SL_26 SL_26N SL_27 SL_27N SL_28 SL_28N SL_29 SL_29N SL_2N SL_3 SL_30 SL_30N SL_31
+ SL_31N SL_3N SL_4 SL_4N SL_5 SL_5N SL_6 SL_6N SL_7 SL_7N SL_8 SL_8N SL_9 SL_9N VDD VEVAL VSS WL_22 pc
+ WORD_32bits
XI48 ML_21 SL_0 SL_0N SL_1 SL_10 SL_10N SL_11 SL_11N SL_12 SL_12N SL_13 SL_13N SL_14 SL_14N SL_15 SL_15N SL_16
+ SL_16N SL_17 SL_17N SL_18 SL_18N SL_19 SL_19N SL_1N SL_2 SL_20 SL_20N SL_21 SL_21N SL_22 SL_22N SL_23 SL_23N
+ SL_24 SL_24N SL_25 SL_25N SL_26 SL_26N SL_27 SL_27N SL_28 SL_28N SL_29 SL_29N SL_2N SL_3 SL_30 SL_30N SL_31
+ SL_31N SL_3N SL_4 SL_4N SL_5 SL_5N SL_6 SL_6N SL_7 SL_7N SL_8 SL_8N SL_9 SL_9N VDD VEVAL VSS WL_21 pc
+ WORD_32bits
XI44 ML_19 SL_0 SL_0N SL_1 SL_10 SL_10N SL_11 SL_11N SL_12 SL_12N SL_13 SL_13N SL_14 SL_14N SL_15 SL_15N SL_16
+ SL_16N SL_17 SL_17N SL_18 SL_18N SL_19 SL_19N SL_1N SL_2 SL_20 SL_20N SL_21 SL_21N SL_22 SL_22N SL_23 SL_23N
+ SL_24 SL_24N SL_25 SL_25N SL_26 SL_26N SL_27 SL_27N SL_28 SL_28N SL_29 SL_29N SL_2N SL_3 SL_30 SL_30N SL_31
+ SL_31N SL_3N SL_4 SL_4N SL_5 SL_5N SL_6 SL_6N SL_7 SL_7N SL_8 SL_8N SL_9 SL_9N VDD VEVAL VSS WL_19 pc
+ WORD_32bits
XI45 ML_23 SL_0 SL_0N SL_1 SL_10 SL_10N SL_11 SL_11N SL_12 SL_12N SL_13 SL_13N SL_14 SL_14N SL_15 SL_15N SL_16
+ SL_16N SL_17 SL_17N SL_18 SL_18N SL_19 SL_19N SL_1N SL_2 SL_20 SL_20N SL_21 SL_21N SL_22 SL_22N SL_23 SL_23N
+ SL_24 SL_24N SL_25 SL_25N SL_26 SL_26N SL_27 SL_27N SL_28 SL_28N SL_29 SL_29N SL_2N SL_3 SL_30 SL_30N SL_31
+ SL_31N SL_3N SL_4 SL_4N SL_5 SL_5N SL_6 SL_6N SL_7 SL_7N SL_8 SL_8N SL_9 SL_9N VDD VEVAL VSS WL_23 pc
+ WORD_32bits
XI50 ML_20 SL_0 SL_0N SL_1 SL_10 SL_10N SL_11 SL_11N SL_12 SL_12N SL_13 SL_13N SL_14 SL_14N SL_15 SL_15N SL_16
+ SL_16N SL_17 SL_17N SL_18 SL_18N SL_19 SL_19N SL_1N SL_2 SL_20 SL_20N SL_21 SL_21N SL_22 SL_22N SL_23 SL_23N
+ SL_24 SL_24N SL_25 SL_25N SL_26 SL_26N SL_27 SL_27N SL_28 SL_28N SL_29 SL_29N SL_2N SL_3 SL_30 SL_30N SL_31
+ SL_31N SL_3N SL_4 SL_4N SL_5 SL_5N SL_6 SL_6N SL_7 SL_7N SL_8 SL_8N SL_9 SL_9N VDD VEVAL VSS WL_20 pc
+ WORD_32bits
XI22 ML_9 SL_0 SL_0N SL_1 SL_10 SL_10N SL_11 SL_11N SL_12 SL_12N SL_13 SL_13N SL_14 SL_14N SL_15 SL_15N SL_16
+ SL_16N SL_17 SL_17N SL_18 SL_18N SL_19 SL_19N SL_1N SL_2 SL_20 SL_20N SL_21 SL_21N SL_22 SL_22N SL_23 SL_23N
+ SL_24 SL_24N SL_25 SL_25N SL_26 SL_26N SL_27 SL_27N SL_28 SL_28N SL_29 SL_29N SL_2N SL_3 SL_30 SL_30N SL_31
+ SL_31N SL_3N SL_4 SL_4N SL_5 SL_5N SL_6 SL_6N SL_7 SL_7N SL_8 SL_8N SL_9 SL_9N VDD VEVAL VSS WL_9 pc
+ WORD_32bits
XI20 ML_10 SL_0 SL_0N SL_1 SL_10 SL_10N SL_11 SL_11N SL_12 SL_12N SL_13 SL_13N SL_14 SL_14N SL_15 SL_15N SL_16
+ SL_16N SL_17 SL_17N SL_18 SL_18N SL_19 SL_19N SL_1N SL_2 SL_20 SL_20N SL_21 SL_21N SL_22 SL_22N SL_23 SL_23N
+ SL_24 SL_24N SL_25 SL_25N SL_26 SL_26N SL_27 SL_27N SL_28 SL_28N SL_29 SL_29N SL_2N SL_3 SL_30 SL_30N SL_31
+ SL_31N SL_3N SL_4 SL_4N SL_5 SL_5N SL_6 SL_6N SL_7 SL_7N SL_8 SL_8N SL_9 SL_9N VDD VEVAL VSS WL_10 pc
+ WORD_32bits
XI10 ML_0 SL_0 SL_0N SL_1 SL_10 SL_10N SL_11 SL_11N SL_12 SL_12N SL_13 SL_13N SL_14 SL_14N SL_15 SL_15N SL_16
+ SL_16N SL_17 SL_17N SL_18 SL_18N SL_19 SL_19N SL_1N SL_2 SL_20 SL_20N SL_21 SL_21N SL_22 SL_22N SL_23 SL_23N
+ SL_24 SL_24N SL_25 SL_25N SL_26 SL_26N SL_27 SL_27N SL_28 SL_28N SL_29 SL_29N SL_2N SL_3 SL_30 SL_30N SL_31
+ SL_31N SL_3N SL_4 SL_4N SL_5 SL_5N SL_6 SL_6N SL_7 SL_7N SL_8 SL_8N SL_9 SL_9N VDD VEVAL VSS WL_0 pc
+ WORD_32bits
XI14 ML_4 SL_0 SL_0N SL_1 SL_10 SL_10N SL_11 SL_11N SL_12 SL_12N SL_13 SL_13N SL_14 SL_14N SL_15 SL_15N SL_16
+ SL_16N SL_17 SL_17N SL_18 SL_18N SL_19 SL_19N SL_1N SL_2 SL_20 SL_20N SL_21 SL_21N SL_22 SL_22N SL_23 SL_23N
+ SL_24 SL_24N SL_25 SL_25N SL_26 SL_26N SL_27 SL_27N SL_28 SL_28N SL_29 SL_29N SL_2N SL_3 SL_30 SL_30N SL_31
+ SL_31N SL_3N SL_4 SL_4N SL_5 SL_5N SL_6 SL_6N SL_7 SL_7N SL_8 SL_8N SL_9 SL_9N VDD VEVAL VSS WL_4 pc
+ WORD_32bits
XI15 ML_5 SL_0 SL_0N SL_1 SL_10 SL_10N SL_11 SL_11N SL_12 SL_12N SL_13 SL_13N SL_14 SL_14N SL_15 SL_15N SL_16
+ SL_16N SL_17 SL_17N SL_18 SL_18N SL_19 SL_19N SL_1N SL_2 SL_20 SL_20N SL_21 SL_21N SL_22 SL_22N SL_23 SL_23N
+ SL_24 SL_24N SL_25 SL_25N SL_26 SL_26N SL_27 SL_27N SL_28 SL_28N SL_29 SL_29N SL_2N SL_3 SL_30 SL_30N SL_31
+ SL_31N SL_3N SL_4 SL_4N SL_5 SL_5N SL_6 SL_6N SL_7 SL_7N SL_8 SL_8N SL_9 SL_9N VDD VEVAL VSS WL_5 pc
+ WORD_32bits
XI17 ML_7 SL_0 SL_0N SL_1 SL_10 SL_10N SL_11 SL_11N SL_12 SL_12N SL_13 SL_13N SL_14 SL_14N SL_15 SL_15N SL_16
+ SL_16N SL_17 SL_17N SL_18 SL_18N SL_19 SL_19N SL_1N SL_2 SL_20 SL_20N SL_21 SL_21N SL_22 SL_22N SL_23 SL_23N
+ SL_24 SL_24N SL_25 SL_25N SL_26 SL_26N SL_27 SL_27N SL_28 SL_28N SL_29 SL_29N SL_2N SL_3 SL_30 SL_30N SL_31
+ SL_31N SL_3N SL_4 SL_4N SL_5 SL_5N SL_6 SL_6N SL_7 SL_7N SL_8 SL_8N SL_9 SL_9N VDD VEVAL VSS WL_7 pc
+ WORD_32bits
XI16 ML_6 SL_0 SL_0N SL_1 SL_10 SL_10N SL_11 SL_11N SL_12 SL_12N SL_13 SL_13N SL_14 SL_14N SL_15 SL_15N SL_16
+ SL_16N SL_17 SL_17N SL_18 SL_18N SL_19 SL_19N SL_1N SL_2 SL_20 SL_20N SL_21 SL_21N SL_22 SL_22N SL_23 SL_23N
+ SL_24 SL_24N SL_25 SL_25N SL_26 SL_26N SL_27 SL_27N SL_28 SL_28N SL_29 SL_29N SL_2N SL_3 SL_30 SL_30N SL_31
+ SL_31N SL_3N SL_4 SL_4N SL_5 SL_5N SL_6 SL_6N SL_7 SL_7N SL_8 SL_8N SL_9 SL_9N VDD VEVAL VSS WL_6 pc
+ WORD_32bits
XI13 ML_3 SL_0 SL_0N SL_1 SL_10 SL_10N SL_11 SL_11N SL_12 SL_12N SL_13 SL_13N SL_14 SL_14N SL_15 SL_15N SL_16
+ SL_16N SL_17 SL_17N SL_18 SL_18N SL_19 SL_19N SL_1N SL_2 SL_20 SL_20N SL_21 SL_21N SL_22 SL_22N SL_23 SL_23N
+ SL_24 SL_24N SL_25 SL_25N SL_26 SL_26N SL_27 SL_27N SL_28 SL_28N SL_29 SL_29N SL_2N SL_3 SL_30 SL_30N SL_31
+ SL_31N SL_3N SL_4 SL_4N SL_5 SL_5N SL_6 SL_6N SL_7 SL_7N SL_8 SL_8N SL_9 SL_9N VDD VEVAL VSS WL_3 pc
+ WORD_32bits
XI18 ML_15 SL_0 SL_0N SL_1 SL_10 SL_10N SL_11 SL_11N SL_12 SL_12N SL_13 SL_13N SL_14 SL_14N SL_15 SL_15N SL_16
+ SL_16N SL_17 SL_17N SL_18 SL_18N SL_19 SL_19N SL_1N SL_2 SL_20 SL_20N SL_21 SL_21N SL_22 SL_22N SL_23 SL_23N
+ SL_24 SL_24N SL_25 SL_25N SL_26 SL_26N SL_27 SL_27N SL_28 SL_28N SL_29 SL_29N SL_2N SL_3 SL_30 SL_30N SL_31
+ SL_31N SL_3N SL_4 SL_4N SL_5 SL_5N SL_6 SL_6N SL_7 SL_7N SL_8 SL_8N SL_9 SL_9N VDD VEVAL VSS WL_15 pc
+ WORD_32bits
XI51 ML_28 SL_0 SL_0N SL_1 SL_10 SL_10N SL_11 SL_11N SL_12 SL_12N SL_13 SL_13N SL_14 SL_14N SL_15 SL_15N SL_16
+ SL_16N SL_17 SL_17N SL_18 SL_18N SL_19 SL_19N SL_1N SL_2 SL_20 SL_20N SL_21 SL_21N SL_22 SL_22N SL_23 SL_23N
+ SL_24 SL_24N SL_25 SL_25N SL_26 SL_26N SL_27 SL_27N SL_28 SL_28N SL_29 SL_29N SL_2N SL_3 SL_30 SL_30N SL_31
+ SL_31N SL_3N SL_4 SL_4N SL_5 SL_5N SL_6 SL_6N SL_7 SL_7N SL_8 SL_8N SL_9 SL_9N VDD VEVAL VSS WL_28 pc
+ WORD_32bits
XI57 ML_27 SL_0 SL_0N SL_1 SL_10 SL_10N SL_11 SL_11N SL_12 SL_12N SL_13 SL_13N SL_14 SL_14N SL_15 SL_15N SL_16
+ SL_16N SL_17 SL_17N SL_18 SL_18N SL_19 SL_19N SL_1N SL_2 SL_20 SL_20N SL_21 SL_21N SL_22 SL_22N SL_23 SL_23N
+ SL_24 SL_24N SL_25 SL_25N SL_26 SL_26N SL_27 SL_27N SL_28 SL_28N SL_29 SL_29N SL_2N SL_3 SL_30 SL_30N SL_31
+ SL_31N SL_3N SL_4 SL_4N SL_5 SL_5N SL_6 SL_6N SL_7 SL_7N SL_8 SL_8N SL_9 SL_9N VDD VEVAL VSS WL_27 pc
+ WORD_32bits
XI53 ML_29 SL_0 SL_0N SL_1 SL_10 SL_10N SL_11 SL_11N SL_12 SL_12N SL_13 SL_13N SL_14 SL_14N SL_15 SL_15N SL_16
+ SL_16N SL_17 SL_17N SL_18 SL_18N SL_19 SL_19N SL_1N SL_2 SL_20 SL_20N SL_21 SL_21N SL_22 SL_22N SL_23 SL_23N
+ SL_24 SL_24N SL_25 SL_25N SL_26 SL_26N SL_27 SL_27N SL_28 SL_28N SL_29 SL_29N SL_2N SL_3 SL_30 SL_30N SL_31
+ SL_31N SL_3N SL_4 SL_4N SL_5 SL_5N SL_6 SL_6N SL_7 SL_7N SL_8 SL_8N SL_9 SL_9N VDD VEVAL VSS WL_29 pc
+ WORD_32bits
XI54 ML_25 SL_0 SL_0N SL_1 SL_10 SL_10N SL_11 SL_11N SL_12 SL_12N SL_13 SL_13N SL_14 SL_14N SL_15 SL_15N SL_16
+ SL_16N SL_17 SL_17N SL_18 SL_18N SL_19 SL_19N SL_1N SL_2 SL_20 SL_20N SL_21 SL_21N SL_22 SL_22N SL_23 SL_23N
+ SL_24 SL_24N SL_25 SL_25N SL_26 SL_26N SL_27 SL_27N SL_28 SL_28N SL_29 SL_29N SL_2N SL_3 SL_30 SL_30N SL_31
+ SL_31N SL_3N SL_4 SL_4N SL_5 SL_5N SL_6 SL_6N SL_7 SL_7N SL_8 SL_8N SL_9 SL_9N VDD VEVAL VSS WL_25 pc
+ WORD_32bits
XI19 ML_11 SL_0 SL_0N SL_1 SL_10 SL_10N SL_11 SL_11N SL_12 SL_12N SL_13 SL_13N SL_14 SL_14N SL_15 SL_15N SL_16
+ SL_16N SL_17 SL_17N SL_18 SL_18N SL_19 SL_19N SL_1N SL_2 SL_20 SL_20N SL_21 SL_21N SL_22 SL_22N SL_23 SL_23N
+ SL_24 SL_24N SL_25 SL_25N SL_26 SL_26N SL_27 SL_27N SL_28 SL_28N SL_29 SL_29N SL_2N SL_3 SL_30 SL_30N SL_31
+ SL_31N SL_3N SL_4 SL_4N SL_5 SL_5N SL_6 SL_6N SL_7 SL_7N SL_8 SL_8N SL_9 SL_9N VDD VEVAL VSS WL_11 pc
+ WORD_32bits
XI52 ML_24 SL_0 SL_0N SL_1 SL_10 SL_10N SL_11 SL_11N SL_12 SL_12N SL_13 SL_13N SL_14 SL_14N SL_15 SL_15N SL_16
+ SL_16N SL_17 SL_17N SL_18 SL_18N SL_19 SL_19N SL_1N SL_2 SL_20 SL_20N SL_21 SL_21N SL_22 SL_22N SL_23 SL_23N
+ SL_24 SL_24N SL_25 SL_25N SL_26 SL_26N SL_27 SL_27N SL_28 SL_28N SL_29 SL_29N SL_2N SL_3 SL_30 SL_30N SL_31
+ SL_31N SL_3N SL_4 SL_4N SL_5 SL_5N SL_6 SL_6N SL_7 SL_7N SL_8 SL_8N SL_9 SL_9N VDD VEVAL VSS WL_24 pc
+ WORD_32bits
XI26 ML_8 SL_0 SL_0N SL_1 SL_10 SL_10N SL_11 SL_11N SL_12 SL_12N SL_13 SL_13N SL_14 SL_14N SL_15 SL_15N SL_16
+ SL_16N SL_17 SL_17N SL_18 SL_18N SL_19 SL_19N SL_1N SL_2 SL_20 SL_20N SL_21 SL_21N SL_22 SL_22N SL_23 SL_23N
+ SL_24 SL_24N SL_25 SL_25N SL_26 SL_26N SL_27 SL_27N SL_28 SL_28N SL_29 SL_29N SL_2N SL_3 SL_30 SL_30N SL_31
+ SL_31N SL_3N SL_4 SL_4N SL_5 SL_5N SL_6 SL_6N SL_7 SL_7N SL_8 SL_8N SL_9 SL_9N VDD VEVAL VSS WL_8 pc
+ WORD_32bits
XI58 ML_26 SL_0 SL_0N SL_1 SL_10 SL_10N SL_11 SL_11N SL_12 SL_12N SL_13 SL_13N SL_14 SL_14N SL_15 SL_15N SL_16
+ SL_16N SL_17 SL_17N SL_18 SL_18N SL_19 SL_19N SL_1N SL_2 SL_20 SL_20N SL_21 SL_21N SL_22 SL_22N SL_23 SL_23N
+ SL_24 SL_24N SL_25 SL_25N SL_26 SL_26N SL_27 SL_27N SL_28 SL_28N SL_29 SL_29N SL_2N SL_3 SL_30 SL_30N SL_31
+ SL_31N SL_3N SL_4 SL_4N SL_5 SL_5N SL_6 SL_6N SL_7 SL_7N SL_8 SL_8N SL_9 SL_9N VDD VEVAL VSS WL_26 pc
+ WORD_32bits
XI56 ML_31 SL_0 SL_0N SL_1 SL_10 SL_10N SL_11 SL_11N SL_12 SL_12N SL_13 SL_13N SL_14 SL_14N SL_15 SL_15N SL_16
+ SL_16N SL_17 SL_17N SL_18 SL_18N SL_19 SL_19N SL_1N SL_2 SL_20 SL_20N SL_21 SL_21N SL_22 SL_22N SL_23 SL_23N
+ SL_24 SL_24N SL_25 SL_25N SL_26 SL_26N SL_27 SL_27N SL_28 SL_28N SL_29 SL_29N SL_2N SL_3 SL_30 SL_30N SL_31
+ SL_31N SL_3N SL_4 SL_4N SL_5 SL_5N SL_6 SL_6N SL_7 SL_7N SL_8 SL_8N SL_9 SL_9N VDD VEVAL VSS WL_31 pc
+ WORD_32bits
XI55 ML_30 SL_0 SL_0N SL_1 SL_10 SL_10N SL_11 SL_11N SL_12 SL_12N SL_13 SL_13N SL_14 SL_14N SL_15 SL_15N SL_16
+ SL_16N SL_17 SL_17N SL_18 SL_18N SL_19 SL_19N SL_1N SL_2 SL_20 SL_20N SL_21 SL_21N SL_22 SL_22N SL_23 SL_23N
+ SL_24 SL_24N SL_25 SL_25N SL_26 SL_26N SL_27 SL_27N SL_28 SL_28N SL_29 SL_29N SL_2N SL_3 SL_30 SL_30N SL_31
+ SL_31N SL_3N SL_4 SL_4N SL_5 SL_5N SL_6 SL_6N SL_7 SL_7N SL_8 SL_8N SL_9 SL_9N VDD VEVAL VSS WL_30 pc
+ WORD_32bits
XI11 ML_1 SL_0 SL_0N SL_1 SL_10 SL_10N SL_11 SL_11N SL_12 SL_12N SL_13 SL_13N SL_14 SL_14N SL_15 SL_15N SL_16
+ SL_16N SL_17 SL_17N SL_18 SL_18N SL_19 SL_19N SL_1N SL_2 SL_20 SL_20N SL_21 SL_21N SL_22 SL_22N SL_23 SL_23N
+ SL_24 SL_24N SL_25 SL_25N SL_26 SL_26N SL_27 SL_27N SL_28 SL_28N SL_29 SL_29N SL_2N SL_3 SL_30 SL_30N SL_31
+ SL_31N SL_3N SL_4 SL_4N SL_5 SL_5N SL_6 SL_6N SL_7 SL_7N SL_8 SL_8N SL_9 SL_9N VDD VEVAL VSS WL_1 pc
+ WORD_32bits
XI12 ML_2 SL_0 SL_0N SL_1 SL_10 SL_10N SL_11 SL_11N SL_12 SL_12N SL_13 SL_13N SL_14 SL_14N SL_15 SL_15N SL_16
+ SL_16N SL_17 SL_17N SL_18 SL_18N SL_19 SL_19N SL_1N SL_2 SL_20 SL_20N SL_21 SL_21N SL_22 SL_22N SL_23 SL_23N
+ SL_24 SL_24N SL_25 SL_25N SL_26 SL_26N SL_27 SL_27N SL_28 SL_28N SL_29 SL_29N SL_2N SL_3 SL_30 SL_30N SL_31
+ SL_31N SL_3N SL_4 SL_4N SL_5 SL_5N SL_6 SL_6N SL_7 SL_7N SL_8 SL_8N SL_9 SL_9N VDD VEVAL VSS WL_2 pc
+ WORD_32bits

.ends ARRAY_32x32

**************************************************
* SUBCKT: inverter_sens
**************************************************

.subckt inverter_sens GND ML_0 ML_1 ML_10 ML_11 ML_12 ML_13 ML_14 ML_15 ML_16 ML_17 ML_18 ML_19 ML_2 ML_20
+ ML_21 ML_22 ML_23 ML_24 ML_25 ML_26 ML_27 ML_28 ML_29 ML_3 ML_30 ML_31 ML_4 ML_5 ML_6 ML_7 ML_8 ML_9 OUT0
+ OUT1 OUT10 OUT11 OUT12 OUT13 OUT14 OUT15 OUT16 OUT17 OUT18 OUT19 OUT2 OUT20 OUT21 OUT22 OUT23 OUT24 OUT25
+ OUT26 OUT27 OUT28 OUT29 OUT3 OUT30 OUT31 OUT4 OUT5 OUT6 OUT7 OUT8 OUT9 VDD

XI33 GND ML_1 VDD OUT1 INV
XI32 GND ML_0 VDD OUT0 INV
XI60 GND ML_26 VDD OUT26 INV
XI58 GND ML_25 VDD OUT25 INV
XI38 GND ML_6 VDD OUT6 INV
XI59 GND ML_27 VDD OUT27 INV
XI41 GND ML_9 VDD OUT9 INV
XI35 GND ML_3 VDD OUT3 INV
XI51 GND ML_18 VDD OUT18 INV
XI50 GND ML_19 VDD OUT19 INV
XI49 GND ML_17 VDD OUT17 INV
XI44 GND ML_14 VDD OUT14 INV
XI46 GND ML_13 VDD OUT13 INV
XI48 GND ML_16 VDD OUT16 INV
XI47 GND ML_12 VDD OUT12 INV
XI34 GND ML_2 VDD OUT2 INV
XI55 GND ML_30 VDD OUT30 INV
XI57 GND ML_29 VDD OUT29 INV
XI56 GND ML_31 VDD OUT31 INV
XI37 GND ML_5 VDD OUT5 INV
XI40 GND ML_8 VDD OUT8 INV
XI43 GND ML_10 VDD OUT10 INV
XI52 GND ML_20 VDD OUT20 INV
XI54 GND ML_28 VDD OUT28 INV
XI53 GND ML_24 VDD OUT24 INV
XI61 GND ML_22 VDD OUT22 INV
XI36 GND ML_4 VDD OUT4 INV
XI63 GND ML_21 VDD OUT21 INV
XI62 GND ML_23 VDD OUT23 INV
XI39 GND ML_7 VDD OUT7 INV
XI42 GND ML_11 VDD OUT11 INV
XI45 GND ML_15 VDD OUT15 INV

.ends inverter_sens

**************************************************
* SUBCKT: flip_flop
**************************************************

.subckt flip_flop CLK D Q Q_n VDD VSS

XI7 VSS Q_n VDD Q INV
XI5 VSS Q_n VDD net14 INV
XI4 VSS net17 VDD Q_n INV
XI3 VSS net9 VDD net15 INV
XI2 VSS CLK VDD net12 INV
XI1 VSS net8 VDD net9 INV
XI0 VSS D VDD net5 INV
MN4 net17 net12 net14 VSS sg13_lv_nmos w=740n l=130n ng=1 m=1
MN3 net9 CLK net17 VSS sg13_lv_nmos w=740n l=130n ng=1 m=1
MN2 net8 CLK net15 VSS sg13_lv_nmos w=740n l=130n ng=1 m=1
MN0 net5 net12 net8 VSS sg13_lv_nmos w=740n l=130n ng=1 m=1
MP4 net17 CLK net14 VDD sg13_lv_pmos w=1120n l=130n ng=1 m=1
MP3 net9 net12 net17 VDD sg13_lv_pmos w=1120n l=130n ng=1 m=1
MP2 net8 net12 net15 VDD sg13_lv_pmos w=1120n l=130n ng=1 m=1
MP0 net5 CLK net8 VDD sg13_lv_pmos w=1120n l=130n ng=1 m=1

.ends flip_flop

**************************************************
* SUBCKT: COMPARATOR_NEWBUFFER_64x32
**************************************************

.subckt COMPARATOR_NEWBUFFER_64x32 COMP0 COMP1 COMP10 COMP11 COMP12 COMP13 COMP14 COMP15 COMP16 COMP17 COMP18
+ COMP19 COMP2 COMP20 COMP21 COMP22 COMP23 COMP24 COMP25 COMP26 COMP27 COMP28 COMP29 COMP3 COMP30 COMP31 COMP4
+ COMP5 COMP6 COMP7 COMP8 COMP9 REFSENS SENSML0 SENSML1 SENSML10 SENSML11 SENSML12 SENSML13 SENSML14 SENSML15
+ SENSML16 SENSML17 SENSML18 SENSML19 SENSML2 SENSML20 SENSML21 SENSML22 SENSML23 SENSML24 SENSML25 SENSML26
+ SENSML27 SENSML28 SENSML29 SENSML3 SENSML30 SENSML31 SENSML4 SENSML5 SENSML6 SENSML7 SENSML8 SENSML9 VDD VSS

XI36 REFSENS SENSML0 COMP0 net12 VDD VSS flip_flop
XI38 REFSENS SENSML2 COMP2 net11 VDD VSS flip_flop
XI37 REFSENS SENSML1 COMP1 net10 VDD VSS flip_flop
XI39 REFSENS SENSML3 COMP3 net9 VDD VSS flip_flop
XI40 REFSENS SENSML4 COMP4 net8 VDD VSS flip_flop
XI42 REFSENS SENSML6 COMP6 net7 VDD VSS flip_flop
XI41 REFSENS SENSML5 COMP5 net6 VDD VSS flip_flop
XI43 REFSENS SENSML7 COMP7 net5 VDD VSS flip_flop
XI44 REFSENS SENSML8 COMP8 net4 VDD VSS flip_flop
XI46 REFSENS SENSML10 COMP10 net3 VDD VSS flip_flop
XI45 REFSENS SENSML9 COMP9 net2 VDD VSS flip_flop
XI47 REFSENS SENSML11 COMP11 net1 VDD VSS flip_flop
XI48 REFSENS SENSML12 COMP12 net32 VDD VSS flip_flop
XI50 REFSENS SENSML14 COMP14 net31 VDD VSS flip_flop
XI49 REFSENS SENSML13 COMP13 net30 VDD VSS flip_flop
XI51 REFSENS SENSML15 COMP15 net29 VDD VSS flip_flop
XI52 REFSENS SENSML16 COMP16 net28 VDD VSS flip_flop
XI54 REFSENS SENSML19 COMP19 net27 VDD VSS flip_flop
XI53 REFSENS SENSML17 COMP17 net26 VDD VSS flip_flop
XI55 REFSENS SENSML18 COMP18 net25 VDD VSS flip_flop
XI56 REFSENS SENSML20 COMP20 net24 VDD VSS flip_flop
XI58 REFSENS SENSML22 COMP22 net23 VDD VSS flip_flop
XI57 REFSENS SENSML21 COMP21 net22 VDD VSS flip_flop
XI59 REFSENS SENSML23 COMP23 net21 VDD VSS flip_flop
XI60 REFSENS SENSML24 COMP24 net20 VDD VSS flip_flop
XI62 REFSENS SENSML26 COMP26 net19 VDD VSS flip_flop
XI61 REFSENS SENSML25 COMP25 net18 VDD VSS flip_flop
XI63 REFSENS SENSML27 COMP27 net17 VDD VSS flip_flop
XI64 REFSENS SENSML28 COMP28 net16 VDD VSS flip_flop
XI65 REFSENS SENSML29 COMP29 net15 VDD VSS flip_flop
XI66 REFSENS SENSML30 COMP30 net14 VDD VSS flip_flop
XI67 REFSENS SENSML31 COMP31 net13 VDD VSS flip_flop

.ends COMPARATOR_NEWBUFFER_64x32

**************************************************
* SUBCKT: PART_SENS_COMPARATOR
**************************************************

.subckt PART_SENS_COMPARATOR COMP0 COMP1 COMP10 COMP11 COMP12 COMP13 COMP14 COMP15 COMP16 COMP17 COMP18 COMP19
+ COMP2 COMP20 COMP21 COMP22 COMP23 COMP24 COMP25 COMP26 COMP27 COMP28 COMP29 COMP3 COMP30 COMP31 COMP4 COMP5
+ COMP6 COMP7 COMP8 COMP9 ML_0 ML_1 ML_10 ML_11 ML_12 ML_13 ML_14 ML_15 ML_16 ML_17 ML_18 ML_19 ML_2 ML_20
+ ML_21 ML_22 ML_23 ML_24 ML_25 ML_26 ML_27 ML_28 ML_29 ML_3 ML_30 ML_31 ML_4 ML_5 ML_6 ML_7 ML_8 ML_9 REFSENS
+ VDD VSS

XI3 VSS ML_0 ML_1 ML_10 ML_11 ML_12 ML_13 ML_14 ML_15 ML_16 ML_17 ML_18 ML_19 ML_2 ML_20 ML_21 ML_22 ML_23
+ ML_24 ML_25 ML_26 ML_27 ML_28 ML_29 ML_3 ML_30 ML_31 ML_4 ML_5 ML_6 ML_7 ML_8 ML_9 net32 net31 net22 net21
+ net20 net19 net18 net17 net16 net15 net14 net13 net30 net12 net11 net10 net9 net8 net7 net6 net5 net4 net3
+ net29 net2 net1 net28 net27 net26 net25 net24 net23 VDD inverter_sens
XI4 COMP0 COMP1 COMP10 COMP11 COMP12 COMP13 COMP14 COMP15 COMP16 COMP17 COMP18 COMP19 COMP2 COMP20 COMP21
+ COMP22 COMP23 COMP24 COMP25 COMP26 COMP27 COMP28 COMP29 COMP3 COMP30 COMP31 COMP4 COMP5 COMP6 COMP7 COMP8
+ COMP9 REFSENS net32 net31 net22 net21 net20 net19 net18 net17 net16 net15 net14 net13 net30 net12 net11
+ net10 net9 net8 net7 net6 net5 net4 net3 net29 net2 net1 net28 net27 net26 net25 net24 net23 VDD VSS
+ COMPARATOR_NEWBUFFER_64x32

.ends PART_SENS_COMPARATOR

**************************************************
* SUBCKT: ANALOG_FIGURE
**************************************************

.subckt ANALOG_FIGURE COMP0 COMP1 COMP10 COMP11 COMP12 COMP13 COMP14 COMP15 COMP16 COMP17 COMP18 COMP19 COMP2
+ COMP20 COMP21 COMP22 COMP23 COMP24 COMP25 COMP26 COMP27 COMP28 COMP29 COMP3 COMP30 COMP31 COMP4 COMP5 COMP6
+ COMP7 COMP8 COMP9 PC PSL_0 PSL_0N PSL_1 PSL_10 PSL_10N PSL_11 PSL_11N PSL_12 PSL_12N PSL_13 PSL_13N PSL_14
+ PSL_14N PSL_15 PSL_15N PSL_16 PSL_16N PSL_17 PSL_17N PSL_18 PSL_18N PSL_19 PSL_19N PSL_1N PSL_2 PSL_20
+ PSL_20N PSL_21 PSL_21N PSL_22 PSL_22N PSL_23 PSL_23N PSL_24 PSL_24N PSL_25 PSL_25N PSL_26 PSL_26N PSL_27
+ PSL_27N PSL_28 PSL_28N PSL_29 PSL_29N PSL_2N PSL_3 PSL_30 PSL_30N PSL_31 PSL_31N PSL_3N PSL_4 PSL_4N PSL_5
+ PSL_5N PSL_6 PSL_6N PSL_7 PSL_7N PSL_8 PSL_8N PSL_9 PSL_9N SL_0 SL_0N SL_1 SL_10 SL_10N SL_11 SL_11N SL_12
+ SL_12N SL_13 SL_13N SL_14 SL_14N SL_15 SL_15N SL_16 SL_16N SL_17 SL_17N SL_18 SL_18N SL_19 SL_19N SL_1N SL_2
+ SL_20 SL_20N SL_21 SL_21N SL_22 SL_22N SL_23 SL_23N SL_24 SL_24N SL_25 SL_25N SL_26 SL_26N SL_27 SL_27N
+ SL_28 SL_28N SL_29 SL_29N SL_2N SL_3 SL_30 SL_30N SL_31 SL_31N SL_3N SL_4 SL_4N SL_5 SL_5N SL_6 SL_6N SL_7
+ SL_7N SL_8 SL_8N SL_9 SL_9N VDD VEVAL VSS WL WL_0 WL_1 WL_10 WL_11 WL_12 WL_13 WL_14 WL_15 WL_16 WL_17 WL_18
+ WL_19 WL_2 WL_20 WL_21 WL_22 WL_23 WL_24 WL_25 WL_26 WL_27 WL_28 WL_29 WL_3 WL_30 WL_31 WL_4 WL_5 WL_6 WL_7
+ WL_8 WL_9

XI1 OUTP PSL_0 PSL_0N PSL_1 PSL_10 PSL_10N PSL_11 PSL_11N PSL_12 PSL_12N PSL_13 PSL_13N PSL_14 PSL_14N PSL_15
+ PSL_15N PSL_16 PSL_16N PSL_17 PSL_17N PSL_18 PSL_18N PSL_19 PSL_19N PSL_1N PSL_2 PSL_20 PSL_20N PSL_21
+ PSL_21N PSL_22 PSL_22N PSL_23 PSL_23N PSL_24 PSL_24N PSL_25 PSL_25N PSL_26 PSL_26N PSL_27 PSL_27N PSL_28
+ PSL_28N PSL_29 PSL_29N PSL_2N PSL_3 PSL_30 PSL_30N PSL_31 PSL_31N PSL_3N PSL_4 PSL_4N PSL_5 PSL_5N PSL_6
+ PSL_6N PSL_7 PSL_7N PSL_8 PSL_8N PSL_9 PSL_9N VDD VEVAL VSS WL PC reference_complete
XI0 ML_0 ML_1 ML_10 ML_11 ML_12 ML_13 ML_14 ML_15 ML_16 ML_17 ML_18 ML_19 ML_2 ML_20 ML_21 ML_22 ML_23 ML_24
+ ML_25 ML_26 ML_27 ML_28 ML_29 ML_3 ML_30 ML_31 ML_4 ML_5 ML_6 ML_7 ML_8 ML_9 SL_0 SL_0N SL_1 SL_10 SL_10N
+ SL_11 SL_11N SL_12 SL_12N SL_13 SL_13N SL_14 SL_14N SL_15 SL_15N SL_16 SL_16N SL_17 SL_17N SL_18 SL_18N
+ SL_19 SL_19N SL_1N SL_2 SL_20 SL_20N SL_21 SL_21N SL_22 SL_22N SL_23 SL_23N SL_24 SL_24N SL_25 SL_25N SL_26
+ SL_26N SL_27 SL_27N SL_28 SL_28N SL_29 SL_29N SL_2N SL_3 SL_30 SL_30N SL_31 SL_31N SL_3N SL_4 SL_4N SL_5
+ SL_5N SL_6 SL_6N SL_7 SL_7N SL_8 SL_8N SL_9 SL_9N VDD VEVAL VSS WL_0 WL_1 WL_10 WL_11 WL_12 WL_13 WL_14
+ WL_15 WL_16 WL_17 WL_18 WL_19 WL_2 WL_20 WL_21 WL_22 WL_23 WL_24 WL_25 WL_26 WL_27 WL_28 WL_29 WL_3 WL_30
+ WL_31 WL_4 WL_5 WL_6 WL_7 WL_8 WL_9 PC ARRAY_32x32
XI326 COMP0 COMP1 COMP10 COMP11 COMP12 COMP13 COMP14 COMP15 COMP16 COMP17 COMP18 COMP19 COMP2 COMP20 COMP21
+ COMP22 COMP23 COMP24 COMP25 COMP26 COMP27 COMP28 COMP29 COMP3 COMP30 COMP31 COMP4 COMP5 COMP6 COMP7 COMP8
+ COMP9 ML_0 ML_1 ML_10 ML_11 ML_12 ML_13 ML_14 ML_15 ML_16 ML_17 ML_18 ML_19 ML_2 ML_20 ML_21 ML_22 ML_23
+ ML_24 ML_25 ML_26 ML_27 ML_28 ML_29 ML_3 ML_30 ML_31 ML_4 ML_5 ML_6 ML_7 ML_8 ML_9 OUTP VDD VSS
+ PART_SENS_COMPARATOR

.ends ANALOG_FIGURE

**************************************************
* SUBCKT: CAM_CONTROL
**************************************************

.subckt CAM_CONTROL EN_REFERENCE EN_SEARCH EN_WRITE PC VEVAL clk output_enable reset REF_SEL WL_REF
+ addr_shift_enable decoder_enable shift_enable VGND VPWR

Xctl_sg13g2_and2_1_3 ctl_sg13g2_and2_1_3_X VGND VPWR ctl_sg13g2_and2_1_3_B ctl_sg13g2_nor3_1_4_A
+ ctl_sg13g2_and2_1
Xctl_sg13g2_nand2b_1_0 VGND ctl_sg13g2_nor3_1_3_B ctl_sg13g2_nand2_1_4_A ctl_sg13g2_nor2_1_10_B VPWR
+ ctl_sg13g2_nand2b_1
Xctl_sg13g2_inv_1_1 ctl_sg13g2_inv_1_1_Y ctl_sg13g2_inv_1_6_A VGND VPWR ctl_sg13g2_inv_1
Xctl_sg13g2_buf_1_1 decoder_enable ctl_sg13g2_buf_1_1_A VGND VPWR ctl_sg13g2_buf_1
Xctl_sg13g2_dlygate4sd3_1_14 ctl_sg13g2_nor3_1_0_Y VPWR VGND ctl_sg13g2_nor4_1_0_A ctl_sg13g2_dlygate4sd3_1
Xctl_sg13g2_nor2_1_5 ctl_sg13g2_nor2_1_5_A VPWR ctl_sg13g2_nor4_1_0_D VGND ctl_sg13g2_nor3_1_0_A
+ ctl_sg13g2_nor2_1
Xctl_sg13g2_dfrbpq_1_9 clk VGND ctl_sg13g2_nor4_1_0_Y ctl_sg13g2_buf_1_5_A VPWR ctl_sg13g2_inv_1_17_Y
+ ctl_sg13g2_dfrbpq_1
Xctl_sg13g2_and2_1_4 ctl_sg13g2_nor3_1_0_B VGND VPWR ctl_sg13g2_or2_1_0_B ctl_sg13g2_or2_1_0_A
+ ctl_sg13g2_and2_1
Xctl_sg13g2_nand4_1_0 VPWR ctl_sg13g2_nand4_1_0_Y ctl_sg13g2_nor3_1_6_B ctl_sg13g2_nor2_1_2_A VGND
+ ctl_sg13g2_inv_1_0_A ctl_sg13g2_nor3_1_6_C ctl_sg13g2_nand4_1
Xctl_sg13g2_nand2b_1_1 VGND ctl_sg13g2_xor2_1_1_B ctl_sg13g2_nor2_1_10_B ctl_sg13g2_and2_1_2_B VPWR
+ ctl_sg13g2_nand2b_1
Xctl_sg13g2_inv_1_2 ctl_sg13g2_inv_1_2_Y ctl_sg13g2_inv_1_6_A VGND VPWR ctl_sg13g2_inv_1
Xctl_sg13g2_buf_1_2 VEVAL ctl_sg13g2_buf_1_2_A VGND VPWR ctl_sg13g2_buf_1
Xctl_sg13g2_buf_1_10 ctl_sg13g2_buf_1_10_X EN_WRITE VGND VPWR ctl_sg13g2_buf_1
Xctl_sg13g2_nor2_1_6 ctl_sg13g2_nor2_1_7_A VPWR ctl_sg13g2_nor2_1_6_Y VGND ctl_sg13g2_nor3_1_3_B
+ ctl_sg13g2_nor2_1
Xctl_sg13g2_dlygate4sd3_1_15 ctl_sg13g2_or2_1_0_A VPWR VGND ctl_sg13g2_xor2_1_0_A ctl_sg13g2_dlygate4sd3_1
Xctl_sg13g2_nand2b_1_2 VGND ctl_sg13g2_o21ai_1_7_A1 ctl_sg13g2_nand2_1_3_A ctl_sg13g2_buf_1_10_X VPWR
+ ctl_sg13g2_nand2b_1
Xctl_sg13g2_a221oi_1_0 ctl_sg13g2_and2_1_3_X ctl_sg13g2_o21ai_1_4_A2 ctl_sg13g2_nor3_1_1_B
+ ctl_sg13g2_nor3_1_2_A ctl_sg13g2_mux2_1_1_X VPWR ctl_sg13g2_inv_1_27_Y VGND ctl_sg13g2_a221oi_1
Xctl_sg13g2_buf_1_3 shift_enable ctl_sg13g2_buf_1_3_A VGND VPWR ctl_sg13g2_buf_1
Xctl_sg13g2_buf_1_11 REF_SEL ctl_sg13g2_buf_1_11_A VGND VPWR ctl_sg13g2_buf_1
Xctl_sg13g2_inv_1_3 ctl_sg13g2_inv_1_3_Y ctl_sg13g2_inv_1_6_A VGND VPWR ctl_sg13g2_inv_1
Xctl_sg13g2_a21o_1_0 ctl_sg13g2_nor3_1_6_C ctl_sg13g2_a21o_1_0_X VPWR VGND ctl_sg13g2_inv_1_0_A
+ ctl_sg13g2_nor3_1_6_B ctl_sg13g2_a21o_1
Xctl_sg13g2_nor2_1_7 ctl_sg13g2_nor2_1_7_A VPWR ctl_sg13g2_nor3_1_3_C VGND ctl_sg13g2_nor3_1_1_A
+ ctl_sg13g2_nor2_1
Xctl_sg13g2_nand2b_1_3 VGND ctl_sg13g2_a21oi_1_3_B1 ctl_sg13g2_nand2b_1_5_B ctl_sg13g2_buf_1_9_X VPWR
+ ctl_sg13g2_nand2b_1
Xctl_sg13g2_buf_1_4 output_enable ctl_sg13g2_buf_1_4_A VGND VPWR ctl_sg13g2_buf_1
Xctl_sg13g2_buf_1_12 ctl_sg13g2_buf_1_12_X EN_SEARCH VGND VPWR ctl_sg13g2_buf_1
Xctl_sg13g2_inv_1_4 ctl_sg13g2_inv_1_4_Y ctl_sg13g2_inv_1_4_A VGND VPWR ctl_sg13g2_inv_1
Xctl_sg13g2_a21o_1_1 ctl_sg13g2_nor2_1_9_Y ctl_sg13g2_a21o_1_1_X VPWR VGND ctl_sg13g2_a21o_1_1_A1
+ ctl_sg13g2_buf_1_12_X ctl_sg13g2_a21o_1
Xctl_sg13g2_nor2_1_8 ctl_sg13g2_nor2_1_9_Y VPWR ctl_sg13g2_inv_1_0_A VGND ctl_sg13g2_nor2_1_8_B
+ ctl_sg13g2_nor2_1
Xctl_sg13g2_nand2b_1_4 VGND ctl_sg13g2_a21o_1_1_A1 ctl_sg13g2_nand2b_1_4_Y ctl_sg13g2_buf_1_12_X VPWR
+ ctl_sg13g2_nand2b_1
Xctl_sg13g2_buf_1_5 addr_shift_enable ctl_sg13g2_buf_1_5_A VGND VPWR ctl_sg13g2_buf_1
Xctl_sg13g2_inv_1_5 ctl_sg13g2_inv_1_5_Y ctl_sg13g2_inv_1_6_A VGND VPWR ctl_sg13g2_inv_1
Xctl_sg13g2_buf_1_13 ctl_sg13g2_inv_1_6_A ctl_sg13g2_buf_1_8_A VGND VPWR ctl_sg13g2_buf_1
Xctl_sg13g2_a21o_1_2 ctl_sg13g2_nor3_1_0_B ctl_sg13g2_buf_1_15_A VPWR VGND ctl_sg13g2_or2_1_0_X
+ ctl_sg13g2_nor3_1_0_A ctl_sg13g2_a21o_1
Xctl_sg13g2_nor2_1_9 ctl_sg13g2_nor2_1_9_A VPWR ctl_sg13g2_nor2_1_9_Y VGND ctl_sg13g2_nor2_1_9_B
+ ctl_sg13g2_nor2_1
Xctl_sg13g2_nand2b_1_5 VGND ctl_sg13g2_nand2b_1_4_Y ctl_sg13g2_nor2_1_9_B ctl_sg13g2_nand2b_1_5_B VPWR
+ ctl_sg13g2_nand2b_1
Xctl_sg13g2_buf_1_6 ctl_sg13g2_buf_1_7_A reset VGND VPWR ctl_sg13g2_buf_1
Xctl_sg13g2_inv_1_6 ctl_sg13g2_inv_1_6_Y ctl_sg13g2_inv_1_6_A VGND VPWR ctl_sg13g2_inv_1
Xctl_sg13g2_buf_1_14 ctl_sg13g2_xor2_1_1_A ctl_sg13g2_buf_1_14_A VGND VPWR ctl_sg13g2_buf_1
Xctl_sg13g2_a21o_1_3 ctl_sg13g2_and2_1_3_X ctl_sg13g2_or2_1_0_B VPWR VGND ctl_sg13g2_inv_1_27_Y
+ ctl_sg13g2_mux2_1_1_X ctl_sg13g2_a21o_1
Xctl_sg13g2_nand2b_1_6 VGND ctl_sg13g2_xor2_1_1_A ctl_sg13g2_mux2_1_1_A0 ctl_sg13g2_xor2_1_1_B VPWR
+ ctl_sg13g2_nand2b_1
Xctl_sg13g2_buf_1_7 ctl_sg13g2_buf_1_8_A ctl_sg13g2_buf_1_7_A VGND VPWR ctl_sg13g2_buf_1
Xctl_sg13g2_inv_1_7 ctl_sg13g2_inv_1_7_Y ctl_sg13g2_inv_1_9_A VGND VPWR ctl_sg13g2_inv_1
Xctl_sg13g2_buf_1_15 ctl_sg13g2_nor3_1_3_B ctl_sg13g2_buf_1_15_A VGND VPWR ctl_sg13g2_buf_1
Xctl_sg13g2_buf_1_8 ctl_sg13g2_inv_1_9_A ctl_sg13g2_buf_1_8_A VGND VPWR ctl_sg13g2_buf_1
Xctl_sg13g2_buf_1_16 WL_REF ctl_sg13g2_buf_1_16_A VGND VPWR ctl_sg13g2_buf_1
Xctl_sg13g2_inv_1_8 ctl_sg13g2_inv_1_8_Y ctl_sg13g2_inv_1_9_A VGND VPWR ctl_sg13g2_inv_1
Xctl_sg13g2_dlygate4sd3_1_0 ctl_sg13g2_a21oi_1_1_Y VPWR VGND ctl_sg13g2_nor3_1_6_C ctl_sg13g2_dlygate4sd3_1
Xctl_sg13g2_o21ai_1_0 VGND VPWR ctl_sg13g2_o21ai_1_0_Y ctl_sg13g2_buf_1_15_A ctl_sg13g2_buf_1_14_A
+ ctl_sg13g2_nor3_1_4_A ctl_sg13g2_o21ai_1
Xctl_sg13g2_buf_1_9 ctl_sg13g2_buf_1_9_X EN_REFERENCE VGND VPWR ctl_sg13g2_buf_1
Xctl_sg13g2_inv_1_9 ctl_sg13g2_inv_1_9_Y ctl_sg13g2_inv_1_9_A VGND VPWR ctl_sg13g2_inv_1
Xctl_sg13g2_nor2_1_10 ctl_sg13g2_nor3_1_4_Y VPWR ctl_sg13g2_nor2_1_10_Y VGND ctl_sg13g2_nor2_1_10_B
+ ctl_sg13g2_nor2_1
Xctl_sg13g2_dlygate4sd3_1_1 ctl_sg13g2_nor3_1_4_A VPWR VGND ctl_sg13g2_o21ai_1_6_A1 ctl_sg13g2_dlygate4sd3_1
Xctl_sg13g2_o21ai_1_1 VGND VPWR ctl_sg13g2_o21ai_1_1_Y ctl_sg13g2_nor2_1_2_A ctl_sg13g2_nor3_1_5_C
+ ctl_sg13g2_nor3_1_6_C ctl_sg13g2_o21ai_1
Xctl_sg13g2_nor4_1_0 VGND VPWR ctl_sg13g2_nor4_1_0_B ctl_sg13g2_nor4_1_0_C ctl_sg13g2_nor4_1_0_Y
+ ctl_sg13g2_nor4_1_0_A ctl_sg13g2_nor4_1_0_D ctl_sg13g2_nor4_1
Xctl_sg13g2_dlygate4sd3_1_2 ctl_sg13g2_nor3_1_4_B VPWR VGND ctl_sg13g2_a21oi_1_1_A1 ctl_sg13g2_dlygate4sd3_1
Xctl_sg13g2_o21ai_1_2 VGND VPWR ctl_sg13g2_o21ai_1_2_Y ctl_sg13g2_and2_1_3_B ctl_sg13g2_inv_1_25_Y
+ ctl_sg13g2_inv_1_27_Y ctl_sg13g2_o21ai_1
Xctl_sg13g2_dlygate4sd3_1_3 ctl_sg13g2_nand4_1_0_Y VPWR VGND ctl_sg13g2_nor4_1_0_C ctl_sg13g2_dlygate4sd3_1
Xctl_sg13g2_o21ai_1_3 VGND VPWR ctl_sg13g2_o21ai_1_3_Y ctl_sg13g2_nor4_1_0_C ctl_sg13g2_a21o_1_0_X
+ ctl_sg13g2_nor2_1_1_Y ctl_sg13g2_o21ai_1
Xctl_sg13g2_dlygate4sd3_1_4 ctl_sg13g2_dfrbpq_1_17_Q VPWR VGND ctl_sg13g2_nor3_1_1_A ctl_sg13g2_dlygate4sd3_1
Xctl_sg13g2_o21ai_1_4 VGND VPWR ctl_sg13g2_nor3_1_0_A ctl_sg13g2_a21oi_1_2_Y ctl_sg13g2_o21ai_1_4_A2
+ ctl_sg13g2_nor3_1_1_Y ctl_sg13g2_o21ai_1
Xctl_sg13g2_dlygate4sd3_1_5 ctl_sg13g2_dfrbpq_1_8_Q VPWR VGND ctl_sg13g2_nor3_1_1_B ctl_sg13g2_dlygate4sd3_1
Xctl_sg13g2_o21ai_1_5 VGND VPWR ctl_sg13g2_and2_1_2_B ctl_sg13g2_nor3_1_4_B ctl_sg13g2_xor2_1_1_A
+ ctl_sg13g2_nor3_1_4_A ctl_sg13g2_o21ai_1
Xctl_sg13g2_dlygate4sd3_1_6 ctl_sg13g2_dfrbpq_1_11_Q VPWR VGND ctl_sg13g2_nor2_1_7_A ctl_sg13g2_dlygate4sd3_1
Xctl_sg13g2_o21ai_1_6 VGND VPWR ctl_sg13g2_nor2_1_2_A ctl_sg13g2_nand2_1_5_Y ctl_sg13g2_and3_1_1_X
+ ctl_sg13g2_o21ai_1_6_A1 ctl_sg13g2_o21ai_1
Xctl_sg13g2_decap_8_0 VPWR VGND ctl_sg13g2_decap_8
Xctl_sg13g2_or2_1_0 ctl_sg13g2_or2_1_0_A VGND ctl_sg13g2_or2_1_0_B ctl_sg13g2_or2_1_0_X VPWR ctl_sg13g2_or2_1
Xctl_sg13g2_dlygate4sd3_1_7 ctl_sg13g2_dfrbpq_1_10_Q VPWR VGND ctl_sg13g2_nor3_1_1_C ctl_sg13g2_dlygate4sd3_1
Xctl_sg13g2_o21ai_1_7 VGND VPWR ctl_sg13g2_o21ai_1_7_Y ctl_sg13g2_buf_1_10_X ctl_sg13g2_nor2b_1_0_Y
+ ctl_sg13g2_o21ai_1_7_A1 ctl_sg13g2_o21ai_1
Xctl_sg13g2_decap_8_1 VPWR VGND ctl_sg13g2_decap_8
Xctl_sg13g2_dlygate4sd3_1_8 ctl_sg13g2_dfrbpq_1_16_Q VPWR VGND ctl_sg13g2_o21ai_1_7_A1
+ ctl_sg13g2_dlygate4sd3_1
Xctl_sg13g2_a22oi_1_0 ctl_sg13g2_nand2_1_4_B ctl_sg13g2_nor2_1_10_Y VPWR ctl_sg13g2_nand2_1_3_Y
+ ctl_sg13g2_nor3_1_3_B VGND ctl_sg13g2_nor2b_1_0_Y ctl_sg13g2_a22oi_1
Xctl_sg13g2_decap_8_2 VPWR VGND ctl_sg13g2_decap_8
Xctl_sg13g2_dlygate4sd3_1_9 ctl_sg13g2_a21oi_1_3_Y VPWR VGND ctl_sg13g2_nor2b_1_1_A ctl_sg13g2_dlygate4sd3_1
Xctl_sg13g2_decap_8_3 VPWR VGND ctl_sg13g2_decap_8
Xctl_sg13g2_a21oi_1_0 VPWR VGND ctl_sg13g2_nor3_1_6_B ctl_sg13g2_inv_1_0_A ctl_sg13g2_nor2_1_2_A
+ ctl_sg13g2_a21oi_1_0_Y ctl_sg13g2_a21oi_1
Xctl_sg13g2_decap_8_4 VPWR VGND ctl_sg13g2_decap_8
Xctl_sg13g2_a21oi_1_1 VPWR VGND ctl_sg13g2_o21ai_1_0_Y ctl_sg13g2_a21oi_1_1_A1 ctl_sg13g2_a21oi_1_4_Y
+ ctl_sg13g2_a21oi_1_1_Y ctl_sg13g2_a21oi_1
Xctl_sg13g2_decap_8_5 VPWR VGND ctl_sg13g2_decap_8
Xctl_sg13g2_a21oi_1_2 VPWR VGND ctl_sg13g2_mux2_1_1_X ctl_sg13g2_inv_1_27_Y ctl_sg13g2_a21oi_1_5_Y
+ ctl_sg13g2_a21oi_1_2_Y ctl_sg13g2_a21oi_1
Xctl_sg13g2_a21oi_1_3 VPWR VGND ctl_sg13g2_nand2_1_3_A ctl_sg13g2_nor2b_1_0_Y ctl_sg13g2_a21oi_1_3_B1
+ ctl_sg13g2_a21oi_1_3_Y ctl_sg13g2_a21oi_1
Xctl_sg13g2_decap_4_0 VPWR VGND ctl_sg13g2_decap_4
Xctl_sg13g2_nor3_1_0 ctl_sg13g2_nor3_1_0_A ctl_sg13g2_nor3_1_0_Y ctl_sg13g2_nor3_1_0_B ctl_sg13g2_nor3_1_0_C
+ VPWR VGND ctl_sg13g2_nor3_1
Xctl_sg13g2_inv_1_20 ctl_sg13g2_inv_1_20_Y ctl_sg13g2_buf_1_8_A VGND VPWR ctl_sg13g2_inv_1
Xctl_sg13g2_a21oi_1_4 VPWR VGND ctl_sg13g2_nand2b_1_5_B ctl_sg13g2_nand2b_1_4_Y ctl_sg13g2_nor2_1_9_A
+ ctl_sg13g2_a21oi_1_4_Y ctl_sg13g2_a21oi_1
Xctl_sg13g2_nor3_1_1 ctl_sg13g2_nor3_1_1_A ctl_sg13g2_nor3_1_1_Y ctl_sg13g2_nor3_1_1_B ctl_sg13g2_nor3_1_1_C
+ VPWR VGND ctl_sg13g2_nor3_1
Xctl_sg13g2_decap_4_1 VPWR VGND ctl_sg13g2_decap_4
Xctl_sg13g2_inv_1_21 ctl_sg13g2_inv_1_21_Y ctl_sg13g2_inv_1_9_A VGND VPWR ctl_sg13g2_inv_1
Xctl_sg13g2_inv_1_10 ctl_sg13g2_inv_1_10_Y ctl_sg13g2_inv_1_9_A VGND VPWR ctl_sg13g2_inv_1
Xctl_sg13g2_and3_1_0 ctl_sg13g2_and3_1_0_X ctl_sg13g2_nor3_1_6_B VPWR VGND ctl_sg13g2_nor3_1_5_A
+ ctl_sg13g2_inv_1_0_A ctl_sg13g2_and3_1
Xctl_sg13g2_a21oi_1_5 VPWR VGND ctl_sg13g2_xor2_1_1_A ctl_sg13g2_inv_1_25_Y ctl_sg13g2_inv_1_27_Y
+ ctl_sg13g2_a21oi_1_5_Y ctl_sg13g2_a21oi_1
Xctl_sg13g2_decap_4_2 VPWR VGND ctl_sg13g2_decap_4
Xctl_sg13g2_nor3_1_2 ctl_sg13g2_nor3_1_2_A ctl_sg13g2_nor3_1_2_Y ctl_sg13g2_nor3_1_3_B ctl_sg13g2_nor3_1_2_C
+ VPWR VGND ctl_sg13g2_nor3_1
Xctl_sg13g2_inv_1_22 ctl_sg13g2_inv_1_22_Y ctl_sg13g2_inv_1_6_A VGND VPWR ctl_sg13g2_inv_1
Xctl_sg13g2_inv_1_11 ctl_sg13g2_nor3_1_5_B ctl_sg13g2_nor3_1_6_C VGND VPWR ctl_sg13g2_inv_1
Xctl_sg13g2_mux2_1_0 ctl_sg13g2_and2_1_2_X ctl_sg13g2_nor2_1_8_B ctl_sg13g2_nor3_1_3_B VPWR VGND
+ ctl_sg13g2_xor2_1_1_A ctl_sg13g2_mux2_1
Xctl_sg13g2_and3_1_1 ctl_sg13g2_and3_1_1_X ctl_sg13g2_xor2_1_1_B VPWR VGND ctl_sg13g2_buf_1_15_A
+ ctl_sg13g2_xor2_1_1_A ctl_sg13g2_and3_1
Xctl_sg13g2_nand2_1_0 ctl_sg13g2_nor3_1_5_C VPWR ctl_sg13g2_inv_1_0_Y VGND ctl_sg13g2_nor3_1_6_B
+ ctl_sg13g2_nand2_1
Xctl_sg13g2_nor3_1_3 ctl_sg13g2_nor3_1_3_A ctl_sg13g2_nor3_1_3_Y ctl_sg13g2_nor3_1_3_B ctl_sg13g2_nor3_1_3_C
+ VPWR VGND ctl_sg13g2_nor3_1
Xctl_sg13g2_decap_4_3 VPWR VGND ctl_sg13g2_decap_4
Xctl_sg13g2_inv_1_23 ctl_sg13g2_inv_1_23_Y ctl_sg13g2_inv_1_6_A VGND VPWR ctl_sg13g2_inv_1
Xctl_sg13g2_inv_1_12 ctl_sg13g2_nor3_1_5_A ctl_sg13g2_nor2_1_2_A VGND VPWR ctl_sg13g2_inv_1
Xctl_sg13g2_mux2_1_1 ctl_sg13g2_xor2_1_1_X ctl_sg13g2_mux2_1_1_X ctl_sg13g2_nor3_1_4_B VPWR VGND
+ ctl_sg13g2_mux2_1_1_A0 ctl_sg13g2_mux2_1
Xctl_sg13g2_xor2_1_0 ctl_sg13g2_xor2_1_0_X VPWR ctl_sg13g2_xor2_1_0_B ctl_sg13g2_xor2_1_0_A VGND
+ ctl_sg13g2_xor2_1
Xctl_sg13g2_dfrbpq_1_10 clk VGND ctl_sg13g2_nor3_1_2_Y ctl_sg13g2_dfrbpq_1_10_Q VPWR ctl_sg13g2_inv_1_14_Y
+ ctl_sg13g2_dfrbpq_1
Xctl_sg13g2_nand2_1_1 ctl_sg13g2_xor2_1_0_B VPWR ctl_sg13g2_nor3_1_1_B VGND ctl_sg13g2_nor3_1_2_A
+ ctl_sg13g2_nand2_1
Xctl_sg13g2_nor3_1_4 ctl_sg13g2_nor3_1_4_A ctl_sg13g2_nor3_1_4_Y ctl_sg13g2_nor3_1_4_B ctl_sg13g2_xor2_1_1_A
+ VPWR VGND ctl_sg13g2_nor3_1
Xctl_sg13g2_inv_1_24 ctl_sg13g2_inv_1_24_Y ctl_sg13g2_inv_1_6_A VGND VPWR ctl_sg13g2_inv_1
Xctl_sg13g2_inv_1_13 ctl_sg13g2_inv_1_13_Y ctl_sg13g2_inv_1_9_A VGND VPWR ctl_sg13g2_inv_1
Xctl_sg13g2_xor2_1_1 ctl_sg13g2_xor2_1_1_X VPWR ctl_sg13g2_xor2_1_1_B ctl_sg13g2_xor2_1_1_A VGND
+ ctl_sg13g2_xor2_1
Xctl_sg13g2_dfrbpq_1_11 clk VGND ctl_sg13g2_nor2_1_6_Y ctl_sg13g2_dfrbpq_1_11_Q VPWR ctl_sg13g2_inv_1_18_Y
+ ctl_sg13g2_dfrbpq_1
Xctl_sg13g2_nor2b_1_0 ctl_sg13g2_xor2_1_1_B ctl_sg13g2_nor3_1_4_Y VPWR ctl_sg13g2_nor2b_1_0_Y VGND
+ ctl_sg13g2_nor2b_1
Xctl_sg13g2_nand2_1_2 ctl_sg13g2_nor2_1_9_A VPWR ctl_sg13g2_nor2b_1_0_Y VGND ctl_sg13g2_nand2_1_3_A
+ ctl_sg13g2_nand2_1
Xctl_sg13g2_nand3b_1_0 ctl_sg13g2_nor3_1_4_B ctl_sg13g2_and2_1_3_B VPWR VGND ctl_sg13g2_xor2_1_1_A
+ ctl_sg13g2_xor2_1_1_B ctl_sg13g2_nand3b_1
Xctl_sg13g2_nor3_1_5 ctl_sg13g2_nor3_1_5_A ctl_sg13g2_nor3_1_5_Y ctl_sg13g2_nor3_1_5_B ctl_sg13g2_nor3_1_5_C
+ VPWR VGND ctl_sg13g2_nor3_1
Xctl_sg13g2_inv_1_14 ctl_sg13g2_inv_1_14_Y ctl_sg13g2_inv_1_9_A VGND VPWR ctl_sg13g2_inv_1
Xctl_sg13g2_inv_1_25 ctl_sg13g2_inv_1_25_Y ctl_sg13g2_nor3_1_4_B VGND VPWR ctl_sg13g2_inv_1
Xctl_sg13g2_dfrbpq_1_12 clk VGND ctl_sg13g2_o21ai_1_1_Y ctl_sg13g2_buf_1_11_A VPWR ctl_sg13g2_inv_1_28_Y
+ ctl_sg13g2_dfrbpq_1
Xctl_sg13g2_nor2b_1_1 ctl_sg13g2_nor2b_1_1_A ctl_sg13g2_buf_1_9_X VPWR ctl_sg13g2_nor2b_1_1_Y VGND
+ ctl_sg13g2_nor2b_1
Xctl_sg13g2_nand2_1_3 ctl_sg13g2_nand2_1_3_Y VPWR ctl_sg13g2_nand2_1_3_A VGND ctl_sg13g2_nor2_1_9_B
+ ctl_sg13g2_nand2_1
Xctl_sg13g2_nor3_1_6 ctl_sg13g2_inv_1_0_A ctl_sg13g2_nor3_1_6_Y ctl_sg13g2_nor3_1_6_B ctl_sg13g2_nor3_1_6_C
+ VPWR VGND ctl_sg13g2_nor3_1
Xctl_sg13g2_inv_1_15 ctl_sg13g2_nor2_1_5_A ctl_sg13g2_nor3_1_1_C VGND VPWR ctl_sg13g2_inv_1
Xctl_sg13g2_inv_1_26 ctl_sg13g2_buf_1_2_A ctl_sg13g2_inv_1_26_A VGND VPWR ctl_sg13g2_inv_1
Xctl_sg13g2_dfrbpq_1_13 clk VGND ctl_sg13g2_nor3_1_6_Y ctl_sg13g2_buf_1_16_A VPWR ctl_sg13g2_inv_1_24_Y
+ ctl_sg13g2_dfrbpq_1
Xctl_sg13g2_nand2_1_4 ctl_sg13g2_nor3_1_6_B VPWR ctl_sg13g2_nand2_1_4_A VGND ctl_sg13g2_nand2_1_4_B
+ ctl_sg13g2_nand2_1
Xctl_sg13g2_inv_1_27 ctl_sg13g2_inv_1_27_Y ctl_sg13g2_nor3_1_4_A VGND VPWR ctl_sg13g2_inv_1
Xctl_sg13g2_inv_1_16 ctl_sg13g2_inv_1_16_Y ctl_sg13g2_buf_1_8_A VGND VPWR ctl_sg13g2_inv_1
Xctl_sg13g2_dfrbpq_1_0 clk VGND ctl_sg13g2_nor3_1_5_Y ctl_sg13g2_buf_1_1_A VPWR ctl_sg13g2_inv_1_1_Y
+ ctl_sg13g2_dfrbpq_1
Xctl_sg13g2_dfrbpq_1_14 clk VGND ctl_sg13g2_dfrbpq_1_14_D ctl_sg13g2_dfrbpq_1_14_Q VPWR ctl_sg13g2_inv_1_23_Y
+ ctl_sg13g2_dfrbpq_1
Xctl_sg13g2_nand2_1_5 ctl_sg13g2_nand2_1_5_Y VPWR ctl_sg13g2_nor3_1_3_B VGND ctl_sg13g2_o21ai_1_2_Y
+ ctl_sg13g2_nand2_1
Xctl_sg13g2_inv_1_17 ctl_sg13g2_inv_1_17_Y ctl_sg13g2_buf_1_8_A VGND VPWR ctl_sg13g2_inv_1
Xctl_sg13g2_inv_1_28 ctl_sg13g2_inv_1_28_Y ctl_sg13g2_buf_1_8_A VGND VPWR ctl_sg13g2_inv_1
Xctl_sg13g2_dfrbpq_1_1 clk VGND ctl_sg13g2_inv_1_0_Y ctl_sg13g2_buf_1_14_A VPWR ctl_sg13g2_inv_1_6_Y
+ ctl_sg13g2_dfrbpq_1
Xctl_sg13g2_dfrbpq_1_15 clk VGND ctl_sg13g2_nor2b_1_1_Y ctl_sg13g2_dfrbpq_1_15_Q VPWR ctl_sg13g2_inv_1_22_Y
+ ctl_sg13g2_dfrbpq_1
Xctl_sg13g2_inv_1_18 ctl_sg13g2_inv_1_18_Y ctl_sg13g2_inv_1_9_A VGND VPWR ctl_sg13g2_inv_1
Xctl_sg13g2_dfrbpq_1_2 clk VGND ctl_sg13g2_nor3_1_6_B ctl_sg13g2_xor2_1_1_B VPWR ctl_sg13g2_inv_1_5_Y
+ ctl_sg13g2_dfrbpq_1
Xctl_sg13g2_dfrbpq_1_16 clk VGND ctl_sg13g2_inv_1_19_Y ctl_sg13g2_dfrbpq_1_16_Q VPWR ctl_sg13g2_inv_1_20_Y
+ ctl_sg13g2_dfrbpq_1
Xctl_sg13g2_inv_1_19 ctl_sg13g2_inv_1_19_Y ctl_sg13g2_inv_1_19_A VGND VPWR ctl_sg13g2_inv_1
Xctl_sg13g2_dfrbpq_1_3 clk VGND ctl_sg13g2_a21oi_1_0_Y ctl_sg13g2_inv_1_26_A VPWR ctl_sg13g2_inv_1_3_Y
+ ctl_sg13g2_dfrbpq_1
Xctl_sg13g2_dfrbpq_1_17 clk VGND ctl_sg13g2_nor3_1_3_Y ctl_sg13g2_dfrbpq_1_17_Q VPWR ctl_sg13g2_inv_1_21_Y
+ ctl_sg13g2_dfrbpq_1
Xctl_sg13g2_nor2_1_0 ctl_sg13g2_nor3_1_3_B VPWR ctl_sg13g2_nor4_1_0_B VGND ctl_sg13g2_xor2_1_0_X
+ ctl_sg13g2_nor2_1
Xctl_sg13g2_dfrbpq_1_4 clk VGND ctl_sg13g2_nor3_1_5_B ctl_sg13g2_nor3_1_4_B VPWR ctl_sg13g2_inv_1_2_Y
+ ctl_sg13g2_dfrbpq_1
Xctl_sg13g2_dfrbpq_1_18 clk VGND ctl_sg13g2_and3_1_0_X ctl_sg13g2_inv_1_4_A VPWR ctl_sg13g2_inv_1_7_Y
+ ctl_sg13g2_dfrbpq_1
Xctl_sg13g2_dlygate4sd3_1_10 ctl_sg13g2_dfrbpq_1_15_Q VPWR VGND ctl_sg13g2_a21oi_1_3_B1
+ ctl_sg13g2_dlygate4sd3_1
Xctl_sg13g2_nor2_1_1 ctl_sg13g2_inv_1_0_A VPWR ctl_sg13g2_nor2_1_1_Y VGND ctl_sg13g2_nor3_1_6_B
+ ctl_sg13g2_nor2_1
Xctl_sg13g2_dfrbpq_1_5 clk VGND ctl_sg13g2_nor2_1_2_Y ctl_sg13g2_buf_1_4_A VPWR ctl_sg13g2_inv_1_8_Y
+ ctl_sg13g2_dfrbpq_1
Xctl_sg13g2_and2_1_0 ctl_sg13g2_nor3_1_2_A VGND VPWR ctl_sg13g2_nor3_1_3_A ctl_sg13g2_nor3_1_1_C
+ ctl_sg13g2_and2_1
Xctl_sg13g2_dfrbpq_1_19 clk VGND ctl_sg13g2_nor3_1_5_A ctl_sg13g2_nor3_1_4_A VPWR ctl_sg13g2_inv_1_10_Y
+ ctl_sg13g2_dfrbpq_1
Xctl_sg13g2_dlygate4sd3_1_11 ctl_sg13g2_a21o_1_1_X VPWR VGND ctl_sg13g2_dfrbpq_1_14_D ctl_sg13g2_dlygate4sd3_1
Xctl_sg13g2_nor2_1_2 ctl_sg13g2_nor2_1_2_A VPWR ctl_sg13g2_nor2_1_2_Y VGND ctl_sg13g2_nor3_1_5_C
+ ctl_sg13g2_nor2_1
Xctl_sg13g2_dfrbpq_1_6 clk VGND ctl_sg13g2_nor4_1_0_B ctl_sg13g2_or2_1_0_A VPWR ctl_sg13g2_inv_1_9_Y
+ ctl_sg13g2_dfrbpq_1
Xctl_sg13g2_and2_1_1 ctl_sg13g2_nor3_1_3_A VGND VPWR ctl_sg13g2_nor3_1_1_A ctl_sg13g2_nor2_1_7_A
+ ctl_sg13g2_and2_1
Xctl_sg13g2_dlygate4sd3_1_12 ctl_sg13g2_dfrbpq_1_14_Q VPWR VGND ctl_sg13g2_a21o_1_1_A1
+ ctl_sg13g2_dlygate4sd3_1
Xctl_sg13g2_nor2_1_3 ctl_sg13g2_nor3_1_1_B VPWR ctl_sg13g2_nor3_1_0_C VGND ctl_sg13g2_nor3_1_2_A
+ ctl_sg13g2_nor2_1
Xctl_sg13g2_dfrbpq_1_7 clk VGND ctl_sg13g2_o21ai_1_3_Y ctl_sg13g2_buf_1_3_A VPWR ctl_sg13g2_inv_1_13_Y
+ ctl_sg13g2_dfrbpq_1
Xctl_sg13g2_and2_1_2 ctl_sg13g2_and2_1_2_X VGND VPWR ctl_sg13g2_and2_1_2_B ctl_sg13g2_xor2_1_1_X
+ ctl_sg13g2_and2_1
Xctl_sg13g2_buf_1_0 PC ctl_sg13g2_inv_1_4_Y VGND VPWR ctl_sg13g2_buf_1
Xctl_sg13g2_inv_1_0 ctl_sg13g2_inv_1_0_Y ctl_sg13g2_inv_1_0_A VGND VPWR ctl_sg13g2_inv_1
Xctl_sg13g2_dlygate4sd3_1_13 ctl_sg13g2_o21ai_1_7_Y VPWR VGND ctl_sg13g2_inv_1_19_A ctl_sg13g2_dlygate4sd3_1
Xctl_sg13g2_nor2_1_4 ctl_sg13g2_nor3_1_1_C VPWR ctl_sg13g2_nor3_1_2_C VGND ctl_sg13g2_nor3_1_3_A
+ ctl_sg13g2_nor2_1
Xctl_sg13g2_dfrbpq_1_8 clk VGND ctl_sg13g2_nor4_1_0_A ctl_sg13g2_dfrbpq_1_8_Q VPWR ctl_sg13g2_inv_1_16_Y
+ ctl_sg13g2_dfrbpq_1

.ends CAM_CONTROL

**************************************************
* SUBCKT: ctl_sg13g2_and2_1
**************************************************

.subckt ctl_sg13g2_and2_1 X VSS VDD B A

MP0 X a_45_160 VDD VDD sg13_lv_pmos w=1120n l=130n ng=1 m=1
MN1 X a_45_160 VSS VSS sg13_lv_nmos w=740n l=130n ng=1 m=1
MP2 a_45_160 A VDD VDD sg13_lv_pmos w=840n l=130n ng=1 m=1
MP3 VDD B a_45_160 VDD sg13_lv_pmos w=840n l=130n ng=1 m=1
MN4 a_139_160 A a_45_160 VSS sg13_lv_nmos w=640n l=130n ng=1 m=1
MN5 VSS B a_139_160 VSS sg13_lv_nmos w=640n l=130n ng=1 m=1

.ends ctl_sg13g2_and2_1

**************************************************
* SUBCKT: ctl_sg13g2_nand2b_1
**************************************************

.subckt ctl_sg13g2_nand2b_1 VSS A_N Y B VDD

MP0 VDD A_N a_27_156 VDD sg13_lv_pmos w=840n l=130n ng=1 m=1
MP1 Y B VDD VDD sg13_lv_pmos w=1120n l=130n ng=1 m=1
MN2 Y a_27_156 a_229_118 VSS sg13_lv_nmos w=740n l=130n ng=1 m=1
MN3 VSS A_N a_27_156 VSS sg13_lv_nmos w=550n l=130n ng=1 m=1
MP4 VDD a_27_156 Y VDD sg13_lv_pmos w=1120n l=130n ng=1 m=1
MN5 a_229_118 B VSS VSS sg13_lv_nmos w=740n l=130n ng=1 m=1

.ends ctl_sg13g2_nand2b_1

**************************************************
* SUBCKT: ctl_sg13g2_inv_1
**************************************************

.subckt ctl_sg13g2_inv_1 Y A VSS VDD

MP0 Y A VDD VDD sg13_lv_pmos w=1120n l=130n ng=1 m=1
MN1 Y A VSS VSS sg13_lv_nmos w=740n l=130n ng=1 m=1

.ends ctl_sg13g2_inv_1

**************************************************
* SUBCKT: ctl_sg13g2_buf_1
**************************************************

.subckt ctl_sg13g2_buf_1 X A VSS VDD

MN0 X a_40_152 VSS VSS sg13_lv_nmos w=740n l=130n ng=1 m=1
MP1 X a_40_152 VDD VDD sg13_lv_pmos w=1120n l=130n ng=1 m=1
MP2 VDD A a_40_152 VDD sg13_lv_pmos w=840n l=130n ng=1 m=1
MN3 VSS A a_40_152 VSS sg13_lv_nmos w=550n l=130n ng=1 m=1

.ends ctl_sg13g2_buf_1

**************************************************
* SUBCKT: ctl_sg13g2_dlygate4sd3_1
**************************************************

.subckt ctl_sg13g2_dlygate4sd3_1 A VDD VSS X

MP0 VDD A a_56_118 VDD sg13_lv_pmos w=420n l=130n ng=1 m=1
MN1 VSS a_326_118 a_438_182 VSS sg13_lv_nmos w=420n l=500n ng=1 m=1
MP2 VDD a_326_118 a_438_182 VDD sg13_lv_pmos w=1u l=500n ng=1 m=1
MP3 X a_438_182 VDD VDD sg13_lv_pmos w=1120n l=130n ng=1 m=1
MP4 a_326_118 a_56_118 VDD VDD sg13_lv_pmos w=1u l=500n ng=1 m=1
MN5 VSS A a_56_118 VSS sg13_lv_nmos w=420n l=130n ng=1 m=1
MN6 X a_438_182 VSS VSS sg13_lv_nmos w=740n l=130n ng=1 m=1
MN7 a_326_118 a_56_118 VSS VSS sg13_lv_nmos w=420n l=500n ng=1 m=1

.ends ctl_sg13g2_dlygate4sd3_1

**************************************************
* SUBCKT: ctl_sg13g2_nor2_1
**************************************************

.subckt ctl_sg13g2_nor2_1 A VDD Y VSS B

MN0 Y A VSS VSS sg13_lv_nmos w=740n l=130n ng=1 m=1
MP1 a_170_412 A VDD VDD sg13_lv_pmos w=1120n l=130n ng=1 m=1
MN2 VSS B Y VSS sg13_lv_nmos w=740n l=130n ng=1 m=1
MP3 Y B a_170_412 VDD sg13_lv_pmos w=1120n l=130n ng=1 m=1

.ends ctl_sg13g2_nor2_1

**************************************************
* SUBCKT: ctl_sg13g2_dfrbpq_1
**************************************************

.subckt ctl_sg13g2_dfrbpq_1 CLK VSS D Q VDD RESET_B

MP0 VDD RESET_B a_298_337 VDD sg13_lv_pmos w=420n l=130n ng=1 m=1
MN1 VSS RESET_B a_132_114 VSS sg13_lv_nmos w=420n l=130n ng=1 m=1
MN2 a_550_127 RESET_B VSS VSS sg13_lv_nmos w=420n l=130n ng=1 m=1
MP3 a_298_337 a_741_93 a_681_505 VDD sg13_lv_pmos w=420n l=130n ng=1 m=1
MN4 a_1840_334 a_1583_191 a_2002_114 VSS sg13_lv_nmos w=420n l=130n ng=1 m=1
MP5 a_38_114 a_843_236 a_298_337 VDD sg13_lv_pmos w=420n l=130n ng=1 m=1
MN6 a_741_93 CLK VSS VSS sg13_lv_nmos w=740n l=130n ng=1 m=1
MP7 a_38_114 D VDD VDD sg13_lv_pmos w=420n l=130n ng=1 m=1
MP8 a_741_93 CLK VDD VDD sg13_lv_pmos w=1120n l=130n ng=1 m=1
MN9 VSS a_741_93 a_843_236 VSS sg13_lv_nmos w=740n l=130n ng=1 m=1
MN10 VSS a_1840_334 a_1489_191 VSS sg13_lv_nmos w=420n l=130n ng=1 m=1
MP11 VDD RESET_B a_38_114 VDD sg13_lv_pmos w=420n l=130n ng=1 m=1
MN12 a_324_432 a_298_337 VSS VSS sg13_lv_nmos w=740n l=130n ng=1 m=1
MP13 VDD a_741_93 a_843_236 VDD sg13_lv_pmos w=1120n l=130n ng=1 m=1
MN14 a_2002_114 RESET_B VSS VSS sg13_lv_nmos w=420n l=130n ng=1 m=1
MP15 VDD a_1583_191 a_2250_412 VDD sg13_lv_pmos w=1120n l=130n ng=1 m=1
MP16 Q a_2250_412 VDD VDD sg13_lv_pmos w=1120n l=130n ng=1 m=1
MN17 a_132_114 D a_38_114 VSS sg13_lv_nmos w=420n l=130n ng=1 m=1
MP18 a_1785_429 a_843_236 a_1583_191 VDD sg13_lv_pmos w=420n l=130n ng=1 m=1
MP19 VDD a_1583_191 a_1840_334 VDD sg13_lv_pmos w=420n l=130n ng=1 m=1
MP20 a_1583_191 a_741_93 a_324_432 VDD sg13_lv_pmos w=1u l=130n ng=1 m=1
MN21 a_1583_191 a_741_93 a_1489_191 VSS sg13_lv_nmos w=420n l=130n ng=1 m=1
MP22 VDD a_1840_334 a_1785_429 VDD sg13_lv_pmos w=420n l=130n ng=1 m=1
MP23 a_1840_334 RESET_B VDD VDD sg13_lv_pmos w=420n l=130n ng=1 m=1
MN24 a_324_432 a_843_236 a_1583_191 VSS sg13_lv_nmos w=740n l=130n ng=1 m=1
MN25 a_298_337 a_741_93 a_38_114 VSS sg13_lv_nmos w=420n l=130n ng=1 m=1
MN26 a_612_127 a_324_432 a_550_127 VSS sg13_lv_nmos w=420n l=130n ng=1 m=1
MP27 a_681_505 a_324_432 VDD VDD sg13_lv_pmos w=420n l=130n ng=1 m=1
MN28 a_612_127 a_843_236 a_298_337 VSS sg13_lv_nmos w=420n l=130n ng=1 m=1
MN29 VSS a_1583_191 a_2250_412 VSS sg13_lv_nmos w=740n l=130n ng=1 m=1
MP30 a_324_432 a_298_337 VDD VDD sg13_lv_pmos w=1u l=130n ng=1 m=1
MN31 Q a_2250_412 VSS VSS sg13_lv_nmos w=740n l=130n ng=1 m=1

.ends ctl_sg13g2_dfrbpq_1

**************************************************
* SUBCKT: ctl_sg13g2_nand4_1
**************************************************

.subckt ctl_sg13g2_nand4_1 VDD Y B C VSS A D

MN0 Y A a_350_122 VSS sg13_lv_nmos w=740n l=130n ng=1 m=1
MP1 Y D VDD VDD sg13_lv_pmos w=1120n l=130n ng=1 m=1
MP2 VDD C Y VDD sg13_lv_pmos w=1120n l=130n ng=1 m=1
MP3 Y B VDD VDD sg13_lv_pmos w=1120n l=130n ng=1 m=1
MP4 VDD A Y VDD sg13_lv_pmos w=1120n l=130n ng=1 m=1
MN5 a_146_122 D VSS VSS sg13_lv_nmos w=740n l=130n ng=1 m=1
MN6 a_248_122 C a_146_122 VSS sg13_lv_nmos w=740n l=130n ng=1 m=1
MN7 a_350_122 B a_248_122 VSS sg13_lv_nmos w=740n l=130n ng=1 m=1

.ends ctl_sg13g2_nand4_1

**************************************************
* SUBCKT: ctl_sg13g2_a221oi_1
**************************************************

.subckt ctl_sg13g2_a221oi_1 C1 Y B2 B1 A2 VDD A1 VSS

MN0 a_550_140 A1 Y VSS sg13_lv_nmos w=740n l=130n ng=1 m=1
MN1 VSS A2 a_550_140 VSS sg13_lv_nmos w=740n l=130n ng=1 m=1
MP2 a_142_412 C1 Y VDD sg13_lv_pmos w=1120n l=130n ng=1 m=1
MP3 a_244_412 B2 a_142_412 VDD sg13_lv_pmos w=1120n l=130n ng=1 m=1
MP4 a_142_412 B1 a_244_412 VDD sg13_lv_pmos w=1120n l=130n ng=1 m=1
MP5 a_244_412 A1 VDD VDD sg13_lv_pmos w=1120n l=130n ng=1 m=1
MP6 VDD A2 a_244_412 VDD sg13_lv_pmos w=1120n l=130n ng=1 m=1
MN7 VSS C1 Y VSS sg13_lv_nmos w=740n l=130n ng=1 m=1
MN8 a_244_140 B2 VSS VSS sg13_lv_nmos w=740n l=130n ng=1 m=1
MN9 Y B1 a_244_140 VSS sg13_lv_nmos w=740n l=130n ng=1 m=1

.ends ctl_sg13g2_a221oi_1

**************************************************
* SUBCKT: ctl_sg13g2_a21o_1
**************************************************

.subckt ctl_sg13g2_a21o_1 B1 X VDD VSS A1 A2

MN0 VSS a_115_308 X VSS sg13_lv_nmos w=740n l=130n ng=1 m=1
MP1 VDD A1 a_358_436 VDD sg13_lv_pmos w=1u l=130n ng=1 m=1
MN2 VSS A2 a_494_160 VSS sg13_lv_nmos w=640n l=130n ng=1 m=1
MP3 a_358_436 A2 VDD VDD sg13_lv_pmos w=1u l=130n ng=1 m=1
MN4 a_115_308 B1 VSS VSS sg13_lv_nmos w=640n l=130n ng=1 m=1
MN5 a_494_160 A1 a_115_308 VSS sg13_lv_nmos w=640n l=130n ng=1 m=1
MP6 a_358_436 B1 a_115_308 VDD sg13_lv_pmos w=1u l=130n ng=1 m=1
MP7 VDD a_115_308 X VDD sg13_lv_pmos w=1120n l=130n ng=1 m=1

.ends ctl_sg13g2_a21o_1

**************************************************
* SUBCKT: ctl_sg13g2_o21ai_1
**************************************************

.subckt ctl_sg13g2_o21ai_1 VSS VDD Y B1 A2 A1

MN0 VSS A1 a_22_110 VSS sg13_lv_nmos w=740n l=150n ng=1 m=1
MP1 a_120_432 A1 VDD VDD sg13_lv_pmos w=1120n l=150n ng=1 m=1
MN2 a_22_110 A2 VSS VSS sg13_lv_nmos w=740n l=150n ng=1 m=1
MN3 Y B1 a_22_110 VSS sg13_lv_nmos w=740n l=150n ng=1 m=1
MP4 Y A2 a_120_432 VDD sg13_lv_pmos w=1120n l=150n ng=1 m=1
MP5 VDD B1 Y VDD sg13_lv_pmos w=1120n l=150n ng=1 m=1

.ends ctl_sg13g2_o21ai_1

**************************************************
* SUBCKT: ctl_sg13g2_nor4_1
**************************************************

.subckt ctl_sg13g2_nor4_1 VSS VDD B C Y A D

MN0 Y C VSS VSS sg13_lv_nmos w=740n l=130n ng=1 m=1
MP1 a_252_412 B a_150_412 VDD sg13_lv_pmos w=1120n l=130n ng=1 m=1
MN2 VSS D Y VSS sg13_lv_nmos w=740n l=130n ng=1 m=1
MP3 a_354_412 C a_252_412 VDD sg13_lv_pmos w=1120n l=130n ng=1 m=1
MP4 Y D a_354_412 VDD sg13_lv_pmos w=1120n l=130n ng=1 m=1
MN5 Y A VSS VSS sg13_lv_nmos w=740n l=130n ng=1 m=1
MN6 VSS B Y VSS sg13_lv_nmos w=740n l=130n ng=1 m=1
MP7 a_150_412 A VDD VDD sg13_lv_pmos w=1120n l=130n ng=1 m=1

.ends ctl_sg13g2_nor4_1

**************************************************
* SUBCKT: ctl_sg13g2_decap_8
**************************************************

.subckt ctl_sg13g2_decap_8 VDD VSS

MP0 VDD VSS VDD VDD sg13_lv_pmos w=1u l=1u ng=1 m=1
MN1 VSS VDD VSS VSS sg13_lv_nmos w=420n l=1u ng=1 m=1
MP2 VDD VSS VDD VDD sg13_lv_pmos w=1u l=1u ng=1 m=1
MN3 VSS VDD VSS VSS sg13_lv_nmos w=420n l=1u ng=1 m=1

.ends ctl_sg13g2_decap_8

**************************************************
* SUBCKT: ctl_sg13g2_or2_1
**************************************************

.subckt ctl_sg13g2_or2_1 A VSS B X VDD

MP0 a_142_492 B a_48_492 VDD sg13_lv_pmos w=840n l=130n ng=1 m=1
MP1 VDD A a_142_492 VDD sg13_lv_pmos w=840n l=130n ng=1 m=1
MN2 X a_48_492 VSS VSS sg13_lv_nmos w=740n l=130n ng=1 m=1
MN3 VSS A a_48_492 VSS sg13_lv_nmos w=550n l=130n ng=1 m=1
MN4 a_48_492 B VSS VSS sg13_lv_nmos w=550n l=130n ng=1 m=1
MP5 X a_48_492 VDD VDD sg13_lv_pmos w=1120n l=130n ng=1 m=1

.ends ctl_sg13g2_or2_1

**************************************************
* SUBCKT: ctl_sg13g2_a22oi_1
**************************************************

.subckt ctl_sg13g2_a22oi_1 Y A2 VDD B1 A1 VSS B2

MN0 Y B2 a_127_96 VSS sg13_lv_nmos w=740n l=130n ng=1 m=1
MN1 a_398_96 A1 Y VSS sg13_lv_nmos w=740n l=130n ng=1 m=1
MP2 VDD A2 a_127_436 VDD sg13_lv_pmos w=1120n l=130n ng=1 m=1
MP3 Y B1 a_127_436 VDD sg13_lv_pmos w=1120n l=130n ng=1 m=1
MP4 a_127_436 B2 Y VDD sg13_lv_pmos w=1120n l=130n ng=1 m=1
MN5 a_127_96 B1 VSS VSS sg13_lv_nmos w=740n l=130n ng=1 m=1
MP6 a_127_436 A1 VDD VDD sg13_lv_pmos w=1120n l=130n ng=1 m=1
MN7 VSS A2 a_398_96 VSS sg13_lv_nmos w=740n l=130n ng=1 m=1

.ends ctl_sg13g2_a22oi_1

**************************************************
* SUBCKT: ctl_sg13g2_a21oi_1
**************************************************

.subckt ctl_sg13g2_a21oi_1 VDD VSS A2 A1 B1 Y

MN0 Y B1 VSS VSS sg13_lv_nmos w=740n l=130n ng=1 m=1
MN1 a_257_140 A1 Y VSS sg13_lv_nmos w=740n l=130n ng=1 m=1
MN2 VSS A2 a_257_140 VSS sg13_lv_nmos w=740n l=130n ng=1 m=1
MP3 a_155_412 B1 Y VDD sg13_lv_pmos w=1120n l=130n ng=1 m=1
MP4 VDD A1 a_155_412 VDD sg13_lv_pmos w=1120n l=130n ng=1 m=1
MP5 a_155_412 A2 VDD VDD sg13_lv_pmos w=1120n l=130n ng=1 m=1

.ends ctl_sg13g2_a21oi_1

**************************************************
* SUBCKT: ctl_sg13g2_decap_4
**************************************************

.subckt ctl_sg13g2_decap_4 VDD VSS

MP0 VDD VSS VDD VDD sg13_lv_pmos w=1u l=1u ng=1 m=1
MN1 VSS VDD VSS VSS sg13_lv_nmos w=420n l=1u ng=1 m=1

.ends ctl_sg13g2_decap_4

**************************************************
* SUBCKT: ctl_sg13g2_nor3_1
**************************************************

.subckt ctl_sg13g2_nor3_1 A Y B C VDD VSS

MN0 Y A VSS VSS sg13_lv_nmos w=770n l=130n ng=1 m=1
MP1 a_165_412 A VDD VDD sg13_lv_pmos w=1120n l=130n ng=1 m=1
MN2 VSS B Y VSS sg13_lv_nmos w=770n l=130n ng=1 m=1
MN3 Y C VSS VSS sg13_lv_nmos w=770n l=130n ng=1 m=1
MP4 a_279_412 B a_165_412 VDD sg13_lv_pmos w=1120n l=130n ng=1 m=1
MP5 Y C a_279_412 VDD sg13_lv_pmos w=1120n l=130n ng=1 m=1

.ends ctl_sg13g2_nor3_1

**************************************************
* SUBCKT: ctl_sg13g2_and3_1
**************************************************

.subckt ctl_sg13g2_and3_1 X B VDD VSS C A

MN0 a_170_160 A a_76_160 VSS sg13_lv_nmos w=640n l=130n ng=1 m=1
MN1 a_272_160 B a_170_160 VSS sg13_lv_nmos w=640n l=130n ng=1 m=1
MN2 VSS C a_272_160 VSS sg13_lv_nmos w=640n l=130n ng=1 m=1
MP3 VDD A a_76_160 VDD sg13_lv_pmos w=840n l=130n ng=1 m=1
MP4 a_76_160 B VDD VDD sg13_lv_pmos w=840n l=130n ng=1 m=1
MP5 VDD C a_76_160 VDD sg13_lv_pmos w=840n l=130n ng=1 m=1
MP6 X a_76_160 VDD VDD sg13_lv_pmos w=1120n l=130n ng=1 m=1
MN7 X a_76_160 VSS VSS sg13_lv_nmos w=740n l=130n ng=1 m=1

.ends ctl_sg13g2_and3_1

**************************************************
* SUBCKT: ctl_sg13g2_mux2_1
**************************************************

.subckt ctl_sg13g2_mux2_1 A1 X S VDD VSS A0

MN0 a_496_118 A0 a_382_118 VSS sg13_lv_nmos w=740n l=130n ng=1 m=1
MP1 a_382_118 A0 a_285_412 VDD sg13_lv_pmos w=1u l=130n ng=1 m=1
MP2 a_559_412 A1 a_382_118 VDD sg13_lv_pmos w=1u l=130n ng=1 m=1
MP3 VDD S a_59_156 VDD sg13_lv_pmos w=840n l=130n ng=1 m=1
MN4 VSS S a_59_156 VSS sg13_lv_nmos w=550n l=130n ng=1 m=1
MN5 X a_382_118 VSS VSS sg13_lv_nmos w=740n l=130n ng=1 m=1
MP6 X a_382_118 VDD VDD sg13_lv_pmos w=1120n l=130n ng=1 m=1
MN7 a_285_118 S VSS VSS sg13_lv_nmos w=740n l=130n ng=1 m=1
MP8 a_285_412 S VDD VDD sg13_lv_pmos w=1u l=130n ng=1 m=1
MN9 VSS a_59_156 a_496_118 VSS sg13_lv_nmos w=740n l=130n ng=1 m=1
MN10 a_382_118 A1 a_285_118 VSS sg13_lv_nmos w=740n l=130n ng=1 m=1
MP11 VDD a_59_156 a_559_412 VDD sg13_lv_pmos w=1u l=130n ng=1 m=1

.ends ctl_sg13g2_mux2_1

**************************************************
* SUBCKT: ctl_sg13g2_nand2_1
**************************************************

.subckt ctl_sg13g2_nand2_1 Y VDD A VSS B

MN0 a_154_118 B VSS VSS sg13_lv_nmos w=740n l=130n ng=1 m=1
MN1 Y A a_154_118 VSS sg13_lv_nmos w=740n l=130n ng=1 m=1
MP2 Y B VDD VDD sg13_lv_pmos w=1120n l=130n ng=1 m=1
MP3 VDD A Y VDD sg13_lv_pmos w=1120n l=130n ng=1 m=1

.ends ctl_sg13g2_nand2_1

**************************************************
* SUBCKT: ctl_sg13g2_xor2_1
**************************************************

.subckt ctl_sg13g2_xor2_1 X VDD B A VSS

MN0 X B a_474_130 VSS sg13_lv_nmos w=740n l=130n ng=1 m=1
MN1 VSS a_209_168 X VSS sg13_lv_nmos w=740n l=130n ng=1 m=1
MP2 VDD A a_380_412 VDD sg13_lv_pmos w=1120n l=130n ng=1 m=1
MP3 a_380_412 B VDD VDD sg13_lv_pmos w=1120n l=130n ng=1 m=1
MP4 X a_209_168 a_380_412 VDD sg13_lv_pmos w=1120n l=130n ng=1 m=1
MP5 a_177_436 A VDD VDD sg13_lv_pmos w=1u l=130n ng=1 m=1
MN6 a_209_168 A VSS VSS sg13_lv_nmos w=550n l=130n ng=1 m=1
MP7 a_209_168 B a_177_436 VDD sg13_lv_pmos w=1u l=130n ng=1 m=1
MN8 VSS B a_209_168 VSS sg13_lv_nmos w=550n l=130n ng=1 m=1
MN9 a_474_130 A VSS VSS sg13_lv_nmos w=740n l=130n ng=1 m=1

.ends ctl_sg13g2_xor2_1

**************************************************
* SUBCKT: ctl_sg13g2_nor2b_1
**************************************************

.subckt ctl_sg13g2_nor2b_1 A B_N VDD Y VSS

MP0 VDD B_N a_46_156 VDD sg13_lv_pmos w=840n l=130n ng=1 m=1
MN1 VSS B_N a_46_156 VSS sg13_lv_nmos w=550n l=130n ng=1 m=1
MN2 Y a_46_156 VSS VSS sg13_lv_nmos w=740n l=130n ng=1 m=1
MP3 a_268_412 a_46_156 VDD VDD sg13_lv_pmos w=1120n l=130n ng=1 m=1
MN4 VSS A Y VSS sg13_lv_nmos w=740n l=130n ng=1 m=1
MP5 Y A a_268_412 VDD sg13_lv_pmos w=1120n l=130n ng=1 m=1

.ends ctl_sg13g2_nor2b_1

**************************************************
* SUBCKT: ctl_sg13g2_nand3b_1
**************************************************

.subckt ctl_sg13g2_nand3b_1 A_N Y VDD VSS B C

MN0 a_318_122 C VSS VSS sg13_lv_nmos w=740n l=130n ng=1 m=1
MN1 a_420_122 B a_318_122 VSS sg13_lv_nmos w=740n l=130n ng=1 m=1
MN2 Y a_94_160 a_420_122 VSS sg13_lv_nmos w=740n l=130n ng=1 m=1
MN3 VSS A_N a_94_160 VSS sg13_lv_nmos w=550n l=130n ng=1 m=1
MP4 VDD A_N a_94_160 VDD sg13_lv_pmos w=840n l=130n ng=1 m=1
MP5 Y C VDD VDD sg13_lv_pmos w=1120n l=130n ng=1 m=1
MP6 VDD B Y VDD sg13_lv_pmos w=1120n l=130n ng=1 m=1
MP7 Y a_94_160 VDD VDD sg13_lv_pmos w=1120n l=130n ng=1 m=1

.ends ctl_sg13g2_nand3b_1

**************************************************
* SUBCKT: REFERENCE_MUX
**************************************************

.subckt REFERENCE_MUX REF_SEL RSLN[0] RSLN[10] RSLN[11] RSLN[12] RSLN[13] RSLN[14] RSLN[15] RSLN[16] RSLN[17]
+ RSLN[18] RSLN[19] RSLN[1] RSLN[20] RSLN[21] RSLN[22] RSLN[23] RSLN[24] RSLN[25] RSLN[26] RSLN[27] RSLN[28]
+ RSLN[29] RSLN[2] RSLN[30] RSLN[31] RSLN[3] RSLN[4] RSLN[5] RSLN[6] RSLN[7] RSLN[8] RSLN[9] RSL[0] RSL[10]
+ RSL[11] RSL[12] RSL[13] RSL[14] RSL[15] RSL[16] RSL[17] RSL[18] RSL[19] RSL[1] RSL[20] RSL[21] RSL[22]
+ RSL[23] RSL[24] RSL[25] RSL[26] RSL[27] RSL[28] RSL[29] RSL[2] RSL[30] RSL[31] RSL[3] RSL[4] RSL[5] RSL[6]
+ RSL[7] RSL[8] RSL[9] SLN[0] SLN[10] SLN[11] SLN[12] SLN[13] SLN[14] SLN[15] SLN[16] SLN[17] SLN[18] SLN[19]
+ SLN[1] SLN[20] SLN[21] SLN[22] SLN[23] SLN[24] SLN[25] SLN[26] SLN[27] SLN[28] SLN[29] SLN[2] SLN[30]
+ SLN[31] SLN[3] SLN[4] SLN[5] SLN[6] SLN[7] SLN[8] SLN[9] SL[0] SL[10] SL[11] SL[12] SL[13] SL[14] SL[15]
+ SL[16] SL[17] SL[18] SL[19] SL[1] SL[20] SL[21] SL[22] SL[23] SL[24] SL[25] SL[26] SL[27] SL[28] SL[29]
+ SL[2] SL[30] SL[31] SL[3] SL[4] SL[5] SL[6] SL[7] SL[8] SL[9] VGND VPWR

Xfanout138 _39__A _34__A VPWR VGND sg13g2_buf_1
X_49_ _51__A _49__B_N VPWR _49__Y VGND sg13g2_nor2b_1
Xoutput97 _17__X RSLN[9] VPWR VGND sg13g2_buf_1
Xoutput75 _26__Y RSLN[18] VPWR VGND sg13g2_buf_1
Xoutput86 _36__Y RSLN[28] VPWR VGND sg13g2_buf_1
Xfanout139 input1_X _39__A VPWR VGND sg13g2_buf_1
X_48_ _51__A _48__B_N VPWR _48__Y VGND sg13g2_nor2b_1
Xoutput98 _40__Y RSL[0] VPWR VGND sg13g2_buf_1
Xoutput76 _27__Y RSLN[19] VPWR VGND sg13g2_buf_1
Xoutput87 _37__Y RSLN[29] VPWR VGND sg13g2_buf_1
X_47_ _47__A _47__B_N VPWR _47__Y VGND sg13g2_nor2b_1
Xoutput66 _08__X RSLN[0] VPWR VGND sg13g2_buf_1
Xoutput99 _50__Y RSL[10] VPWR VGND sg13g2_buf_1
Xoutput88 _10__X RSLN[2] VPWR VGND sg13g2_buf_1
Xoutput77 _09__X RSLN[1] VPWR VGND sg13g2_buf_1
X_63_ _63__A VGND _63__B _63__X VPWR sg13g2_or2_1
X_46_ _47__A _46__B_N VPWR _46__Y VGND sg13g2_nor2b_1
X_29_ _63__A _29__B_N VPWR _29__Y VGND sg13g2_nor2b_1
Xoutput67 _18__X RSLN[10] VPWR VGND sg13g2_buf_1
Xoutput78 _28__Y RSLN[20] VPWR VGND sg13g2_buf_1
Xoutput89 _38__Y RSLN[30] VPWR VGND sg13g2_buf_1
X_62_ _63__A VGND _62__B _62__X VPWR sg13g2_or2_1
X_28_ _63__A _28__B_N VPWR _28__Y VGND sg13g2_nor2b_1
X_45_ _47__A _45__B_N VPWR _45__Y VGND sg13g2_nor2b_1
Xoutput68 _19__X RSLN[11] VPWR VGND sg13g2_buf_1
Xoutput79 _29__Y RSLN[21] VPWR VGND sg13g2_buf_1
X_61_ _63__A VGND _61__B _61__X VPWR sg13g2_or2_1
X_44_ _47__A _44__B_N VPWR _44__Y VGND sg13g2_nor2b_1
X_27_ _59__A _27__B_N VPWR _27__Y VGND sg13g2_nor2b_1
Xoutput69 _20__X RSLN[12] VPWR VGND sg13g2_buf_1
X_60_ _63__A VGND _60__B _60__X VPWR sg13g2_or2_1
X_26_ _59__A _26__B_N VPWR _26__Y VGND sg13g2_nor2b_1
X_43_ _43__A _43__B_N VPWR _43__Y VGND sg13g2_nor2b_1
X_09_ _43__A VGND _09__B _09__X VPWR sg13g2_or2_1
X_42_ _43__A _42__B_N VPWR _42__Y VGND sg13g2_nor2b_1
X_08_ _43__A VGND _08__B _08__X VPWR sg13g2_or2_1
X_25_ _59__A _25__B_N VPWR _25__Y VGND sg13g2_nor2b_1
X_24_ _59__A input9_X VPWR _24__Y VGND sg13g2_nor2b_1
X_41_ _43__A _41__B_N VPWR _41__Y VGND sg13g2_nor2b_1
X_07_ _38__A VGND _07__B _07__X VPWR sg13g2_or2_1
X_40_ _43__A _40__B_N VPWR _40__Y VGND sg13g2_nor2b_1
X_23_ _55__A VGND _23__B _23__X VPWR sg13g2_or2_1
X_06_ _38__A VGND _06__B _06__X VPWR sg13g2_or2_1
X_22_ _55__A VGND _22__B _22__X VPWR sg13g2_or2_1
X_05_ _38__A VGND _05__B _05__X VPWR sg13g2_or2_1
X_21_ _55__A VGND _21__B _21__X VPWR sg13g2_or2_1
X_04_ _38__A VGND _04__B _04__X VPWR sg13g2_or2_1
X_03_ _34__A VGND _03__B _03__X VPWR sg13g2_or2_1
X_20_ _55__A VGND _20__B _20__X VPWR sg13g2_or2_1
Xinput1 REF_SEL input1_X VPWR VGND sg13g2_buf_1
Xinput2 SLN[0] _08__B VPWR VGND sg13g2_buf_1
X_02_ _34__A VGND _02__B _02__X VPWR sg13g2_or2_1
Xinput60 SL[4] _44__B_N VPWR VGND sg13g2_buf_1
X_01_ _34__A VGND _01__B _01__X VPWR sg13g2_or2_1
Xinput3 SLN[10] _18__B VPWR VGND sg13g2_buf_1
Xinput50 SL[24] _00__B VPWR VGND sg13g2_buf_1
Xinput61 SL[5] _45__B_N VPWR VGND sg13g2_buf_1
Xinput4 SLN[11] _19__B VPWR VGND sg13g2_buf_1
X_00_ _34__A VGND _00__B _00__X VPWR sg13g2_or2_1
Xinput51 SL[25] _01__B VPWR VGND sg13g2_buf_1
Xinput40 SL[15] _55__B_N VPWR VGND sg13g2_buf_1
Xinput62 SL[6] _46__B_N VPWR VGND sg13g2_buf_1
Xinput5 SLN[12] _20__B VPWR VGND sg13g2_buf_1
Xinput52 SL[26] _02__B VPWR VGND sg13g2_buf_1
Xinput41 SL[16] _56__B VPWR VGND sg13g2_buf_1
Xinput30 SLN[6] _14__B VPWR VGND sg13g2_buf_1
X_59_ _59__A VGND _59__B _59__X VPWR sg13g2_or2_1
Xinput63 SL[7] _47__B_N VPWR VGND sg13g2_buf_1
X_58_ _59__A VGND _58__B _58__X VPWR sg13g2_or2_1
Xinput6 SLN[13] _21__B VPWR VGND sg13g2_buf_1
Xinput42 SL[17] _57__B VPWR VGND sg13g2_buf_1
Xinput31 SLN[7] _15__B VPWR VGND sg13g2_buf_1
Xinput53 SL[27] _03__B VPWR VGND sg13g2_buf_1
Xinput20 SLN[26] _34__B_N VPWR VGND sg13g2_buf_1
Xinput64 SL[8] _48__B_N VPWR VGND sg13g2_buf_1
Xinput7 SLN[14] _22__B VPWR VGND sg13g2_buf_1
Xinput43 SL[18] _58__B VPWR VGND sg13g2_buf_1
Xinput10 SLN[17] _25__B_N VPWR VGND sg13g2_buf_1
X_57_ _59__A VGND _57__B _57__X VPWR sg13g2_or2_1
Xinput54 SL[28] _04__B VPWR VGND sg13g2_buf_1
Xinput65 SL[9] _49__B_N VPWR VGND sg13g2_buf_1
Xinput21 SLN[27] _35__B_N VPWR VGND sg13g2_buf_1
Xinput32 SLN[8] _16__B VPWR VGND sg13g2_buf_1
Xinput8 SLN[15] _23__B VPWR VGND sg13g2_buf_1
X_56_ _59__A VGND _56__B _56__X VPWR sg13g2_or2_1
Xoutput120 _42__Y RSL[2] VPWR VGND sg13g2_buf_1
X_39_ _39__A _39__B_N VPWR _39__Y VGND sg13g2_nor2b_1
Xinput44 SL[19] _59__B VPWR VGND sg13g2_buf_1
Xinput11 SLN[18] _26__B_N VPWR VGND sg13g2_buf_1
Xinput33 SLN[9] _17__B VPWR VGND sg13g2_buf_1
Xinput22 SLN[28] _36__B_N VPWR VGND sg13g2_buf_1
Xinput55 SL[29] _05__B VPWR VGND sg13g2_buf_1
Xinput9 SLN[16] input9_X VPWR VGND sg13g2_buf_1
Xinput12 SLN[19] _27__B_N VPWR VGND sg13g2_buf_1
Xinput23 SLN[29] _37__B_N VPWR VGND sg13g2_buf_1
X_55_ _55__A _55__B_N VPWR _55__Y VGND sg13g2_nor2b_1
Xinput56 SL[2] _42__B_N VPWR VGND sg13g2_buf_1
Xinput34 SL[0] _40__B_N VPWR VGND sg13g2_buf_1
Xinput45 SL[1] _41__B_N VPWR VGND sg13g2_buf_1
Xoutput110 _60__X RSL[20] VPWR VGND sg13g2_buf_1
Xoutput121 _06__X RSL[30] VPWR VGND sg13g2_buf_1
X_38_ _38__A _38__B_N VPWR _38__Y VGND sg13g2_nor2b_1
X_54_ _55__A _54__B_N VPWR _54__Y VGND sg13g2_nor2b_1
X_37_ _38__A _37__B_N VPWR _37__Y VGND sg13g2_nor2b_1
Xinput46 SL[20] _60__B VPWR VGND sg13g2_buf_1
Xinput57 SL[30] _06__B VPWR VGND sg13g2_buf_1
Xinput24 SLN[2] _10__B VPWR VGND sg13g2_buf_1
Xoutput100 _51__Y RSL[11] VPWR VGND sg13g2_buf_1
Xoutput111 _61__X RSL[21] VPWR VGND sg13g2_buf_1
Xoutput122 _07__X RSL[31] VPWR VGND sg13g2_buf_1
Xinput13 SLN[1] _09__B VPWR VGND sg13g2_buf_1
Xinput35 SL[10] _50__B_N VPWR VGND sg13g2_buf_1
Xinput14 SLN[20] _28__B_N VPWR VGND sg13g2_buf_1
Xinput36 SL[11] _51__B_N VPWR VGND sg13g2_buf_1
X_53_ _55__A _53__B_N VPWR _53__Y VGND sg13g2_nor2b_1
Xinput25 SLN[30] _38__B_N VPWR VGND sg13g2_buf_1
Xoutput123 _43__Y RSL[3] VPWR VGND sg13g2_buf_1
Xoutput101 _52__Y RSL[12] VPWR VGND sg13g2_buf_1
Xoutput112 _62__X RSL[22] VPWR VGND sg13g2_buf_1
Xinput47 SL[21] _61__B VPWR VGND sg13g2_buf_1
X_36_ _38__A _36__B_N VPWR _36__Y VGND sg13g2_nor2b_1
Xinput58 SL[31] _07__B VPWR VGND sg13g2_buf_1
X_19_ _51__A VGND _19__B _19__X VPWR sg13g2_or2_1
X_52_ _55__A _52__B_N VPWR _52__Y VGND sg13g2_nor2b_1
Xinput48 SL[22] _62__B VPWR VGND sg13g2_buf_1
Xinput15 SLN[21] _29__B_N VPWR VGND sg13g2_buf_1
X_35_ _38__A _35__B_N VPWR _35__Y VGND sg13g2_nor2b_1
Xinput26 SLN[31] _39__B_N VPWR VGND sg13g2_buf_1
Xoutput124 _44__Y RSL[4] VPWR VGND sg13g2_buf_1
Xoutput102 _53__Y RSL[13] VPWR VGND sg13g2_buf_1
Xinput37 SL[12] _52__B_N VPWR VGND sg13g2_buf_1
Xoutput113 _63__X RSL[23] VPWR VGND sg13g2_buf_1
Xinput59 SL[3] _43__B_N VPWR VGND sg13g2_buf_1
X_18_ _51__A VGND _18__B _18__X VPWR sg13g2_or2_1
X_51_ _51__A _51__B_N VPWR _51__Y VGND sg13g2_nor2b_1
Xoutput125 _45__Y RSL[5] VPWR VGND sg13g2_buf_1
Xoutput103 _54__Y RSL[14] VPWR VGND sg13g2_buf_1
Xoutput114 _00__X RSL[24] VPWR VGND sg13g2_buf_1
Xinput16 SLN[22] _30__B_N VPWR VGND sg13g2_buf_1
X_17_ _51__A VGND _17__B _17__X VPWR sg13g2_or2_1
Xinput38 SL[13] _53__B_N VPWR VGND sg13g2_buf_1
Xinput49 SL[23] _63__B VPWR VGND sg13g2_buf_1
X_34_ _34__A _34__B_N VPWR _34__Y VGND sg13g2_nor2b_1
Xinput27 SLN[3] _11__B VPWR VGND sg13g2_buf_1
Xinput39 SL[14] _54__B_N VPWR VGND sg13g2_buf_1
X_50_ _51__A _50__B_N VPWR _50__Y VGND sg13g2_nor2b_1
Xinput17 SLN[23] _31__B_N VPWR VGND sg13g2_buf_1
X_33_ _34__A _33__B_N VPWR _33__Y VGND sg13g2_nor2b_1
Xoutput126 _46__Y RSL[6] VPWR VGND sg13g2_buf_1
Xinput28 SLN[4] _12__B VPWR VGND sg13g2_buf_1
Xoutput104 _55__Y RSL[15] VPWR VGND sg13g2_buf_1
Xoutput115 _01__X RSL[25] VPWR VGND sg13g2_buf_1
X_16_ _51__A VGND _16__B _16__X VPWR sg13g2_or2_1
Xoutput127 _47__Y RSL[7] VPWR VGND sg13g2_buf_1
Xoutput105 _56__X RSL[16] VPWR VGND sg13g2_buf_1
Xoutput116 _02__X RSL[26] VPWR VGND sg13g2_buf_1
X_15_ _47__A VGND _15__B _15__X VPWR sg13g2_or2_1
X_32_ _34__A _32__B_N VPWR _32__Y VGND sg13g2_nor2b_1
Xinput18 SLN[24] _32__B_N VPWR VGND sg13g2_buf_1
Xinput29 SLN[5] _13__B VPWR VGND sg13g2_buf_1
X_31_ _34__A _31__B_N VPWR _31__Y VGND sg13g2_nor2b_1
Xoutput128 _48__Y RSL[8] VPWR VGND sg13g2_buf_1
Xoutput106 _57__X RSL[17] VPWR VGND sg13g2_buf_1
Xinput19 SLN[25] _33__B_N VPWR VGND sg13g2_buf_1
Xoutput117 _03__X RSL[27] VPWR VGND sg13g2_buf_1
X_14_ _47__A VGND _14__B _14__X VPWR sg13g2_or2_1
Xfanout130 fanout134_X _43__A VPWR VGND sg13g2_buf_1
Xoutput129 _49__Y RSL[9] VPWR VGND sg13g2_buf_1
Xoutput107 _58__X RSL[18] VPWR VGND sg13g2_buf_1
Xoutput118 _04__X RSL[28] VPWR VGND sg13g2_buf_1
X_30_ _63__A _30__B_N VPWR _30__Y VGND sg13g2_nor2b_1
Xfanout131 fanout134_X _47__A VPWR VGND sg13g2_buf_1
X_13_ _47__A VGND _13__B _13__X VPWR sg13g2_or2_1
Xoutput108 _59__X RSL[19] VPWR VGND sg13g2_buf_1
Xoutput119 _05__X RSL[29] VPWR VGND sg13g2_buf_1
Xoutput90 _39__Y RSLN[31] VPWR VGND sg13g2_buf_1
X_12_ _47__A VGND _12__B _12__X VPWR sg13g2_or2_1
Xfanout132 fanout134_X _51__A VPWR VGND sg13g2_buf_1
Xoutput109 _41__Y RSL[1] VPWR VGND sg13g2_buf_1
Xfanout133 fanout134_X _55__A VPWR VGND sg13g2_buf_1
Xoutput80 _30__Y RSLN[22] VPWR VGND sg13g2_buf_1
Xoutput91 _11__X RSLN[3] VPWR VGND sg13g2_buf_1
X_11_ _43__A VGND _11__B _11__X VPWR sg13g2_or2_1
Xoutput92 _12__X RSLN[4] VPWR VGND sg13g2_buf_1
Xoutput70 _21__X RSLN[13] VPWR VGND sg13g2_buf_1
Xoutput81 _31__Y RSLN[23] VPWR VGND sg13g2_buf_1
X_10_ _43__A VGND _10__B _10__X VPWR sg13g2_or2_1
Xfanout134 input1_X fanout134_X VPWR VGND sg13g2_buf_1
Xoutput93 _13__X RSLN[5] VPWR VGND sg13g2_buf_1
Xoutput71 _22__X RSLN[14] VPWR VGND sg13g2_buf_1
Xoutput82 _32__Y RSLN[24] VPWR VGND sg13g2_buf_1
Xfanout135 _39__A _59__A VPWR VGND sg13g2_buf_1
Xoutput94 _14__X RSLN[6] VPWR VGND sg13g2_buf_1
Xoutput72 _23__X RSLN[15] VPWR VGND sg13g2_buf_1
Xoutput83 _33__Y RSLN[25] VPWR VGND sg13g2_buf_1
Xfanout136 _39__A _63__A VPWR VGND sg13g2_buf_1
Xoutput95 _15__X RSLN[7] VPWR VGND sg13g2_buf_1
Xoutput73 _24__Y RSLN[16] VPWR VGND sg13g2_buf_1
Xoutput84 _34__Y RSLN[26] VPWR VGND sg13g2_buf_1
Xfanout137 _39__A _38__A VPWR VGND sg13g2_buf_1
Xoutput96 _16__X RSLN[8] VPWR VGND sg13g2_buf_1
Xoutput74 _25__Y RSLN[17] VPWR VGND sg13g2_buf_1
Xoutput85 _35__Y RSLN[27] VPWR VGND sg13g2_buf_1

.ends REFERENCE_MUX

**************************************************
* SUBCKT: sg13g2_buf_1
**************************************************

.subckt sg13g2_buf_1 A X VDD VSS

MN0 X a_40_152 VSS VSS sg13_lv_nmos w=740n l=130n ng=1 m=1
MP1 X a_40_152 VDD VDD sg13_lv_pmos w=1120n l=130n ng=1 m=1
MP2 VDD A a_40_152 VDD sg13_lv_pmos w=840n l=130n ng=1 m=1
MN3 VSS A a_40_152 VSS sg13_lv_nmos w=550n l=130n ng=1 m=1

.ends sg13g2_buf_1

**************************************************
* SUBCKT: sg13g2_nor2b_1
**************************************************

.subckt sg13g2_nor2b_1 A B_N VDD Y VSS

MP0 VDD B_N a_46_156 VDD sg13_lv_pmos w=840n l=130n ng=1 m=1
MN1 VSS B_N a_46_156 VSS sg13_lv_nmos w=550n l=130n ng=1 m=1
MN2 Y a_46_156 VSS VSS sg13_lv_nmos w=740n l=130n ng=1 m=1
MP3 a_268_412 a_46_156 VDD VDD sg13_lv_pmos w=1120n l=130n ng=1 m=1
MN4 VSS A Y VSS sg13_lv_nmos w=740n l=130n ng=1 m=1
MP5 Y A a_268_412 VDD sg13_lv_pmos w=1120n l=130n ng=1 m=1

.ends sg13g2_nor2b_1

**************************************************
* SUBCKT: sg13g2_or2_1
**************************************************

.subckt sg13g2_or2_1 A VSS B X VDD

MP0 a_142_492 B a_48_492 VDD sg13_lv_pmos w=840n l=130n ng=1 m=1
MP1 VDD A a_142_492 VDD sg13_lv_pmos w=840n l=130n ng=1 m=1
MN2 X a_48_492 VSS VSS sg13_lv_nmos w=740n l=130n ng=1 m=1
MN3 VSS A a_48_492 VSS sg13_lv_nmos w=550n l=130n ng=1 m=1
MN4 a_48_492 B VSS VSS sg13_lv_nmos w=550n l=130n ng=1 m=1
MP5 X a_48_492 VDD VDD sg13_lv_pmos w=1120n l=130n ng=1 m=1

.ends sg13g2_or2_1

**************************************************
* SUBCKT: decoder_5to32
**************************************************

.subckt decoder_5to32 VGND VPWR decoder_enable in[0] in[1] in[2] in[3] in[4] out[0] out[10] out[11] out[12]
+ out[13] out[14] out[15] out[16] out[17] out[18] out[19] out[1] out[20] out[21] out[22] out[23] out[24]
+ out[25] out[26] out[27] out[28] out[29] out[2] out[30] out[31] out[3] out[4] out[5] out[6] out[7] out[8]
+ out[9]

Xsg13g2_nand2b_1_0 VGND sg13g2_buf_1_16_X sg13g2_nor4_1_2_D sg13g2_buf_1_15_X VPWR sg13g2_nand2b_1
Xsg13g2_nor3_1_13 sg13g2_inv_1_0_Y sg13g2_buf_1_26_A sg13g2_or2_1_0_X sg13g2_nor3_1_6_B VPWR VGND
+ sg13g2_nor3_1
Xsg13g2_buf_1_1 sg13g2_buf_1_1_A out[12] VPWR VGND sg13g2_buf_1
Xsg13g2_buf_1_31 in[3] sg13g2_or3_1_0_B VPWR VGND sg13g2_buf_1
Xsg13g2_buf_1_20 sg13g2_buf_1_27_A sg13g2_nor4_1_1_B VPWR VGND sg13g2_buf_1
Xsg13g2_nor2_1_5 sg13g2_nor3_1_5_C VPWR sg13g2_buf_1_7_A VGND sg13g2_nor3_1_2_C sg13g2_nor2_1
Xsg13g2_nand2b_1_1 VGND sg13g2_or3_1_0_B sg13g2_nor4_1_1_D sg13g2_or3_1_0_A VPWR sg13g2_nand2b_1
Xsg13g2_buf_1_2 sg13g2_buf_1_2_A out[17] VPWR VGND sg13g2_buf_1
Xsg13g2_buf_1_21 sg13g2_buf_1_21_A out[1] VPWR VGND sg13g2_buf_1
Xsg13g2_buf_1_32 sg13g2_buf_1_32_A out[9] VPWR VGND sg13g2_buf_1
Xsg13g2_buf_1_10 sg13g2_nor2_1_3_Y out[21] VPWR VGND sg13g2_buf_1
Xsg13g2_nor2_1_6 sg13g2_nor3_1_8_B VPWR sg13g2_nor2_1_6_Y VGND sg13g2_nor3_1_0_C sg13g2_nor2_1
Xsg13g2_nand2b_1_2 VGND sg13g2_or3_1_0_A sg13g2_nor4_1_0_D sg13g2_or3_1_0_B VPWR sg13g2_nand2b_1
Xsg13g2_buf_1_3 sg13g2_buf_1_3_A out[16] VPWR VGND sg13g2_buf_1
Xsg13g2_buf_1_33 sg13g2_nor3_1_6_Y out[10] VPWR VGND sg13g2_buf_1
Xsg13g2_buf_1_22 in[2] sg13g2_buf_1_27_A VPWR VGND sg13g2_buf_1
Xsg13g2_buf_1_11 sg13g2_nor3_1_4_Y out[24] VPWR VGND sg13g2_buf_1
Xsg13g2_nor2_1_7 sg13g2_nor3_1_8_B VPWR sg13g2_nor2_1_7_Y VGND sg13g2_nor3_1_4_C sg13g2_nor2_1
Xsg13g2_buf_1_4 sg13g2_buf_1_4_A out[20] VPWR VGND sg13g2_buf_1
Xsg13g2_buf_1_34 sg13g2_buf_1_34_A out[7] VPWR VGND sg13g2_buf_1
Xsg13g2_or3_1_0 VPWR VGND sg13g2_or3_1_0_C sg13g2_or3_1_0_B sg13g2_or3_1_0_A sg13g2_or3_1_0_X sg13g2_or3_1
Xsg13g2_buf_1_23 in[4] sg13g2_or3_1_0_A VPWR VGND sg13g2_buf_1
Xsg13g2_buf_1_12 sg13g2_nor2_1_0_Y out[25] VPWR VGND sg13g2_buf_1
Xsg13g2_nor2_1_8 sg13g2_nor3_1_5_C VPWR sg13g2_nor2_1_8_Y VGND sg13g2_nor3_1_7_C sg13g2_nor2_1
Xsg13g2_buf_1_5 sg13g2_buf_1_5_A out[19] VPWR VGND sg13g2_buf_1
Xsg13g2_buf_1_24 sg13g2_buf_1_24_A out[3] VPWR VGND sg13g2_buf_1
Xsg13g2_buf_1_35 sg13g2_nor4_1_0_Y out[8] VPWR VGND sg13g2_buf_1
Xsg13g2_buf_1_13 sg13g2_nor2_1_6_Y out[23] VPWR VGND sg13g2_buf_1
Xsg13g2_nor2_1_9 sg13g2_nor3_1_8_B VPWR sg13g2_buf_1_0_A VGND sg13g2_nor3_1_7_C sg13g2_nor2_1
Xsg13g2_buf_1_6 sg13g2_buf_1_6_A out[30] VPWR VGND sg13g2_buf_1
Xsg13g2_buf_1_25 sg13g2_buf_1_25_A out[2] VPWR VGND sg13g2_buf_1
Xsg13g2_buf_1_14 sg13g2_nor2_1_1_Y out[31] VPWR VGND sg13g2_buf_1
Xsg13g2_buf_1_36 sg13g2_nor3_1_3_Y out[18] VPWR VGND sg13g2_buf_1
Xsg13g2_buf_1_7 sg13g2_buf_1_7_A out[29] VPWR VGND sg13g2_buf_1
Xsg13g2_buf_1_26 sg13g2_buf_1_26_A out[6] VPWR VGND sg13g2_buf_1
Xsg13g2_buf_1_15 decoder_enable sg13g2_buf_1_15_X VPWR VGND sg13g2_buf_1
Xsg13g2_buf_1_37 sg13g2_buf_1_9_X sg13g2_nor4_1_1_A VPWR VGND sg13g2_buf_1
Xsg13g2_buf_1_8 sg13g2_buf_1_8_A out[28] VPWR VGND sg13g2_buf_1
Xsg13g2_buf_1_27 sg13g2_buf_1_27_A sg13g2_or3_1_0_C VPWR VGND sg13g2_buf_1
Xsg13g2_buf_1_16 in[0] sg13g2_buf_1_16_X VPWR VGND sg13g2_buf_1
Xsg13g2_buf_1_38 sg13g2_nor3_1_8_Y out[11] VPWR VGND sg13g2_buf_1
Xsg13g2_buf_1_9 in[1] sg13g2_buf_1_9_X VPWR VGND sg13g2_buf_1
Xsg13g2_buf_1_39 sg13g2_nor3_1_5_Y out[5] VPWR VGND sg13g2_buf_1
Xsg13g2_buf_1_28 sg13g2_nor3_1_9_Y out[0] VPWR VGND sg13g2_buf_1
Xsg13g2_buf_1_17 sg13g2_nor2_1_7_Y out[27] VPWR VGND sg13g2_buf_1
Xsg13g2_nor2_1_10 sg13g2_or3_1_0_X VPWR sg13g2_buf_1_24_A VGND sg13g2_nor3_1_8_B sg13g2_nor2_1
Xsg13g2_buf_1_29 sg13g2_nor4_1_2_Y out[4] VPWR VGND sg13g2_buf_1
Xsg13g2_nor2_1_11 sg13g2_nor3_1_6_B VPWR sg13g2_buf_1_30_A VGND sg13g2_nor3_1_7_C sg13g2_nor2_1
Xsg13g2_buf_1_18 sg13g2_buf_1_18_A out[26] VPWR VGND sg13g2_buf_1
Xsg13g2_nor4_1_0 VGND VPWR sg13g2_or3_1_0_C sg13g2_nor4_1_2_D sg13g2_nor4_1_0_Y sg13g2_buf_1_9_X
+ sg13g2_nor4_1_0_D sg13g2_nor4_1
Xsg13g2_nor2_1_12 sg13g2_or3_1_0_X VPWR sg13g2_buf_1_25_A VGND sg13g2_nor3_1_6_B sg13g2_nor2_1
Xsg13g2_buf_1_19 sg13g2_nor2_1_8_Y out[13] VPWR VGND sg13g2_buf_1
Xsg13g2_nor4_1_1 VGND VPWR sg13g2_nor4_1_1_B sg13g2_nor4_1_2_D sg13g2_buf_1_3_A sg13g2_nor4_1_1_A
+ sg13g2_nor4_1_1_D sg13g2_nor4_1
Xsg13g2_nor2_1_13 sg13g2_or3_1_0_X VPWR sg13g2_buf_1_21_A VGND sg13g2_nor3_1_5_C sg13g2_nor2_1
Xsg13g2_nor4_1_2 VGND VPWR sg13g2_inv_1_0_Y sg13g2_or2_1_0_X sg13g2_nor4_1_2_Y sg13g2_buf_1_9_X
+ sg13g2_nor4_1_2_D sg13g2_nor4_1
Xsg13g2_nand3_1_0 VPWR sg13g2_nor3_1_8_B sg13g2_buf_1_16_X sg13g2_buf_1_15_X sg13g2_nor4_1_1_A VGND
+ sg13g2_nand3_1
Xsg13g2_nor2_1_14 sg13g2_nor3_1_6_B VPWR sg13g2_buf_1_18_A VGND sg13g2_nor3_1_4_C sg13g2_nor2_1
Xsg13g2_nand3_1_1 VPWR sg13g2_nor3_1_2_C sg13g2_or3_1_0_B sg13g2_nor4_1_1_B sg13g2_or3_1_0_A VGND
+ sg13g2_nand3_1
Xsg13g2_decap_8_0 VPWR VGND sg13g2_decap_8
Xsg13g2_or2_1_0 sg13g2_or3_1_0_A VGND sg13g2_or3_1_0_B sg13g2_or2_1_0_X VPWR sg13g2_or2_1
Xsg13g2_decap_8_1 VPWR VGND sg13g2_decap_8
Xsg13g2_decap_8_2 VPWR VGND sg13g2_decap_8
Xsg13g2_decap_8_3 VPWR VGND sg13g2_decap_8
Xsg13g2_decap_8_4 VPWR VGND sg13g2_decap_8
Xsg13g2_decap_8_5 VPWR VGND sg13g2_decap_8
Xsg13g2_decap_8_6 VPWR VGND sg13g2_decap_8
Xsg13g2_decap_4_0 VPWR VGND sg13g2_decap_4
Xsg13g2_nor3_1_0 sg13g2_nor4_1_1_A sg13g2_buf_1_4_A sg13g2_nor4_1_2_D sg13g2_nor3_1_0_C VPWR VGND
+ sg13g2_nor3_1
Xsg13g2_decap_8_7 VPWR VGND sg13g2_decap_8
Xsg13g2_decap_4_1 VPWR VGND sg13g2_decap_4
Xsg13g2_nor3_1_1 sg13g2_nor4_1_1_B sg13g2_buf_1_5_A sg13g2_nor3_1_8_B sg13g2_nor4_1_1_D VPWR VGND
+ sg13g2_nor3_1
Xsg13g2_nor3_1_2 sg13g2_nor4_1_1_A sg13g2_buf_1_8_A sg13g2_nor4_1_2_D sg13g2_nor3_1_2_C VPWR VGND
+ sg13g2_nor3_1
Xsg13g2_decap_4_2 VPWR VGND sg13g2_decap_4
Xsg13g2_nor3_1_3 sg13g2_nor4_1_1_B sg13g2_nor3_1_3_Y sg13g2_nor3_1_6_B sg13g2_nor4_1_1_D VPWR VGND
+ sg13g2_nor3_1
Xsg13g2_nor3_1_4 sg13g2_nor4_1_1_A sg13g2_nor3_1_4_Y sg13g2_nor4_1_2_D sg13g2_nor3_1_4_C VPWR VGND
+ sg13g2_nor3_1
Xsg13g2_nand3b_1_0 sg13g2_nor4_1_1_B sg13g2_nor3_1_4_C VPWR VGND sg13g2_or3_1_0_B sg13g2_or3_1_0_A
+ sg13g2_nand3b_1
Xsg13g2_nor3_1_5 sg13g2_inv_1_0_Y sg13g2_nor3_1_5_Y sg13g2_or2_1_0_X sg13g2_nor3_1_5_C VPWR VGND sg13g2_nor3_1
Xsg13g2_nand3b_1_1 sg13g2_nor4_1_1_A sg13g2_nor3_1_5_C VPWR VGND sg13g2_buf_1_16_X sg13g2_buf_1_15_X
+ sg13g2_nand3b_1
Xsg13g2_nor3_1_6 sg13g2_or3_1_0_C sg13g2_nor3_1_6_Y sg13g2_nor3_1_6_B sg13g2_nor4_1_0_D VPWR VGND
+ sg13g2_nor3_1
Xsg13g2_nand3b_1_2 sg13g2_buf_1_16_X sg13g2_nor3_1_6_B VPWR VGND sg13g2_buf_1_15_X sg13g2_nor4_1_1_A
+ sg13g2_nand3b_1
Xsg13g2_nor3_1_7 sg13g2_buf_1_9_X sg13g2_buf_1_1_A sg13g2_nor4_1_2_D sg13g2_nor3_1_7_C VPWR VGND sg13g2_nor3_1
Xsg13g2_nand3b_1_3 sg13g2_or3_1_0_A sg13g2_nor3_1_7_C VPWR VGND sg13g2_or3_1_0_B sg13g2_nor4_1_1_B
+ sg13g2_nand3b_1
Xsg13g2_nor3_1_8 sg13g2_or3_1_0_C sg13g2_nor3_1_8_Y sg13g2_nor3_1_8_B sg13g2_nor4_1_0_D VPWR VGND
+ sg13g2_nor3_1
Xsg13g2_nand3b_1_4 sg13g2_or3_1_0_B sg13g2_nor3_1_0_C VPWR VGND sg13g2_nor4_1_1_B sg13g2_or3_1_0_A
+ sg13g2_nand3b_1
Xsg13g2_nor3_1_9 sg13g2_nor4_1_1_A sg13g2_nor3_1_9_Y sg13g2_or3_1_0_X sg13g2_nor4_1_2_D VPWR VGND
+ sg13g2_nor3_1
Xsg13g2_nor2_1_0 sg13g2_nor3_1_5_C VPWR sg13g2_nor2_1_0_Y VGND sg13g2_nor3_1_4_C sg13g2_nor2_1
Xsg13g2_nor2_1_1 sg13g2_nor3_1_8_B VPWR sg13g2_nor2_1_1_Y VGND sg13g2_nor3_1_2_C sg13g2_nor2_1
Xsg13g2_nor3_1_10 sg13g2_or3_1_0_C sg13g2_buf_1_32_A sg13g2_nor3_1_5_C sg13g2_nor4_1_0_D VPWR VGND
+ sg13g2_nor3_1
Xsg13g2_nor2_1_2 sg13g2_nor3_1_6_B VPWR sg13g2_buf_1_6_A VGND sg13g2_nor3_1_2_C sg13g2_nor2_1
Xsg13g2_nor3_1_11 sg13g2_nor4_1_1_B sg13g2_buf_1_2_A sg13g2_nor3_1_5_C sg13g2_nor4_1_1_D VPWR VGND
+ sg13g2_nor3_1
Xsg13g2_buf_1_40 sg13g2_nor2_1_4_Y out[22] VPWR VGND sg13g2_buf_1
Xsg13g2_nor2_1_3 sg13g2_nor3_1_5_C VPWR sg13g2_nor2_1_3_Y VGND sg13g2_nor3_1_0_C sg13g2_nor2_1
Xsg13g2_nor3_1_12 sg13g2_inv_1_0_Y sg13g2_buf_1_34_A sg13g2_or2_1_0_X sg13g2_nor3_1_8_B VPWR VGND
+ sg13g2_nor3_1
Xsg13g2_buf_1_0 sg13g2_buf_1_0_A out[15] VPWR VGND sg13g2_buf_1
Xsg13g2_inv_1_0 sg13g2_inv_1_0_Y sg13g2_or3_1_0_C VGND VPWR sg13g2_inv_1
Xsg13g2_buf_1_30 sg13g2_buf_1_30_A out[14] VPWR VGND sg13g2_buf_1
Xsg13g2_nor2_1_4 sg13g2_nor3_1_6_B VPWR sg13g2_nor2_1_4_Y VGND sg13g2_nor3_1_0_C sg13g2_nor2_1

.ends decoder_5to32

**************************************************
* SUBCKT: sg13g2_nand2b_1
**************************************************

.subckt sg13g2_nand2b_1 VSS A_N Y B VDD

MP0 VDD A_N a_27_156 VDD sg13_lv_pmos w=840n l=130n ng=1 m=1
MP1 Y B VDD VDD sg13_lv_pmos w=1120n l=130n ng=1 m=1
MN2 Y a_27_156 a_229_118 VSS sg13_lv_nmos w=740n l=130n ng=1 m=1
MN3 VSS A_N a_27_156 VSS sg13_lv_nmos w=550n l=130n ng=1 m=1
MP4 VDD a_27_156 Y VDD sg13_lv_pmos w=1120n l=130n ng=1 m=1
MN5 a_229_118 B VSS VSS sg13_lv_nmos w=740n l=130n ng=1 m=1

.ends sg13g2_nand2b_1

**************************************************
* SUBCKT: sg13g2_nor3_1
**************************************************

.subckt sg13g2_nor3_1 A Y B C VDD VSS

MN0 Y A VSS VSS sg13_lv_nmos w=770n l=130n ng=1 m=1
MP1 a_165_412 A VDD VDD sg13_lv_pmos w=1120n l=130n ng=1 m=1
MN2 VSS B Y VSS sg13_lv_nmos w=770n l=130n ng=1 m=1
MN3 Y C VSS VSS sg13_lv_nmos w=770n l=130n ng=1 m=1
MP4 a_279_412 B a_165_412 VDD sg13_lv_pmos w=1120n l=130n ng=1 m=1
MP5 Y C a_279_412 VDD sg13_lv_pmos w=1120n l=130n ng=1 m=1

.ends sg13g2_nor3_1

**************************************************
* SUBCKT: sg13g2_nor2_1
**************************************************

.subckt sg13g2_nor2_1 A VDD Y VSS B

MN0 Y A VSS VSS sg13_lv_nmos w=740n l=130n ng=1 m=1
MP1 a_170_412 A VDD VDD sg13_lv_pmos w=1120n l=130n ng=1 m=1
MN2 VSS B Y VSS sg13_lv_nmos w=740n l=130n ng=1 m=1
MP3 Y B a_170_412 VDD sg13_lv_pmos w=1120n l=130n ng=1 m=1

.ends sg13g2_nor2_1

**************************************************
* SUBCKT: sg13g2_or3_1
**************************************************

.subckt sg13g2_or3_1 VDD VSS C B A X

MN0 VSS A a_73_118 VSS sg13_lv_nmos w=550n l=130n ng=1 m=1
MN1 X a_73_118 VSS VSS sg13_lv_nmos w=740n l=130n ng=1 m=1
MP2 VDD A a_269_412 VDD sg13_lv_pmos w=1u l=130n ng=1 m=1
MN3 VSS C a_73_118 VSS sg13_lv_nmos w=550n l=130n ng=1 m=1
MP4 a_167_412 C a_73_118 VDD sg13_lv_pmos w=1u l=130n ng=1 m=1
MP5 X a_73_118 VDD VDD sg13_lv_pmos w=1120n l=130n ng=1 m=1
MN6 a_73_118 B VSS VSS sg13_lv_nmos w=550n l=130n ng=1 m=1
MP7 a_269_412 B a_167_412 VDD sg13_lv_pmos w=1u l=130n ng=1 m=1

.ends sg13g2_or3_1

**************************************************
* SUBCKT: sg13g2_nor4_1
**************************************************

.subckt sg13g2_nor4_1 VSS VDD B C Y A D

MN0 Y C VSS VSS sg13_lv_nmos w=740n l=130n ng=1 m=1
MP1 a_252_412 B a_150_412 VDD sg13_lv_pmos w=1120n l=130n ng=1 m=1
MN2 VSS D Y VSS sg13_lv_nmos w=740n l=130n ng=1 m=1
MP3 a_354_412 C a_252_412 VDD sg13_lv_pmos w=1120n l=130n ng=1 m=1
MP4 Y D a_354_412 VDD sg13_lv_pmos w=1120n l=130n ng=1 m=1
MN5 Y A VSS VSS sg13_lv_nmos w=740n l=130n ng=1 m=1
MN6 VSS B Y VSS sg13_lv_nmos w=740n l=130n ng=1 m=1
MP7 a_150_412 A VDD VDD sg13_lv_pmos w=1120n l=130n ng=1 m=1

.ends sg13g2_nor4_1

**************************************************
* SUBCKT: sg13g2_nand3_1
**************************************************

.subckt sg13g2_nand3_1 VDD Y B C A VSS

MP0 Y C VDD VDD sg13_lv_pmos w=1120n l=130n ng=1 m=1
MP1 VDD B Y VDD sg13_lv_pmos w=1120n l=130n ng=1 m=1
MP2 Y A VDD VDD sg13_lv_pmos w=1120n l=130n ng=1 m=1
MN3 a_146_122 C VSS VSS sg13_lv_nmos w=740n l=130n ng=1 m=1
MN4 a_248_122 B a_146_122 VSS sg13_lv_nmos w=740n l=130n ng=1 m=1
MN5 Y A a_248_122 VSS sg13_lv_nmos w=740n l=130n ng=1 m=1

.ends sg13g2_nand3_1

**************************************************
* SUBCKT: sg13g2_decap_8
**************************************************

.subckt sg13g2_decap_8 VDD VSS

MP0 VDD VSS VDD VDD sg13_lv_pmos w=1u l=1u ng=1 m=1
MN1 VSS VDD VSS VSS sg13_lv_nmos w=420n l=1u ng=1 m=1
MP2 VDD VSS VDD VDD sg13_lv_pmos w=1u l=1u ng=1 m=1
MN3 VSS VDD VSS VSS sg13_lv_nmos w=420n l=1u ng=1 m=1

.ends sg13g2_decap_8

**************************************************
* SUBCKT: sg13g2_decap_4
**************************************************

.subckt sg13g2_decap_4 VDD VSS

MP0 VDD VSS VDD VDD sg13_lv_pmos w=1u l=1u ng=1 m=1
MN1 VSS VDD VSS VSS sg13_lv_nmos w=420n l=1u ng=1 m=1

.ends sg13g2_decap_4

**************************************************
* SUBCKT: sg13g2_nand3b_1
**************************************************

.subckt sg13g2_nand3b_1 A_N Y VDD VSS B C

MN0 a_318_122 C VSS VSS sg13_lv_nmos w=740n l=130n ng=1 m=1
MN1 a_420_122 B a_318_122 VSS sg13_lv_nmos w=740n l=130n ng=1 m=1
MN2 Y a_94_160 a_420_122 VSS sg13_lv_nmos w=740n l=130n ng=1 m=1
MN3 VSS A_N a_94_160 VSS sg13_lv_nmos w=550n l=130n ng=1 m=1
MP4 VDD A_N a_94_160 VDD sg13_lv_pmos w=840n l=130n ng=1 m=1
MP5 Y C VDD VDD sg13_lv_pmos w=1120n l=130n ng=1 m=1
MP6 VDD B Y VDD sg13_lv_pmos w=1120n l=130n ng=1 m=1
MP7 Y a_94_160 VDD VDD sg13_lv_pmos w=1120n l=130n ng=1 m=1

.ends sg13g2_nand3b_1

**************************************************
* SUBCKT: sg13g2_inv_1
**************************************************

.subckt sg13g2_inv_1 Y A VSS VDD

MP0 Y A VDD VDD sg13_lv_pmos w=1120n l=130n ng=1 m=1
MN1 Y A VSS VSS sg13_lv_nmos w=740n l=130n ng=1 m=1

.ends sg13g2_inv_1

**************************************************
* SUBCKT: shift_register_32
**************************************************

.subckt shift_register_32 VGND VPWR clk q[0] q[10] q[11] q[12] q[13] q[14] q[15] q[16] q[17] q[18] q[19] q[1]
+ q[20] q[21] q[22] q[23] q[24] q[25] q[26] q[27] q[28] q[29] q[2] q[30] q[31] q[3] q[4] q[5] q[6] q[7] q[8]
+ q[9] q_bar[0] q_bar[10] q_bar[11] q_bar[12] q_bar[13] q_bar[14] q_bar[15] q_bar[16] q_bar[17] q_bar[18]
+ q_bar[19] q_bar[1] q_bar[20] q_bar[21] q_bar[22] q_bar[23] q_bar[24] q_bar[25] q_bar[26] q_bar[27] q_bar[28]
+ q_bar[29] q_bar[2] q_bar[30] q_bar[31] q_bar[3] q_bar[4] q_bar[5] q_bar[6] q_bar[7] q_bar[8] q_bar[9] reset
+ serial_in_data shift_enable

X_277_ VPWR _277__D _277__Q clk VGND _277__97_L_HI sg13g2_dfrbpq_1
X_200_ _200__A VPWR _201__C VGND _202__A sg13g2_nor2_1
X_131_ _131__Y _284__Q VGND VPWR sg13g2_inv_1
Xoutput20 _267__Q q[24] VPWR VGND sg13g2_buf_1
Xoutput42 _157__Y q_bar[15] VPWR VGND sg13g2_buf_1
Xoutput64 _134__Y q_bar[6] VPWR VGND sg13g2_buf_1
Xoutput31 _280__Q q[5] VPWR VGND sg13g2_buf_1
Xoutput7 _287__Q q[12] VPWR VGND sg13g2_buf_1
Xoutput53 _147__Y q_bar[25] VPWR VGND sg13g2_buf_1
X_270__88 _270__88_L_HI VPWR VGND sg13g2_tiehi
Xhold160 _162__Y VPWR VGND _256__D sg13g2_dlygate4sd3_1
X_276_ VPWR _276__D _276__Q clk VGND _276__RESET_B sg13g2_dfrbpq_1
X_130_ _130__Y _285__Q VGND VPWR sg13g2_inv_1
X_259_ VPWR _259__D _259__Q clk VGND _259__RESET_B sg13g2_dfrbpq_1
X_267__94 _267__94_L_HI VPWR VGND sg13g2_tiehi
Xoutput43 _156__Y q_bar[16] VPWR VGND sg13g2_buf_1
Xoutput10 _258__Q q[15] VPWR VGND sg13g2_buf_1
Xoutput8 _256__Q q[13] VPWR VGND sg13g2_buf_1
Xoutput65 _133__Y q_bar[7] VPWR VGND sg13g2_buf_1
Xoutput32 _281__Q q[6] VPWR VGND sg13g2_buf_1
Xoutput21 _268__Q q[25] VPWR VGND sg13g2_buf_1
Xoutput54 _146__Y q_bar[26] VPWR VGND sg13g2_buf_1
Xhold161 _268__Q VPWR VGND _197__B sg13g2_dlygate4sd3_1
Xhold150 _255__Y VPWR VGND _287__D sg13g2_dlygate4sd3_1
X_275_ VPWR _275__D _275__Q clk VGND _275__RESET_B sg13g2_dfrbpq_1
X_258_ VPWR _258__D _258__Q clk VGND _258__RESET_B sg13g2_dfrbpq_1
X_189_ _195__A _265__D _189__B _189__C VPWR VGND sg13g2_nor3_1
Xoutput22 _269__Q q[26] VPWR VGND sg13g2_buf_1
Xoutput44 _155__Y q_bar[17] VPWR VGND sg13g2_buf_1
Xoutput11 _259__Q q[16] VPWR VGND sg13g2_buf_1
Xoutput9 _257__Q q[14] VPWR VGND sg13g2_buf_1
Xoutput33 _282__Q q[7] VPWR VGND sg13g2_buf_1
Xoutput66 _132__Y q_bar[8] VPWR VGND sg13g2_buf_1
Xoutput55 _145__Y q_bar[27] VPWR VGND sg13g2_buf_1
Xhold140 _262__Q VPWR VGND _181__A sg13g2_dlygate4sd3_1
Xhold151 _263__Q VPWR VGND _182__B sg13g2_dlygate4sd3_1
Xhold162 _266__Q VPWR VGND _191__B sg13g2_dlygate4sd3_1
X_274_ VPWR _274__D _274__Q clk VGND _274__RESET_B sg13g2_dfrbpq_1
X_264__100 _264__RESET_B VPWR VGND sg13g2_tiehi
X_257_ VPWR _257__D _257__Q clk VGND _257__RESET_B sg13g2_dfrbpq_1
X_188_ _191__A VPWR _189__C VGND _190__A sg13g2_nor2_1
Xoutput56 _144__Y q_bar[28] VPWR VGND sg13g2_buf_1
Xoutput45 _154__Y q_bar[18] VPWR VGND sg13g2_buf_1
Xoutput12 _260__Q q[17] VPWR VGND sg13g2_buf_1
Xoutput67 _131__Y q_bar[9] VPWR VGND sg13g2_buf_1
Xoutput34 _283__Q q[8] VPWR VGND sg13g2_buf_1
Xoutput23 _270__Q q[27] VPWR VGND sg13g2_buf_1
Xhold141 _279__Q VPWR VGND _230__B sg13g2_dlygate4sd3_1
X_273_ VPWR _273__D _273__Q clk VGND _273__RESET_B sg13g2_dfrbpq_1
Xhold130 _283__Q VPWR VGND _244__A sg13g2_dlygate4sd3_1
Xhold152 _265__Q VPWR VGND _190__A sg13g2_dlygate4sd3_1
X_187_ _187__A _191__A VPWR _189__B VGND sg13g2_nor2b_1
X_256_ VPWR _256__D _256__Q clk VGND _256__RESET_B sg13g2_dfrbpq_1
Xfanout80 _255__A _252__A VPWR VGND sg13g2_buf_1
X_239_ _251__B VPWR _240__C VGND _241__A sg13g2_nor2_1
Xoutput24 _271__Q q[28] VPWR VGND sg13g2_buf_1
Xoutput46 _153__Y q_bar[19] VPWR VGND sg13g2_buf_1
Xoutput13 _261__Q q[18] VPWR VGND sg13g2_buf_1
Xoutput35 _284__Q q[9] VPWR VGND sg13g2_buf_1
Xoutput57 _143__Y q_bar[29] VPWR VGND sg13g2_buf_1
Xhold131 _280__Q VPWR VGND _233__B sg13g2_dlygate4sd3_1
Xhold142 _231__Y VPWR VGND _279__D sg13g2_dlygate4sd3_1
Xhold120 _281__Q VPWR VGND _236__B sg13g2_dlygate4sd3_1
X_272_ VPWR _272__D _272__Q clk VGND _272__84_L_HI sg13g2_dfrbpq_1
Xhold153 _285__Q VPWR VGND _250__A sg13g2_dlygate4sd3_1
X_186_ _195__A _186__Y _186__B _186__C VPWR VGND sg13g2_nor3_1
Xfanout70 _247__B_N _245__A VPWR VGND sg13g2_buf_1
X_255_ _255__A _255__Y _255__B _255__C VPWR VGND sg13g2_nor3_1
Xfanout81 _195__A _213__A VPWR VGND sg13g2_buf_1
X_238_ _281__Q _251__B VPWR _240__B VGND sg13g2_nor2b_1
X_169_ _169__A _176__A VPWR _171__B VGND sg13g2_nor2b_1
Xoutput14 _262__Q q[19] VPWR VGND sg13g2_buf_1
Xoutput47 _139__Y q_bar[1] VPWR VGND sg13g2_buf_1
Xoutput25 _272__Q q[29] VPWR VGND sg13g2_buf_1
Xoutput58 _138__Y q_bar[2] VPWR VGND sg13g2_buf_1
Xoutput36 _140__Y q_bar[0] VPWR VGND sg13g2_buf_1
Xhold132 _234__Y VPWR VGND _280__D sg13g2_dlygate4sd3_1
Xhold121 _237__Y VPWR VGND _281__D sg13g2_dlygate4sd3_1
Xhold154 _278__Q VPWR VGND _227__B sg13g2_dlygate4sd3_1
Xhold143 _277__Q VPWR VGND _226__A sg13g2_dlygate4sd3_1
X_271_ VPWR _271__D _271__Q clk VGND _271__86_L_HI sg13g2_dfrbpq_1
X_185_ _191__A VPWR _186__C VGND _187__A sg13g2_nor2_1
Xfanout71 _247__B_N _251__B VPWR VGND sg13g2_buf_1
X_254_ _287__Q VPWR _255__C VGND _254__B sg13g2_nor2_1
Xfanout82 _255__A _195__A VPWR VGND sg13g2_buf_1
X_261__106 _261__RESET_B VPWR VGND sg13g2_tiehi
X_237_ _243__A _237__Y _237__B _237__C VPWR VGND sg13g2_nor3_1
X_168_ _252__A _258__D _168__B _168__C VPWR VGND sg13g2_nor3_1
Xoutput48 _152__Y q_bar[20] VPWR VGND sg13g2_buf_1
Xoutput37 _130__Y q_bar[10] VPWR VGND sg13g2_buf_1
Xoutput15 _276__Q q[1] VPWR VGND sg13g2_buf_1
Xoutput26 _277__Q q[2] VPWR VGND sg13g2_buf_1
Xoutput59 _142__Y q_bar[30] VPWR VGND sg13g2_buf_1
Xhold122 _257__Q VPWR VGND _166__A sg13g2_dlygate4sd3_1
Xhold133 _273__Q VPWR VGND _212__B sg13g2_dlygate4sd3_1
Xhold144 _225__Y VPWR VGND _277__D sg13g2_dlygate4sd3_1
Xhold155 _267__Q VPWR VGND _196__A sg13g2_dlygate4sd3_1
X_270_ VPWR _270__D _270__Q clk VGND _270__88_L_HI sg13g2_dfrbpq_1
X_184_ _263__Q _176__A VPWR _186__B VGND sg13g2_nor2b_1
X_253_ _253__A _254__B VPWR _255__B VGND sg13g2_nor2b_1
Xfanout72 _247__B_N _254__B VPWR VGND sg13g2_buf_1
Xfanout83 input1_X _255__A VPWR VGND sg13g2_buf_1
X_236_ _245__A VPWR _237__C VGND _236__B sg13g2_nor2_1
X_167_ _254__B VPWR _168__C VGND _169__A sg13g2_nor2_1
X_219_ _243__A _275__D _219__B _219__C VPWR VGND sg13g2_nor3_1
Xoutput49 _151__Y q_bar[21] VPWR VGND sg13g2_buf_1
Xoutput16 _263__Q q[20] VPWR VGND sg13g2_buf_1
Xoutput38 _129__Y q_bar[11] VPWR VGND sg13g2_buf_1
Xoutput27 _273__Q q[30] VPWR VGND sg13g2_buf_1
Xhold123 _165__Y VPWR VGND _257__D sg13g2_dlygate4sd3_1
Xhold134 _213__Y VPWR VGND _273__D sg13g2_dlygate4sd3_1
Xhold145 _284__Q VPWR VGND _247__A sg13g2_dlygate4sd3_1
Xhold156 _195__Y VPWR VGND _267__D sg13g2_dlygate4sd3_1
X_183_ _213__A _263__D _183__B _183__C VPWR VGND sg13g2_nor3_1
X_252_ _252__A _286__D _252__B _252__C VPWR VGND sg13g2_nor3_1
Xfanout73 input3_X _247__B_N VPWR VGND sg13g2_buf_1
X_235_ _280__Q _245__A VPWR _237__B VGND sg13g2_nor2b_1
X_166_ _166__A _254__B VPWR _168__B VGND sg13g2_nor2b_1
X_149_ _149__Y _266__Q VGND VPWR sg13g2_inv_1
X_218_ _233__A VPWR _219__C VGND _220__A sg13g2_nor2_1
Xoutput17 _264__Q q[21] VPWR VGND sg13g2_buf_1
Xoutput39 _128__Y q_bar[12] VPWR VGND sg13g2_buf_1
Xoutput28 _274__Q q[31] VPWR VGND sg13g2_buf_1
Xhold146 _260__Q VPWR VGND _173__B sg13g2_dlygate4sd3_1
Xhold124 _264__Q VPWR VGND _187__A sg13g2_dlygate4sd3_1
Xhold135 _270__Q VPWR VGND _205__A sg13g2_dlygate4sd3_1
Xhold157 _271__Q VPWR VGND _206__B sg13g2_dlygate4sd3_1
X_182_ _200__A VPWR _183__C VGND _182__B sg13g2_nor2_1
Xfanout74 _206__A _176__A VPWR VGND sg13g2_buf_1
X_251_ _253__A VPWR _252__C VGND _251__B sg13g2_nor2_1
X_165_ _252__A _165__Y _165__B _165__C VPWR VGND sg13g2_nor3_1
X_234_ _243__A _234__Y _234__B _234__C VPWR VGND sg13g2_nor3_1
X_217_ _217__A _233__A VPWR _219__B VGND sg13g2_nor2b_1
X_148_ _148__Y _267__Q VGND VPWR sg13g2_inv_1
Xoutput18 _265__Q q[22] VPWR VGND sg13g2_buf_1
Xoutput29 _278__Q q[3] VPWR VGND sg13g2_buf_1
X_257__114 _257__RESET_B VPWR VGND sg13g2_tiehi
Xhold125 _186__Y VPWR VGND _264__D sg13g2_dlygate4sd3_1
Xhold136 _258__Q VPWR VGND _169__A sg13g2_dlygate4sd3_1
Xhold147 _174__Y VPWR VGND _260__D sg13g2_dlygate4sd3_1
Xhold158 _276__Q VPWR VGND _221__B sg13g2_dlygate4sd3_1
X_181_ _181__A _200__A VPWR _183__B VGND sg13g2_nor2b_1
X_250_ _250__A _251__B VPWR _252__B VGND sg13g2_nor2b_1
Xfanout75 _206__A _191__A VPWR VGND sg13g2_buf_1
X_164_ _254__B VPWR _165__C VGND _166__A sg13g2_nor2_1
X_279__89 _279__89_L_HI VPWR VGND sg13g2_tiehi
X_233_ _233__A VPWR _234__C VGND _233__B sg13g2_nor2_1
X_147_ _147__Y _268__Q VGND VPWR sg13g2_inv_1
X_216_ _255__A _216__Y _216__B _216__C VPWR VGND sg13g2_nor3_1
Xoutput19 _266__Q q[23] VPWR VGND sg13g2_buf_1
X_274__109 _274__RESET_B VPWR VGND sg13g2_tiehi
X_272__84 _272__84_L_HI VPWR VGND sg13g2_tiehi
XFILLER_8_137 VPWR VGND sg13g2_decap_4
Xhold126 _261__Q VPWR VGND _178__A sg13g2_dlygate4sd3_1
Xhold159 _256__Q VPWR VGND _161__B sg13g2_dlygate4sd3_1
Xhold148 _275__Q VPWR VGND _220__A sg13g2_dlygate4sd3_1
Xhold137 _171__Y VPWR VGND _259__D sg13g2_dlygate4sd3_1
X_180_ _213__A _262__D _180__B _180__C VPWR VGND sg13g2_nor3_1
Xfanout76 _200__A _215__A VPWR VGND sg13g2_buf_1
X_163_ _256__Q _251__B VPWR _165__B VGND sg13g2_nor2b_1
X_232_ _279__Q _233__A VPWR _234__B VGND sg13g2_nor2b_1
X_269__90 _269__90_L_HI VPWR VGND sg13g2_tiehi
X_146_ _146__Y _269__Q VGND VPWR sg13g2_inv_1
X_215_ _215__A VPWR _216__C VGND _215__B sg13g2_nor2_1
X_129_ _129__Y _286__Q VGND VPWR sg13g2_inv_1
Xhold116 _274__Q VPWR VGND _215__B sg13g2_dlygate4sd3_1
Xhold127 _177__Y VPWR VGND _261__D sg13g2_dlygate4sd3_1
Xhold138 _272__Q VPWR VGND _209__B sg13g2_dlygate4sd3_1
Xhold149 _286__Q VPWR VGND _253__A sg13g2_dlygate4sd3_1
Xfanout77 _206__A _200__A VPWR VGND sg13g2_buf_1
X_231_ _243__A _231__Y _231__B _231__C VPWR VGND sg13g2_nor3_1
X_162_ _252__A _162__Y _162__B _162__C VPWR VGND sg13g2_nor3_1
Xinput1 reset input1_X VPWR VGND sg13g2_buf_1
X_214_ _273__Q _215__A VPWR _216__B VGND sg13g2_nor2b_1
X_145_ _145__Y _270__Q VGND VPWR sg13g2_inv_1
X_128_ _128__Y _287__Q VGND VPWR sg13g2_inv_1
Xhold117 _216__Y VPWR VGND _274__D sg13g2_dlygate4sd3_1
Xhold139 _210__Y VPWR VGND _272__D sg13g2_dlygate4sd3_1
Xhold128 _269__Q VPWR VGND _202__A sg13g2_dlygate4sd3_1
Xfanout78 input3_X _206__A VPWR VGND sg13g2_buf_1
X_230_ _233__A VPWR _231__C VGND _230__B sg13g2_nor2_1
X_161_ _251__B VPWR _162__C VGND _161__B sg13g2_nor2_1
Xinput2 serial_in_data _217__A VPWR VGND sg13g2_buf_1
X_213_ _213__A _213__Y _213__B _213__C VPWR VGND sg13g2_nor3_1
X_144_ _144__Y _271__Q VGND VPWR sg13g2_inv_1
Xhold118 _282__Q VPWR VGND _241__A sg13g2_dlygate4sd3_1
Xhold129 _201__Y VPWR VGND _269__D sg13g2_dlygate4sd3_1
Xfanout79 _252__A _243__A VPWR VGND sg13g2_buf_1
Xfanout68 _245__A _233__A VPWR VGND sg13g2_buf_1
X_160_ _287__Q _251__B VPWR _162__B VGND sg13g2_nor2b_1
X_278__93 _278__93_L_HI VPWR VGND sg13g2_tiehi
Xinput3 shift_enable input3_X VPWR VGND sg13g2_buf_1
X_212_ _215__A VPWR _213__C VGND _212__B sg13g2_nor2_1
X_143_ _143__Y _272__Q VGND VPWR sg13g2_inv_1
X_266__96 _266__96_L_HI VPWR VGND sg13g2_tiehi
X_273__113 _273__RESET_B VPWR VGND sg13g2_tiehi
Xhold119 _240__Y VPWR VGND _282__D sg13g2_dlygate4sd3_1
Xfanout69 _245__A _224__A VPWR VGND sg13g2_buf_1
X_211_ _272__Q _215__A VPWR _213__B VGND sg13g2_nor2b_1
X_142_ _142__Y _273__Q VGND VPWR sg13g2_inv_1
X_263__102 _263__RESET_B VPWR VGND sg13g2_tiehi
X_287_ VPWR _287__D _287__Q clk VGND _287__99_L_HI sg13g2_dfrbpq_1
X_284__87 _284__87_L_HI VPWR VGND sg13g2_tiehi
X_276__101 _276__RESET_B VPWR VGND sg13g2_tiehi
X_210_ _213__A _210__Y _210__B _210__C VPWR VGND sg13g2_nor3_1
X_141_ _141__Y _274__Q VGND VPWR sg13g2_inv_1
X_286_ VPWR _286__D _286__Q clk VGND _286__91_L_HI sg13g2_dfrbpq_1
X_140_ _140__Y _275__Q VGND VPWR sg13g2_inv_1
X_269_ VPWR _269__D _269__Q clk VGND _269__90_L_HI sg13g2_dfrbpq_1
X_285_ VPWR _285__D _285__Q clk VGND _285__RESET_B sg13g2_dfrbpq_1
X_199_ _268__Q _200__A VPWR _201__B VGND sg13g2_nor2b_1
X_268_ VPWR _268__D _268__Q clk VGND _268__92_L_HI sg13g2_dfrbpq_1
X_260__108 _260__RESET_B VPWR VGND sg13g2_tiehi
X_284_ VPWR _284__D _284__Q clk VGND _284__87_L_HI sg13g2_dfrbpq_1
X_267_ VPWR _267__D _267__Q clk VGND _267__94_L_HI sg13g2_dfrbpq_1
X_198_ _213__A _268__D _198__B _198__C VPWR VGND sg13g2_nor3_1
X_259__110 _259__RESET_B VPWR VGND sg13g2_tiehi
X_287__99 _287__99_L_HI VPWR VGND sg13g2_tiehi
X_283_ VPWR _283__D _283__Q clk VGND _283__95_L_HI sg13g2_dfrbpq_1
X_197_ _215__A VPWR _198__C VGND _197__B sg13g2_nor2_1
X_266_ VPWR _266__D _266__Q clk VGND _266__96_L_HI sg13g2_dfrbpq_1
X_249_ _252__A _285__D _249__B _249__C VPWR VGND sg13g2_nor3_1
X_282_ VPWR _282__D _282__Q clk VGND _282__RESET_B sg13g2_dfrbpq_1
X_265_ VPWR _265__D _265__Q clk VGND _265__98_L_HI sg13g2_dfrbpq_1
X_196_ _196__A _200__A VPWR _198__B VGND sg13g2_nor2b_1
X_179_ _200__A VPWR _180__C VGND _181__A sg13g2_nor2_1
X_248_ _251__B VPWR _249__C VGND _250__A sg13g2_nor2_1
X_256__115 _256__RESET_B VPWR VGND sg13g2_tiehi
X_281_ VPWR _281__D _281__Q clk VGND _281__RESET_B sg13g2_dfrbpq_1
X_264_ VPWR _264__D _264__Q clk VGND _264__RESET_B sg13g2_dfrbpq_1
X_195_ _195__A _195__Y _195__B _195__C VPWR VGND sg13g2_nor3_1
X_280__85 _280__85_L_HI VPWR VGND sg13g2_tiehi
X_247_ _247__A _247__B_N VPWR _249__B VGND sg13g2_nor2b_1
X_178_ _178__A _176__A VPWR _180__B VGND sg13g2_nor2b_1
X_280_ VPWR _280__D _280__Q clk VGND _280__85_L_HI sg13g2_dfrbpq_1
X_286__91 _286__91_L_HI VPWR VGND sg13g2_tiehi
X_263_ VPWR _263__D _263__Q clk VGND _263__RESET_B sg13g2_dfrbpq_1
X_194_ _200__A VPWR _195__C VGND _196__A sg13g2_nor2_1
X_271__86 _271__86_L_HI VPWR VGND sg13g2_tiehi
X_177_ _195__A _177__Y _177__B _177__C VPWR VGND sg13g2_nor3_1
X_246_ _252__A _284__D _246__B _246__C VPWR VGND sg13g2_nor3_1
X_229_ _278__Q _233__A VPWR _231__B VGND sg13g2_nor2b_1
X_268__92 _268__92_L_HI VPWR VGND sg13g2_tiehi
X_262_ VPWR _262__D _262__Q clk VGND _262__RESET_B sg13g2_dfrbpq_1
X_283__95 _283__95_L_HI VPWR VGND sg13g2_tiehi
X_193_ _266__Q _191__A VPWR _195__B VGND sg13g2_nor2b_1
X_176_ _176__A VPWR _177__C VGND _178__A sg13g2_nor2_1
X_245_ _245__A VPWR _246__C VGND _247__A sg13g2_nor2_1
X_228_ _243__A _278__D _228__B _228__C VPWR VGND sg13g2_nor3_1
X_159_ _159__Y _256__Q VGND VPWR sg13g2_inv_1
X_261_ VPWR _261__D _261__Q clk VGND _261__RESET_B sg13g2_dfrbpq_1
X_192_ _195__A _266__D _192__B _192__C VPWR VGND sg13g2_nor3_1
X_282__103 _282__RESET_B VPWR VGND sg13g2_tiehi
X_175_ _260__Q _176__A VPWR _177__B VGND sg13g2_nor2b_1
X_244_ _244__A _245__A VPWR _246__B VGND sg13g2_nor2b_1
X_158_ _158__Y _257__Q VGND VPWR sg13g2_inv_1
X_227_ _233__A VPWR _228__C VGND _227__B sg13g2_nor2_1
X_260_ VPWR _260__D _260__Q clk VGND _260__RESET_B sg13g2_dfrbpq_1
X_191_ _191__A VPWR _192__C VGND _191__B sg13g2_nor2_1
X_243_ _243__A _283__D _243__B _243__C VPWR VGND sg13g2_nor3_1
X_174_ _195__A _174__Y _174__B _174__C VPWR VGND sg13g2_nor3_1
X_157_ _157__Y _258__Q VGND VPWR sg13g2_inv_1
X_226_ _226__A _233__A VPWR _228__B VGND sg13g2_nor2b_1
X_209_ _215__A VPWR _210__C VGND _209__B sg13g2_nor2_1
X_190_ _190__A _191__A VPWR _192__B VGND sg13g2_nor2b_1
X_265__98 _265__98_L_HI VPWR VGND sg13g2_tiehi
X_173_ _176__A VPWR _174__C VGND _173__B sg13g2_nor2_1
X_242_ _245__A VPWR _243__C VGND _244__A sg13g2_nor2_1
X_156_ _156__Y _259__Q VGND VPWR sg13g2_inv_1
X_225_ _243__A _225__Y _225__B _225__C VPWR VGND sg13g2_nor3_1
X_208_ _271__Q _215__A VPWR _210__B VGND sg13g2_nor2b_1
X_139_ _139__Y _276__Q VGND VPWR sg13g2_inv_1
X_172_ _259__Q _176__A VPWR _174__B VGND sg13g2_nor2b_1
X_241_ _241__A _245__A VPWR _243__B VGND sg13g2_nor2b_1
X_155_ _155__Y _260__Q VGND VPWR sg13g2_inv_1
X_224_ _224__A VPWR _225__C VGND _226__A sg13g2_nor2_1
X_207_ _213__A _271__D _207__B _207__C VPWR VGND sg13g2_nor3_1
X_138_ _138__Y _277__Q VGND VPWR sg13g2_inv_1
X_262__104 _262__RESET_B VPWR VGND sg13g2_tiehi
X_277__97 _277__97_L_HI VPWR VGND sg13g2_tiehi
X_240_ _252__A _240__Y _240__B _240__C VPWR VGND sg13g2_nor3_1
X_171_ _195__A _171__Y _171__B _171__C VPWR VGND sg13g2_nor3_1
X_223_ _276__Q _224__A VPWR _225__B VGND sg13g2_nor2b_1
X_154_ _154__Y _261__Q VGND VPWR sg13g2_inv_1
XFILLER_6_145 VPWR VGND sg13g2_decap_8
X_137_ _137__Y _278__Q VGND VPWR sg13g2_inv_1
X_206_ _206__A VPWR _207__C VGND _206__B sg13g2_nor2_1
X_170_ _176__A VPWR _171__C VGND _259__Q sg13g2_nor2_1
X_153_ _153__Y _262__Q VGND VPWR sg13g2_inv_1
X_222_ _243__A _276__D _222__B _222__C VPWR VGND sg13g2_nor3_1
X_205_ _205__A _206__A VPWR _207__B VGND sg13g2_nor2b_1
X_136_ _136__Y _279__Q VGND VPWR sg13g2_inv_1
X_275__105 _275__RESET_B VPWR VGND sg13g2_tiehi
X_152_ _152__Y _263__Q VGND VPWR sg13g2_inv_1
X_221_ _224__A VPWR _222__C VGND _221__B sg13g2_nor2_1
X_204_ _213__A _270__D _204__B _204__C VPWR VGND sg13g2_nor3_1
X_135_ _135__Y _280__Q VGND VPWR sg13g2_inv_1
X_285__107 _285__RESET_B VPWR VGND sg13g2_tiehi
Xoutput60 _141__Y q_bar[31] VPWR VGND sg13g2_buf_1
X_258__112 _258__RESET_B VPWR VGND sg13g2_tiehi
X_151_ _151__Y _264__Q VGND VPWR sg13g2_inv_1
X_220_ _220__A _224__A VPWR _222__B VGND sg13g2_nor2b_1
X_134_ _134__Y _281__Q VGND VPWR sg13g2_inv_1
X_203_ _206__A VPWR _204__C VGND _205__A sg13g2_nor2_1
Xoutput50 _150__Y q_bar[22] VPWR VGND sg13g2_buf_1
Xoutput61 _137__Y q_bar[3] VPWR VGND sg13g2_buf_1
Xoutput4 _275__Q q[0] VPWR VGND sg13g2_buf_1
X_281__111 _281__RESET_B VPWR VGND sg13g2_tiehi
XFILLER_6_138 VPWR VGND sg13g2_decap_8
X_150_ _150__Y _265__Q VGND VPWR sg13g2_inv_1
X_279_ VPWR _279__D _279__Q clk VGND _279__89_L_HI sg13g2_dfrbpq_1
X_202_ _202__A _215__A VPWR _204__B VGND sg13g2_nor2b_1
X_133_ _133__Y _282__Q VGND VPWR sg13g2_inv_1
Xoutput51 _149__Y q_bar[23] VPWR VGND sg13g2_buf_1
Xoutput40 _159__Y q_bar[13] VPWR VGND sg13g2_buf_1
Xoutput5 _285__Q q[10] VPWR VGND sg13g2_buf_1
Xoutput62 _136__Y q_bar[4] VPWR VGND sg13g2_buf_1
X_278_ VPWR _278__D _278__Q clk VGND _278__93_L_HI sg13g2_dfrbpq_1
X_132_ _132__Y _283__Q VGND VPWR sg13g2_inv_1
X_201_ _213__A _201__Y _201__B _201__C VPWR VGND sg13g2_nor3_1
Xoutput41 _158__Y q_bar[14] VPWR VGND sg13g2_buf_1
Xoutput6 _286__Q q[11] VPWR VGND sg13g2_buf_1
Xoutput30 _279__Q q[4] VPWR VGND sg13g2_buf_1
Xoutput52 _148__Y q_bar[24] VPWR VGND sg13g2_buf_1
Xoutput63 _135__Y q_bar[5] VPWR VGND sg13g2_buf_1

.ends shift_register_32

**************************************************
* SUBCKT: sg13g2_dfrbpq_1
**************************************************

.subckt sg13g2_dfrbpq_1 VDD D Q CLK VSS RESET_B

MN0 VSS RESET_B a_132_114 VSS sg13_lv_nmos w=420n l=130n ng=1 m=1
MN1 a_550_127 RESET_B VSS VSS sg13_lv_nmos w=420n l=130n ng=1 m=1
MP2 a_298_337 a_741_93 a_681_505 VDD sg13_lv_pmos w=420n l=130n ng=1 m=1
MN3 a_1840_334 a_1583_191 a_2002_114 VSS sg13_lv_nmos w=420n l=130n ng=1 m=1
MP4 a_38_114 a_843_236 a_298_337 VDD sg13_lv_pmos w=420n l=130n ng=1 m=1
MN5 a_741_93 CLK VSS VSS sg13_lv_nmos w=740n l=130n ng=1 m=1
MP6 a_38_114 D VDD VDD sg13_lv_pmos w=420n l=130n ng=1 m=1
MP7 a_741_93 CLK VDD VDD sg13_lv_pmos w=1120n l=130n ng=1 m=1
MN8 VSS a_741_93 a_843_236 VSS sg13_lv_nmos w=740n l=130n ng=1 m=1
MN9 VSS a_1840_334 a_1489_191 VSS sg13_lv_nmos w=420n l=130n ng=1 m=1
MP10 VDD RESET_B a_38_114 VDD sg13_lv_pmos w=420n l=130n ng=1 m=1
MN11 a_324_432 a_298_337 VSS VSS sg13_lv_nmos w=740n l=130n ng=1 m=1
MP12 VDD a_741_93 a_843_236 VDD sg13_lv_pmos w=1120n l=130n ng=1 m=1
MN13 a_2002_114 RESET_B VSS VSS sg13_lv_nmos w=420n l=130n ng=1 m=1
MP14 VDD a_1583_191 a_2250_412 VDD sg13_lv_pmos w=1120n l=130n ng=1 m=1
MP15 Q a_2250_412 VDD VDD sg13_lv_pmos w=1120n l=130n ng=1 m=1
MN16 a_132_114 D a_38_114 VSS sg13_lv_nmos w=420n l=130n ng=1 m=1
MP17 a_1785_429 a_843_236 a_1583_191 VDD sg13_lv_pmos w=420n l=130n ng=1 m=1
MP18 VDD a_1583_191 a_1840_334 VDD sg13_lv_pmos w=420n l=130n ng=1 m=1
MP19 a_1583_191 a_741_93 a_324_432 VDD sg13_lv_pmos w=1u l=130n ng=1 m=1
MN20 a_1583_191 a_741_93 a_1489_191 VSS sg13_lv_nmos w=420n l=130n ng=1 m=1
MP21 VDD a_1840_334 a_1785_429 VDD sg13_lv_pmos w=420n l=130n ng=1 m=1
MP22 a_1840_334 RESET_B VDD VDD sg13_lv_pmos w=420n l=130n ng=1 m=1
MN23 a_324_432 a_843_236 a_1583_191 VSS sg13_lv_nmos w=740n l=130n ng=1 m=1
MN24 a_298_337 a_741_93 a_38_114 VSS sg13_lv_nmos w=420n l=130n ng=1 m=1
MN25 a_612_127 a_324_432 a_550_127 VSS sg13_lv_nmos w=420n l=130n ng=1 m=1
MP26 a_681_505 a_324_432 VDD VDD sg13_lv_pmos w=420n l=130n ng=1 m=1
MN27 a_612_127 a_843_236 a_298_337 VSS sg13_lv_nmos w=420n l=130n ng=1 m=1
MN28 VSS a_1583_191 a_2250_412 VSS sg13_lv_nmos w=740n l=130n ng=1 m=1
MP29 a_324_432 a_298_337 VDD VDD sg13_lv_pmos w=1u l=130n ng=1 m=1
MN30 Q a_2250_412 VSS VSS sg13_lv_nmos w=740n l=130n ng=1 m=1
MP31 VDD RESET_B a_298_337 VDD sg13_lv_pmos w=420n l=130n ng=1 m=1

.ends sg13g2_dfrbpq_1

**************************************************
* SUBCKT: sg13g2_tiehi
**************************************************

.subckt sg13g2_tiehi L_HI VDD VSS

MP0 L_HI a_222_366 VDD VDD sg13_lv_pmos w=1155n l=130n ng=1 m=1
MP1 VDD a_23_195 a_23_429 VDD sg13_lv_pmos w=660n l=130n ng=1 m=1
MN2 a_222_366 a_23_429 VSS VSS sg13_lv_nmos w=795n l=130n ng=1 m=1
MN3 VSS a_23_195 a_23_195 VSS sg13_lv_nmos w=300n l=130n ng=1 m=1

.ends sg13g2_tiehi

**************************************************
* SUBCKT: sg13g2_dlygate4sd3_1
**************************************************

.subckt sg13g2_dlygate4sd3_1 A VDD VSS X

MP0 VDD A a_56_118 VDD sg13_lv_pmos w=420n l=130n ng=1 m=1
MN1 VSS a_326_118 a_438_182 VSS sg13_lv_nmos w=420n l=500n ng=1 m=1
MP2 VDD a_326_118 a_438_182 VDD sg13_lv_pmos w=1u l=500n ng=1 m=1
MP3 X a_438_182 VDD VDD sg13_lv_pmos w=1120n l=130n ng=1 m=1
MP4 a_326_118 a_56_118 VDD VDD sg13_lv_pmos w=1u l=500n ng=1 m=1
MN5 VSS A a_56_118 VSS sg13_lv_nmos w=420n l=130n ng=1 m=1
MN6 X a_438_182 VSS VSS sg13_lv_nmos w=740n l=130n ng=1 m=1
MN7 a_326_118 a_56_118 VSS VSS sg13_lv_nmos w=420n l=500n ng=1 m=1

.ends sg13g2_dlygate4sd3_1

**************************************************
* SUBCKT: OUTPUT
**************************************************

.subckt OUTPUT VGND VPWR clk din[0] din[10] din[11] din[12] din[13] din[14] din[15] din[16] din[17] din[18]
+ din[19] din[1] din[20] din[21] din[22] din[23] din[24] din[25] din[26] din[27] din[28] din[29] din[2]
+ din[30] din[31] din[3] din[4] din[5] din[6] din[7] din[8] din[9] dout output_enable reset

Xsg13g2_nand2b_1_0 VGND sg13g2_buf_1_37_X sg13g2_nor3_1_8_B sg13g2_inv_1_21_A VPWR sg13g2_nand2b_1
Xsg13g2_buf_1_1 din[31] sg13g2_buf_1_1_X VPWR VGND sg13g2_buf_1
Xsg13g2_inv_1_1 sg13g2_inv_1_1_Y sg13g2_inv_1_1_A VGND VPWR sg13g2_inv_1
Xsg13g2_buf_1_31 din[2] sg13g2_inv_1_28_A VPWR VGND sg13g2_buf_1
Xsg13g2_buf_1_20 din[12] sg13g2_inv_1_17_A VPWR VGND sg13g2_buf_1
Xsg13g2_tiehi_3 sg13g2_tiehi_3_L_HI VPWR VGND sg13g2_tiehi
Xsg13g2_inv_1_2 sg13g2_inv_1_2_Y sg13g2_inv_1_2_A VGND VPWR sg13g2_inv_1
Xsg13g2_buf_1_2 din[30] sg13g2_buf_1_2_X VPWR VGND sg13g2_buf_1
Xsg13g2_buf_1_21 din[9] sg13g2_inv_1_18_A VPWR VGND sg13g2_buf_1
Xsg13g2_buf_1_32 sg13g2_buf_1_32_A dout VPWR VGND sg13g2_buf_1
Xsg13g2_buf_1_10 din[17] sg13g2_inv_1_11_A VPWR VGND sg13g2_buf_1
Xsg13g2_tiehi_4 sg13g2_tiehi_4_L_HI VPWR VGND sg13g2_tiehi
Xsg13g2_xnor2_1_0 sg13g2_xnor2_1_0_Y sg13g2_nor3_1_0_A VPWR sg13g2_xnor2_1_0_A VGND sg13g2_xnor2_1
Xsg13g2_a221oi_1_0 sg13g2_nor3_1_2_Y sg13g2_a221oi_1_0_Y sg13g2_inv_1_26_Y sg13g2_nor2b_1_1_Y sg13g2_buf_1_0_X
+ VPWR sg13g2_inv_1_12_Y VGND sg13g2_a221oi_1
Xsg13g2_buf_1_3 din[29] sg13g2_buf_1_3_X VPWR VGND sg13g2_buf_1
Xsg13g2_buf_1_22 din[10] sg13g2_inv_1_19_A VPWR VGND sg13g2_buf_1
Xsg13g2_buf_1_33 sg13g2_buf_1_33_A sg13g2_nor3_1_7_B VPWR VGND sg13g2_buf_1
Xsg13g2_inv_1_3 sg13g2_inv_1_3_Y sg13g2_inv_1_3_A VGND VPWR sg13g2_inv_1
Xsg13g2_buf_1_11 din[19] sg13g2_inv_1_7_A VPWR VGND sg13g2_buf_1
Xsg13g2_a221oi_1_10 sg13g2_inv_1_5_Y sg13g2_a221oi_1_9_A2 sg13g2_inv_1_19_Y sg13g2_nor2b_1_0_Y
+ sg13g2_nor3_1_6_A VPWR sg13g2_inv_1_14_Y VGND sg13g2_a221oi_1
Xsg13g2_a221oi_1_1 sg13g2_inv_1_5_Y sg13g2_a221oi_1_1_Y sg13g2_inv_1_11_Y sg13g2_nor2b_1_1_Y sg13g2_nor3_1_6_A
+ VPWR sg13g2_inv_1_7_Y VGND sg13g2_a221oi_1
Xsg13g2_buf_1_4 din[27] sg13g2_buf_1_4_X VPWR VGND sg13g2_buf_1
Xsg13g2_buf_1_34 output_enable sg13g2_inv_1_21_A VPWR VGND sg13g2_buf_1
Xsg13g2_buf_1_23 din[0] sg13g2_inv_1_23_A VPWR VGND sg13g2_buf_1
Xsg13g2_or3_1_0 VPWR VGND sg13g2_or3_1_0_C sg13g2_or3_1_0_B sg13g2_or3_1_0_A sg13g2_or3_1_0_X sg13g2_or3_1
Xsg13g2_buf_1_12 din[20] sg13g2_inv_1_3_A VPWR VGND sg13g2_buf_1
Xsg13g2_inv_1_4 sg13g2_inv_1_4_Y sg13g2_inv_1_4_A VGND VPWR sg13g2_inv_1
Xsg13g2_a221oi_1_11 sg13g2_nor3_1_7_Y sg13g2_a221oi_1_9_B2 sg13g2_inv_1_29_Y sg13g2_nor2b_1_0_Y
+ sg13g2_buf_1_0_X VPWR sg13g2_inv_1_17_Y VGND sg13g2_a221oi_1
Xsg13g2_a221oi_1_2 sg13g2_nor3_1_1_Y sg13g2_a221oi_1_2_Y sg13g2_inv_1_13_Y sg13g2_nor2b_1_1_Y sg13g2_buf_1_0_X
+ VPWR sg13g2_inv_1_9_Y VGND sg13g2_a221oi_1
Xsg13g2_buf_1_5 din[25] sg13g2_buf_1_5_X VPWR VGND sg13g2_buf_1
Xsg13g2_or3_1_1 VPWR VGND sg13g2_or3_1_1_C sg13g2_or3_1_1_B sg13g2_or3_1_1_A sg13g2_or3_1_1_X sg13g2_or3_1
Xsg13g2_inv_1_5 sg13g2_inv_1_5_Y sg13g2_inv_1_5_A VGND VPWR sg13g2_inv_1
Xsg13g2_buf_1_35 sg13g2_nor2_1_2_A sg13g2_nor3_1_7_A VPWR VGND sg13g2_buf_1
Xsg13g2_buf_1_24 din[14] sg13g2_inv_1_29_A VPWR VGND sg13g2_buf_1
Xsg13g2_buf_1_13 din[28] sg13g2_inv_1_12_A VPWR VGND sg13g2_buf_1
Xsg13g2_a221oi_1_3 sg13g2_inv_1_6_A sg13g2_or3_1_0_C sg13g2_a221oi_1_2_Y sg13g2_a21oi_1_2_Y
+ sg13g2_a221oi_1_0_Y VPWR sg13g2_a21oi_1_1_Y VGND sg13g2_a221oi_1
Xsg13g2_inv_1_6 sg13g2_inv_1_6_Y sg13g2_inv_1_6_A VGND VPWR sg13g2_inv_1
Xsg13g2_buf_1_6 din[26] sg13g2_inv_1_0_A VPWR VGND sg13g2_buf_1
Xsg13g2_buf_1_25 din[11] sg13g2_inv_1_14_A VPWR VGND sg13g2_buf_1
Xsg13g2_buf_1_36 din[15] sg13g2_nor3_1_7_C VPWR VGND sg13g2_buf_1
Xsg13g2_buf_1_14 din[23] sg13g2_nor3_1_3_C VPWR VGND sg13g2_buf_1
Xsg13g2_a221oi_1_4 sg13g2_inv_1_6_Y sg13g2_or3_1_0_B sg13g2_a221oi_1_1_Y sg13g2_a22oi_1_0_Y
+ sg13g2_a221oi_1_5_Y VPWR sg13g2_a21oi_1_0_Y VGND sg13g2_a221oi_1
Xsg13g2_inv_1_7 sg13g2_inv_1_7_Y sg13g2_inv_1_7_A VGND VPWR sg13g2_inv_1
Xsg13g2_buf_1_7 din[21] sg13g2_buf_1_7_X VPWR VGND sg13g2_buf_1
Xsg13g2_buf_1_37 reset sg13g2_buf_1_37_X VPWR VGND sg13g2_buf_1
Xsg13g2_buf_1_26 din[3] sg13g2_nor3_1_4_C VPWR VGND sg13g2_buf_1
Xsg13g2_buf_1_15 din[24] sg13g2_inv_1_9_A VPWR VGND sg13g2_buf_1
Xsg13g2_a221oi_1_5 sg13g2_nor3_1_3_Y sg13g2_a221oi_1_5_Y sg13g2_inv_1_10_Y sg13g2_nor2b_1_1_Y
+ sg13g2_nor2b_1_0_Y VPWR sg13g2_inv_1_1_Y VGND sg13g2_a221oi_1
Xsg13g2_buf_1_8 din[16] sg13g2_inv_1_4_A VPWR VGND sg13g2_buf_1
Xsg13g2_buf_1_27 din[7] sg13g2_nor3_1_5_C VPWR VGND sg13g2_buf_1
Xsg13g2_buf_1_16 din[22] sg13g2_inv_1_1_A VPWR VGND sg13g2_buf_1
Xsg13g2_inv_1_8 sg13g2_inv_1_8_Y sg13g2_inv_1_8_A VGND VPWR sg13g2_inv_1
Xsg13g2_dlygate4sd3_1_0 sg13g2_xnor2_1_0_Y VPWR VGND sg13g2_nor2_1_4_B sg13g2_dlygate4sd3_1
Xsg13g2_a221oi_1_6 sg13g2_inv_1_6_Y sg13g2_or3_1_1_C sg13g2_a221oi_1_7_Y sg13g2_a21oi_1_3_Y
+ sg13g2_a221oi_1_8_Y VPWR sg13g2_a21oi_1_4_Y VGND sg13g2_a221oi_1
Xsg13g2_buf_1_9 din[18] sg13g2_inv_1_8_A VPWR VGND sg13g2_buf_1
Xsg13g2_buf_1_28 din[6] sg13g2_inv_1_24_A VPWR VGND sg13g2_buf_1
Xsg13g2_buf_1_17 din[8] sg13g2_inv_1_20_A VPWR VGND sg13g2_buf_1
Xsg13g2_inv_1_9 sg13g2_inv_1_9_Y sg13g2_inv_1_9_A VGND VPWR sg13g2_inv_1
Xsg13g2_dlygate4sd3_1_1 sg13g2_nor2_1_3_Y VPWR VGND sg13g2_nor3_1_0_B sg13g2_dlygate4sd3_1
Xsg13g2_a221oi_1_7 sg13g2_nor3_1_5_Y sg13g2_a221oi_1_7_Y sg13g2_inv_1_24_Y sg13g2_nor2b_1_0_Y sg13g2_buf_1_0_A
+ VPWR sg13g2_inv_1_15_Y VGND sg13g2_a221oi_1
Xsg13g2_buf_1_29 din[5] sg13g2_inv_1_16_A VPWR VGND sg13g2_buf_1
Xsg13g2_buf_1_18 din[1] sg13g2_inv_1_22_A VPWR VGND sg13g2_buf_1
Xsg13g2_dlygate4sd3_1_2 sg13g2_or3_1_0_A VPWR VGND sg13g2_xnor2_1_0_A sg13g2_dlygate4sd3_1
Xsg13g2_a221oi_1_8 sg13g2_nor3_1_4_Y sg13g2_a221oi_1_8_Y sg13g2_inv_1_22_Y sg13g2_nor2b_1_1_Y sg13g2_buf_1_0_A
+ VPWR sg13g2_inv_1_23_Y VGND sg13g2_a221oi_1
Xsg13g2_buf_1_19 din[13] sg13g2_inv_1_2_A VPWR VGND sg13g2_buf_1
Xsg13g2_dlygate4sd3_1_3 sg13g2_nor3_1_0_Y VPWR VGND sg13g2_dfrbpq_1_0_D sg13g2_dlygate4sd3_1
Xsg13g2_a221oi_1_9 sg13g2_inv_1_6_A sg13g2_or3_1_1_B sg13g2_a221oi_1_9_B2 sg13g2_a21oi_1_5_Y
+ sg13g2_a221oi_1_9_A2 VPWR sg13g2_a22oi_1_1_Y VGND sg13g2_a221oi_1
Xsg13g2_dlygate4sd3_1_4 sg13g2_nor3_1_5_B VPWR VGND sg13g2_buf_1_33_A sg13g2_dlygate4sd3_1
Xsg13g2_dlygate4sd3_1_5 sg13g2_nor3_1_5_A VPWR VGND sg13g2_nor2_1_2_A sg13g2_dlygate4sd3_1
Xsg13g2_dlygate4sd3_1_6 sg13g2_inv_1_5_A VPWR VGND sg13g2_nor2_1_0_A sg13g2_dlygate4sd3_1
Xsg13g2_decap_8_0 VPWR VGND sg13g2_decap_8
Xsg13g2_dlygate4sd3_1_7 sg13g2_inv_1_6_A VPWR VGND sg13g2_nor2_1_3_A sg13g2_dlygate4sd3_1
Xsg13g2_decap_8_1 VPWR VGND sg13g2_decap_8
Xsg13g2_a22oi_1_0 sg13g2_a22oi_1_0_Y sg13g2_buf_1_0_X VPWR sg13g2_nor2b_1_0_Y sg13g2_inv_1_4_Y VGND
+ sg13g2_inv_1_8_Y sg13g2_a22oi_1
Xsg13g2_decap_8_2 VPWR VGND sg13g2_decap_8
Xsg13g2_a22oi_1_1 sg13g2_a22oi_1_1_Y sg13g2_buf_1_0_X VPWR sg13g2_nor2b_1_1_Y sg13g2_inv_1_20_Y VGND
+ sg13g2_inv_1_18_Y sg13g2_a22oi_1
Xsg13g2_decap_8_3 VPWR VGND sg13g2_decap_8
Xsg13g2_a21oi_1_0 VPWR VGND sg13g2_buf_1_0_X sg13g2_inv_1_3_Y sg13g2_inv_1_5_A sg13g2_a21oi_1_0_Y
+ sg13g2_a21oi_1
Xsg13g2_decap_8_4 VPWR VGND sg13g2_decap_8
Xsg13g2_a21oi_1_1 VPWR VGND sg13g2_nor2b_1_0_Y sg13g2_inv_1_25_Y sg13g2_inv_1_5_A sg13g2_a21oi_1_1_Y
+ sg13g2_a21oi_1
Xsg13g2_decap_8_5 VPWR VGND sg13g2_decap_8
Xsg13g2_a21oi_1_2 VPWR VGND sg13g2_nor2b_1_0_Y sg13g2_inv_1_0_Y sg13g2_inv_1_5_Y sg13g2_a21oi_1_2_Y
+ sg13g2_a21oi_1
Xsg13g2_decap_8_6 VPWR VGND sg13g2_decap_8
Xsg13g2_a21oi_1_3 VPWR VGND sg13g2_nor2b_1_1_Y sg13g2_inv_1_16_Y sg13g2_inv_1_5_A sg13g2_a21oi_1_3_Y
+ sg13g2_a21oi_1
Xsg13g2_decap_4_0 VPWR VGND sg13g2_decap_4
Xsg13g2_nor3_1_0 sg13g2_nor3_1_0_A sg13g2_nor3_1_0_Y sg13g2_nor3_1_0_B sg13g2_nor3_1_8_B VPWR VGND
+ sg13g2_nor3_1
Xsg13g2_inv_1_20 sg13g2_inv_1_20_Y sg13g2_inv_1_20_A VGND VPWR sg13g2_inv_1
Xsg13g2_decap_8_7 VPWR VGND sg13g2_decap_8
Xsg13g2_a21oi_1_4 VPWR VGND sg13g2_nor2b_1_0_Y sg13g2_inv_1_28_Y sg13g2_inv_1_5_Y sg13g2_a21oi_1_4_Y
+ sg13g2_a21oi_1
Xsg13g2_decap_4_1 VPWR VGND sg13g2_decap_4
Xsg13g2_nor3_1_1 sg13g2_nor3_1_7_A sg13g2_nor3_1_1_Y sg13g2_nor3_1_7_B sg13g2_buf_1_4_X VPWR VGND
+ sg13g2_nor3_1
Xsg13g2_inv_1_21 sg13g2_inv_1_21_Y sg13g2_inv_1_21_A VGND VPWR sg13g2_inv_1
Xsg13g2_inv_1_10 sg13g2_inv_1_10_Y sg13g2_buf_1_7_X VGND VPWR sg13g2_inv_1
Xsg13g2_decap_8_8 VPWR VGND sg13g2_decap_8
Xsg13g2_a21oi_1_5 VPWR VGND sg13g2_nor2b_1_1_Y sg13g2_inv_1_2_Y sg13g2_inv_1_5_A sg13g2_a21oi_1_5_Y
+ sg13g2_a21oi_1
Xsg13g2_decap_4_2 VPWR VGND sg13g2_decap_4
Xsg13g2_nor3_1_2 sg13g2_nor3_1_7_A sg13g2_nor3_1_2_Y sg13g2_buf_1_1_X sg13g2_nor3_1_7_B VPWR VGND
+ sg13g2_nor3_1
Xsg13g2_inv_1_22 sg13g2_inv_1_22_Y sg13g2_inv_1_22_A VGND VPWR sg13g2_inv_1
Xsg13g2_inv_1_11 sg13g2_inv_1_11_Y sg13g2_inv_1_11_A VGND VPWR sg13g2_inv_1
Xsg13g2_decap_8_9 VPWR VGND sg13g2_decap_8
Xsg13g2_a21oi_1_6 VPWR VGND sg13g2_or3_1_0_X sg13g2_or3_1_1_X sg13g2_inv_1_21_Y sg13g2_buf_1_32_A
+ sg13g2_a21oi_1
Xsg13g2_nor3_1_3 sg13g2_nor3_1_7_A sg13g2_nor3_1_3_Y sg13g2_nor3_1_7_B sg13g2_nor3_1_3_C VPWR VGND
+ sg13g2_nor3_1
Xsg13g2_inv_1_23 sg13g2_inv_1_23_Y sg13g2_inv_1_23_A VGND VPWR sg13g2_inv_1
Xsg13g2_inv_1_12 sg13g2_inv_1_12_Y sg13g2_inv_1_12_A VGND VPWR sg13g2_inv_1
Xsg13g2_nor3_1_4 sg13g2_nor3_1_5_A sg13g2_nor3_1_4_Y sg13g2_nor3_1_5_B sg13g2_nor3_1_4_C VPWR VGND
+ sg13g2_nor3_1
Xsg13g2_inv_1_24 sg13g2_inv_1_24_Y sg13g2_inv_1_24_A VGND VPWR sg13g2_inv_1
Xsg13g2_inv_1_13 sg13g2_inv_1_13_Y sg13g2_buf_1_5_X VGND VPWR sg13g2_inv_1
Xsg13g2_nor2b_1_0 sg13g2_nor3_1_7_B sg13g2_nor3_1_7_A VPWR sg13g2_nor2b_1_0_Y VGND sg13g2_nor2b_1
Xsg13g2_nor3_1_5 sg13g2_nor3_1_5_A sg13g2_nor3_1_5_Y sg13g2_nor3_1_5_B sg13g2_nor3_1_5_C VPWR VGND
+ sg13g2_nor3_1
Xsg13g2_inv_1_14 sg13g2_inv_1_14_Y sg13g2_inv_1_14_A VGND VPWR sg13g2_inv_1
Xsg13g2_inv_1_25 sg13g2_inv_1_25_Y sg13g2_buf_1_2_X VGND VPWR sg13g2_inv_1
Xsg13g2_nor2b_1_1 sg13g2_nor3_1_7_A sg13g2_nor3_1_7_B VPWR sg13g2_nor2b_1_1_Y VGND sg13g2_nor2b_1
Xsg13g2_nor3_1_6 sg13g2_nor3_1_6_A sg13g2_nor3_1_6_Y sg13g2_buf_1_0_A sg13g2_nor3_1_8_B VPWR VGND
+ sg13g2_nor3_1
Xsg13g2_inv_1_15 sg13g2_inv_1_15_Y sg13g2_inv_1_15_A VGND VPWR sg13g2_inv_1
Xsg13g2_inv_1_26 sg13g2_inv_1_26_Y sg13g2_buf_1_3_X VGND VPWR sg13g2_inv_1
Xsg13g2_nor3_1_7 sg13g2_nor3_1_7_A sg13g2_nor3_1_7_Y sg13g2_nor3_1_7_B sg13g2_nor3_1_7_C VPWR VGND
+ sg13g2_nor3_1
Xsg13g2_inv_1_16 sg13g2_inv_1_16_Y sg13g2_inv_1_16_A VGND VPWR sg13g2_inv_1
Xsg13g2_inv_1_27 sg13g2_or3_1_1_A sg13g2_or3_1_0_A VGND VPWR sg13g2_inv_1
Xsg13g2_dfrbpq_1_0 VPWR sg13g2_dfrbpq_1_0_D sg13g2_inv_1_6_A clk VGND sg13g2_tiehi_1_L_HI sg13g2_dfrbpq_1
Xsg13g2_nor3_1_8 sg13g2_nor3_1_8_A sg13g2_nor3_1_8_Y sg13g2_nor3_1_8_B sg13g2_nor3_1_8_C VPWR VGND
+ sg13g2_nor3_1
Xsg13g2_inv_1_28 sg13g2_inv_1_28_Y sg13g2_inv_1_28_A VGND VPWR sg13g2_inv_1
Xsg13g2_inv_1_17 sg13g2_inv_1_17_Y sg13g2_inv_1_17_A VGND VPWR sg13g2_inv_1
Xsg13g2_dfrbpq_1_1 VPWR sg13g2_nor3_1_8_Y sg13g2_inv_1_5_A clk VGND sg13g2_tiehi_0_L_HI sg13g2_dfrbpq_1
Xsg13g2_dfrbpq_1_2 VPWR sg13g2_nor3_1_6_Y sg13g2_nor3_1_5_B clk VGND sg13g2_tiehi_3_L_HI sg13g2_dfrbpq_1
Xsg13g2_inv_1_18 sg13g2_inv_1_18_Y sg13g2_inv_1_18_A VGND VPWR sg13g2_inv_1
Xsg13g2_inv_1_29 sg13g2_inv_1_29_Y sg13g2_inv_1_29_A VGND VPWR sg13g2_inv_1
Xsg13g2_dfrbpq_1_3 VPWR sg13g2_nor2_1_2_Y sg13g2_nor3_1_5_A clk VGND sg13g2_tiehi_4_L_HI sg13g2_dfrbpq_1
Xsg13g2_inv_1_19 sg13g2_inv_1_19_Y sg13g2_inv_1_19_A VGND VPWR sg13g2_inv_1
Xsg13g2_nor2_1_0 sg13g2_nor2_1_0_A VPWR sg13g2_nor3_1_8_C VGND sg13g2_buf_1_0_X sg13g2_nor2_1
Xsg13g2_dfrbpq_1_4 VPWR sg13g2_nor2_1_4_Y sg13g2_or3_1_0_A clk VGND sg13g2_tiehi_2_L_HI sg13g2_dfrbpq_1
Xsg13g2_decap_8_10 VPWR VGND sg13g2_decap_8
Xsg13g2_nor2_1_1 sg13g2_nor3_1_7_A VPWR sg13g2_nor3_1_6_A VGND sg13g2_nor3_1_7_B sg13g2_nor2_1
Xsg13g2_and2_1_0 sg13g2_buf_1_0_A VGND VPWR sg13g2_nor3_1_7_B sg13g2_nor3_1_7_A sg13g2_and2_1
Xsg13g2_nor2_1_2 sg13g2_nor2_1_2_A VPWR sg13g2_nor2_1_2_Y VGND sg13g2_nor3_1_8_B sg13g2_nor2_1
Xsg13g2_decap_8_11 VPWR VGND sg13g2_decap_8
Xsg13g2_tiehi_0 sg13g2_tiehi_0_L_HI VPWR VGND sg13g2_tiehi
Xsg13g2_and2_1_1 sg13g2_nor3_1_0_A VGND VPWR sg13g2_nor3_1_8_A sg13g2_nor2_1_3_A sg13g2_and2_1
Xsg13g2_decap_8_12 VPWR VGND sg13g2_decap_8
Xsg13g2_tiehi_1 sg13g2_tiehi_1_L_HI VPWR VGND sg13g2_tiehi
Xsg13g2_nor2_1_3 sg13g2_nor2_1_3_A VPWR sg13g2_nor2_1_3_Y VGND sg13g2_nor3_1_8_A sg13g2_nor2_1
Xsg13g2_and2_1_2 sg13g2_nor3_1_8_A VGND VPWR sg13g2_buf_1_0_X sg13g2_nor2_1_0_A sg13g2_and2_1
Xsg13g2_buf_1_0 sg13g2_buf_1_0_A sg13g2_buf_1_0_X VPWR VGND sg13g2_buf_1
Xsg13g2_inv_1_0 sg13g2_inv_1_0_Y sg13g2_inv_1_0_A VGND VPWR sg13g2_inv_1
Xsg13g2_buf_1_30 din[4] sg13g2_inv_1_15_A VPWR VGND sg13g2_buf_1
Xsg13g2_tiehi_2 sg13g2_tiehi_2_L_HI VPWR VGND sg13g2_tiehi
Xsg13g2_nor2_1_4 sg13g2_nor3_1_8_B VPWR sg13g2_nor2_1_4_Y VGND sg13g2_nor2_1_4_B sg13g2_nor2_1

.ends OUTPUT

**************************************************
* SUBCKT: sg13g2_xnor2_1
**************************************************

.subckt sg13g2_xnor2_1 Y B VDD A VSS

MP0 a_192_429 A VDD VDD sg13_lv_pmos w=840n l=130n ng=1 m=1
MP1 VDD B a_192_429 VDD sg13_lv_pmos w=840n l=130n ng=1 m=1
MN2 VSS A a_341_118 VSS sg13_lv_nmos w=740n l=130n ng=1 m=1
MP3 a_435_412 A VDD VDD sg13_lv_pmos w=1120n l=130n ng=1 m=1
MN4 a_155_160 A VSS VSS sg13_lv_nmos w=640n l=130n ng=1 m=1
MN5 a_341_118 B VSS VSS sg13_lv_nmos w=740n l=130n ng=1 m=1
MN6 Y a_192_429 a_341_118 VSS sg13_lv_nmos w=740n l=130n ng=1 m=1
MP7 VDD a_192_429 Y VDD sg13_lv_pmos w=1120n l=130n ng=1 m=1
MN8 a_192_429 B a_155_160 VSS sg13_lv_nmos w=640n l=130n ng=1 m=1
MP9 Y B a_435_412 VDD sg13_lv_pmos w=1120n l=130n ng=1 m=1

.ends sg13g2_xnor2_1

**************************************************
* SUBCKT: sg13g2_a221oi_1
**************************************************

.subckt sg13g2_a221oi_1 C1 Y B2 B1 A2 VDD A1 VSS

MN0 a_550_140 A1 Y VSS sg13_lv_nmos w=740n l=130n ng=1 m=1
MN1 VSS A2 a_550_140 VSS sg13_lv_nmos w=740n l=130n ng=1 m=1
MP2 a_142_412 C1 Y VDD sg13_lv_pmos w=1120n l=130n ng=1 m=1
MP3 a_244_412 B2 a_142_412 VDD sg13_lv_pmos w=1120n l=130n ng=1 m=1
MP4 a_142_412 B1 a_244_412 VDD sg13_lv_pmos w=1120n l=130n ng=1 m=1
MP5 a_244_412 A1 VDD VDD sg13_lv_pmos w=1120n l=130n ng=1 m=1
MP6 VDD A2 a_244_412 VDD sg13_lv_pmos w=1120n l=130n ng=1 m=1
MN7 VSS C1 Y VSS sg13_lv_nmos w=740n l=130n ng=1 m=1
MN8 a_244_140 B2 VSS VSS sg13_lv_nmos w=740n l=130n ng=1 m=1
MN9 Y B1 a_244_140 VSS sg13_lv_nmos w=740n l=130n ng=1 m=1

.ends sg13g2_a221oi_1

**************************************************
* SUBCKT: sg13g2_a22oi_1
**************************************************

.subckt sg13g2_a22oi_1 Y A2 VDD B1 A1 VSS B2

MN0 Y B2 a_127_96 VSS sg13_lv_nmos w=740n l=130n ng=1 m=1
MN1 a_398_96 A1 Y VSS sg13_lv_nmos w=740n l=130n ng=1 m=1
MP2 VDD A2 a_127_436 VDD sg13_lv_pmos w=1120n l=130n ng=1 m=1
MP3 Y B1 a_127_436 VDD sg13_lv_pmos w=1120n l=130n ng=1 m=1
MP4 a_127_436 B2 Y VDD sg13_lv_pmos w=1120n l=130n ng=1 m=1
MN5 a_127_96 B1 VSS VSS sg13_lv_nmos w=740n l=130n ng=1 m=1
MP6 a_127_436 A1 VDD VDD sg13_lv_pmos w=1120n l=130n ng=1 m=1
MN7 VSS A2 a_398_96 VSS sg13_lv_nmos w=740n l=130n ng=1 m=1

.ends sg13g2_a22oi_1

**************************************************
* SUBCKT: sg13g2_a21oi_1
**************************************************

.subckt sg13g2_a21oi_1 VDD VSS A2 A1 B1 Y

MN0 Y B1 VSS VSS sg13_lv_nmos w=740n l=130n ng=1 m=1
MN1 a_257_140 A1 Y VSS sg13_lv_nmos w=740n l=130n ng=1 m=1
MN2 VSS A2 a_257_140 VSS sg13_lv_nmos w=740n l=130n ng=1 m=1
MP3 a_155_412 B1 Y VDD sg13_lv_pmos w=1120n l=130n ng=1 m=1
MP4 VDD A1 a_155_412 VDD sg13_lv_pmos w=1120n l=130n ng=1 m=1
MP5 a_155_412 A2 VDD VDD sg13_lv_pmos w=1120n l=130n ng=1 m=1

.ends sg13g2_a21oi_1

**************************************************
* SUBCKT: sg13g2_and2_1
**************************************************

.subckt sg13g2_and2_1 X VSS VDD B A

MP0 X a_45_160 VDD VDD sg13_lv_pmos w=1120n l=130n ng=1 m=1
MN1 X a_45_160 VSS VSS sg13_lv_nmos w=740n l=130n ng=1 m=1
MP2 a_45_160 A VDD VDD sg13_lv_pmos w=840n l=130n ng=1 m=1
MP3 VDD B a_45_160 VDD sg13_lv_pmos w=840n l=130n ng=1 m=1
MN4 a_139_160 A a_45_160 VSS sg13_lv_nmos w=640n l=130n ng=1 m=1
MN5 VSS B a_139_160 VSS sg13_lv_nmos w=640n l=130n ng=1 m=1

.ends sg13g2_and2_1

**************************************************
* SUBCKT: SHIFT_5
**************************************************

.subckt SHIFT_5 VGND VPWR addr[0] addr[1] addr[2] addr[3] addr[4] addr_shift_enable clk reset serial_in_addr

Xoutput7 _38__Q addr[3] VPWR VGND sg13g2_buf_1
Xoutput8 _39__Q addr[4] VPWR VGND sg13g2_buf_1
Xhold20 _38__Q VPWR VGND _30__A sg13g2_dlygate4sd3_1
XFILLER_0_14 VPWR VGND sg13g2_decap_8
Xfanout9 _33__B _30__B VPWR VGND sg13g2_buf_1
Xhold21 _36__Q VPWR VGND _24__B sg13g2_dlygate4sd3_1
XFILLER_1_0 VPWR VGND sg13g2_decap_8
X_29_ _29__A _30__B VPWR _31__B VGND sg13g2_nor2b_1
X_28_ _34__A _28__Y _28__B _28__C VPWR VGND sg13g2_nor3_1
X_27_ _30__B VPWR _28__C VGND _29__A sg13g2_nor2_1
X_26_ _36__Q _30__B VPWR _28__B VGND sg13g2_nor2b_1
Xhold15 _39__Q VPWR VGND _33__A sg13g2_dlygate4sd3_1
X_25_ _34__A _36__D _25__B _25__C VPWR VGND sg13g2_nor3_1
X_35__12 _35__12_L_HI VPWR VGND sg13g2_tiehi
Xhold16 _34__Y VPWR VGND _39__D sg13g2_dlygate4sd3_1
X_24_ _30__B VPWR _25__C VGND _24__B sg13g2_nor2_1
Xhold17 _37__Q VPWR VGND _29__A sg13g2_dlygate4sd3_1
X_23_ _23__A _30__B VPWR _25__B VGND sg13g2_nor2b_1
Xhold18 _28__Y VPWR VGND _37__D sg13g2_dlygate4sd3_1
X_22_ _34__A _35__D _22__B _22__C VPWR VGND sg13g2_nor3_1
X_38__14 _38__14_L_HI VPWR VGND sg13g2_tiehi
X_21_ _30__B VPWR _22__C VGND _23__A sg13g2_nor2_1
Xhold19 _35__Q VPWR VGND _23__A sg13g2_dlygate4sd3_1
Xinput1 addr_shift_enable _33__B VPWR VGND sg13g2_buf_1
X_20_ _20__A _30__B VPWR _22__B VGND sg13g2_nor2b_1
Xinput2 reset _34__A VPWR VGND sg13g2_buf_1
Xinput3 serial_in_addr _20__A VPWR VGND sg13g2_buf_1
X_39_ VPWR _39__D _39__Q clk VGND _39__10_L_HI sg13g2_dfrbpq_1
X_38_ VPWR _38__D _38__Q clk VGND _38__14_L_HI sg13g2_dfrbpq_1
X_37__11 _37__11_L_HI VPWR VGND sg13g2_tiehi
X_37_ VPWR _37__D _37__Q clk VGND _37__11_L_HI sg13g2_dfrbpq_1
XFILLER_0_0 VPWR VGND sg13g2_decap_8
X_36_ VPWR _36__D _36__Q clk VGND _36__13_L_HI sg13g2_dfrbpq_1
X_35_ VPWR _35__D _35__Q clk VGND _35__12_L_HI sg13g2_dfrbpq_1
X_34_ _34__A _34__Y _34__B _34__C VPWR VGND sg13g2_nor3_1
X_33_ _33__A VPWR _34__C VGND _33__B sg13g2_nor2_1
X_32_ _38__Q _33__B VPWR _34__B VGND sg13g2_nor2b_1
X_31_ _34__A _38__D _31__B _31__C VPWR VGND sg13g2_nor3_1
X_30_ _30__A VPWR _31__C VGND _30__B sg13g2_nor2_1
XFILLER_7_0 VPWR VGND sg13g2_decap_4
XFILLER_0_7 VPWR VGND sg13g2_decap_8
X_39__10 _39__10_L_HI VPWR VGND sg13g2_tiehi
X_36__13 _36__13_L_HI VPWR VGND sg13g2_tiehi
XFILLER_0_21 VPWR VGND sg13g2_decap_4
Xoutput4 _35__Q addr[0] VPWR VGND sg13g2_buf_1
Xoutput6 _37__Q addr[2] VPWR VGND sg13g2_buf_1
Xoutput5 _36__Q addr[1] VPWR VGND sg13g2_buf_1

.ends SHIFT_5

.end
